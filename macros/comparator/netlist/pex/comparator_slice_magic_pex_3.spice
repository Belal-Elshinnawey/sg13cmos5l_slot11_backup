* PEX produced on Mon Nov  9 01:19:42 AM CET 2026 using /foss/tools/sak/sak-pex.sh with m=3 and s=1 (extresist threshold=10000 mOhm, minres=1000 mOhm, mindelay=1 ps)
* NGSPICE file created from comparator_slice_pex.ext - technology: ihp-sg13cmos5l

.subckt comparator_slice_pex inp inn ibias out AVDD AVSS AVDD1V2
X0 comparator_body_0.outx.t54 comparator_body_0.m3_m4_diff_0.n1.t34 a_n5385_9014# AVDD sg13_hv_pmos ad=0.85p pd=5.68u as=0.85p ps=5.68u w=2.5u l=1u
X1 a_n6285_6504# comparator_body_0.m3_m4_diff_0.n1.t58 AVDD AVDD sg13_hv_pmos ad=0.85p pd=5.68u as=0.85p ps=5.68u w=2.5u l=1u
X2 comparator_body_0.m3_m4_diff_0.n1.t63 comparator_body_0.m3_m4_diff_0.n1.t62 a_n5969_11394# AVDD sg13_hv_pmos ad=0.85p pd=5.68u as=0.85p ps=5.68u w=2.5u l=1u
X3 AVDD comparator_body_0.m3_m4_diff_0.n1.t70 a_n5969_n1956# AVDD sg13_hv_pmos ad=0.85p pd=5.68u as=0.85p ps=5.68u w=2.5u l=1u
X4 AVDD comparator_body_0.m3_m4_diff_0.n1.t34 a_n5385_9014# AVDD sg13_hv_pmos ad=0.85p pd=5.68u as=0.85p ps=5.68u w=2.5u l=1u
X5 AVSS.t55 ibias.t42 a_479_n986# AVSS.t43 sg13_hv_nmos ad=0.85p pd=5.68u as=0.85p ps=5.68u w=2.5u l=1u
X6 comparator_body_0.mref_m5_diff_0.tail.t42 inp a_n2415_n7219# AVSS.t87 sg13_hv_nmos ad=0.85p pd=5.68u as=0.85p ps=5.68u w=2.5u l=1u
X7 a_n6869_10204# comparator_body_0.m3_m4_diff_0.n1.t46 AVDD AVDD sg13_hv_pmos ad=0.85p pd=5.68u as=0.85p ps=5.68u w=2.5u l=1u
X8 a_3871_3330# comparator_body_0.outx.t66 AVDD AVDD sg13_hv_pmos ad=0.85p pd=5.68u as=0.85p ps=5.68u w=2.5u l=1u
X9 a_n6869_1614# comparator_body_0.m3_m4_diff_0.n1.t72 AVDD AVDD sg13_hv_pmos ad=0.85p pd=5.68u as=0.85p ps=5.68u w=2.5u l=1u
X10 a_n3898_7684# inp comparator_body_0.mref_m5_diff_0.tail.t50 AVSS.t80 sg13_hv_nmos ad=0.85p pd=5.68u as=0.85p ps=5.68u w=2.5u l=1u
X11 comparator_body_0.mref_m5_diff_0.tail.t21 ibias.t42 a_479_n986# AVSS.t43 sg13_hv_nmos ad=0.85p pd=5.68u as=0.85p ps=5.68u w=2.5u l=1u
X12 comparator_body_0.m3_m4_diff_0.n1.t1 inp a_n3001_n8459# AVSS.t85 sg13_hv_nmos ad=0.85p pd=5.68u as=0.85p ps=5.68u w=2.5u l=1u
X13 a_n6869_10204# comparator_body_0.m3_m4_diff_0.n1.t46 comparator_body_0.outx.t49 AVDD sg13_hv_pmos ad=0.85p pd=5.68u as=0.85p ps=5.68u w=2.5u l=1u
X14 a_n421_4010# ibias.t10 comparator_body_0.mref_m5_diff_0.tail.t1 AVSS.t29 sg13_hv_nmos ad=0.85p pd=5.68u as=0.85p ps=5.68u w=2.5u l=1u
X15 AVSS.t9 ibias.t48 a_479_11386# AVSS.t8 sg13_hv_nmos ad=0.85p pd=5.68u as=0.85p ps=5.68u w=2.5u l=1u
X16 a_n3898_n1829# inn comparator_body_0.mref_m5_diff_0.tail.t94 AVSS.t84 sg13_hv_nmos ad=0.85p pd=5.68u as=0.85p ps=5.68u w=2.5u l=1u
X17 comparator_body_0.mref_m5_diff_0.tail.t47 inp a_n3001_10164# AVSS.t81 sg13_hv_nmos ad=0.85p pd=5.68u as=0.85p ps=5.68u w=2.5u l=1u
X18 ibias.t15 ibias.t14 a_n105_6390# AVSS.t0 sg13_hv_nmos ad=0.85p pd=5.68u as=0.85p ps=5.68u w=2.5u l=1u
X19 comparator_body_0.m3_m4_diff_0.n1.t93 comparator_body_0.m3_m4_diff_0.n1.t92 a_n5969_n5656# AVDD sg13_hv_pmos ad=0.85p pd=5.68u as=0.85p ps=5.68u w=2.5u l=1u
X20 comparator_body_0.outx.t50 comparator_body_0.m3_m4_diff_0.n1.t86 a_n5969_2934# AVDD sg13_hv_pmos ad=0.85p pd=5.68u as=0.85p ps=5.68u w=2.5u l=1u
X21 a_n6285_11394# comparator_body_0.m3_m4_diff_0.n1.t76 AVDD AVDD sg13_hv_pmos ad=0.85p pd=5.68u as=0.85p ps=5.68u w=2.5u l=1u
X22 a_n421_4010# ibias.t10 AVSS.t33 AVSS.t29 sg13_hv_nmos ad=0.85p pd=5.68u as=0.85p ps=5.68u w=2.5u l=1u
X23 a_n1005_1394# ibias.t32 AVSS.t45 AVSS.t38 sg13_hv_nmos ad=0.85p pd=5.68u as=0.85p ps=5.68u w=2.5u l=1u
X24 a_n3898_n8459# inp comparator_body_0.mref_m5_diff_0.tail.t32 AVSS.t84 sg13_hv_nmos ad=0.85p pd=5.68u as=0.85p ps=5.68u w=2.5u l=1u
X25 a_n3898_3553# inn comparator_body_0.mref_m5_diff_0.tail.t90 AVSS.t95 sg13_hv_nmos ad=0.85p pd=5.68u as=0.85p ps=5.68u w=2.5u l=1u
X26 a_n6869_n4466# comparator_body_0.m3_m4_diff_0.n1.t54 comparator_body_0.outx.t10 AVDD sg13_hv_pmos ad=0.85p pd=5.68u as=0.85p ps=5.68u w=2.5u l=1u
X27 a_n421_n986# ibias.t4 AVSS.t53 AVSS.t36 sg13_hv_nmos ad=0.85p pd=5.68u as=0.85p ps=5.68u w=2.5u l=1u
X28 a_n421_n7172# ibias.t62 AVSS.t74 AVSS.t36 sg13_hv_nmos ad=0.85p pd=5.68u as=0.85p ps=5.68u w=2.5u l=1u
X29 comparator_body_0.mref_m5_diff_0.tail.t38 inp a_n2415_n1829# AVSS.t87 sg13_hv_nmos ad=0.85p pd=5.68u as=0.85p ps=5.68u w=2.5u l=1u
X30 comparator_body_0.mref_m5_diff_0.tail.t28 ibias.t44 a_479_1394# AVSS.t43 sg13_hv_nmos ad=0.85p pd=5.68u as=0.85p ps=5.68u w=2.5u l=1u
X31 a_n421_n986# ibias.t4 comparator_body_0.mref_m5_diff_0.tail.t5 AVSS.t36 sg13_hv_nmos ad=0.85p pd=5.68u as=0.85p ps=5.68u w=2.5u l=1u
X32 a_n421_n5982# ibias.t62 comparator_body_0.mref_m5_diff_0.tail.t16 AVSS.t36 sg13_hv_nmos ad=0.85p pd=5.68u as=0.85p ps=5.68u w=2.5u l=1u
X33 a_n6285_n5656# comparator_body_0.m3_m4_diff_0.n1.t94 AVDD AVDD sg13_hv_pmos ad=0.85p pd=5.68u as=0.85p ps=5.68u w=2.5u l=1u
X34 a_n6285_9014# comparator_body_0.m3_m4_diff_0.n1.t40 comparator_body_0.outx.t55 AVDD sg13_hv_pmos ad=0.85p pd=5.68u as=0.85p ps=5.68u w=2.5u l=1u
X35 AVDD comparator_body_0.m3_m4_diff_0.n1.t56 a_n5385_n766# AVDD sg13_hv_pmos ad=0.85p pd=5.68u as=0.85p ps=5.68u w=2.5u l=1u
X36 ibias.t43 ibias.t42 a_479_n2176# AVSS.t43 sg13_hv_nmos ad=0.85p pd=5.68u as=0.85p ps=5.68u w=2.5u l=1u
X37 a_n1005_n5982# ibias.t2 AVSS.t68 AVSS.t38 sg13_hv_nmos ad=0.85p pd=5.68u as=0.85p ps=5.68u w=2.5u l=1u
X38 comparator_body_0.mref_m5_diff_0.tail.t71 inn a_n2415_n5979# AVSS.t87 sg13_hv_nmos ad=0.85p pd=5.68u as=0.85p ps=5.68u w=2.5u l=1u
X39 comparator_body_0.mref_m5_diff_0.tail.t45 inp a_n3001_7684# AVSS.t81 sg13_hv_nmos ad=0.85p pd=5.68u as=0.85p ps=5.68u w=2.5u l=1u
X40 a_n6285_9014# comparator_body_0.m3_m4_diff_0.n1.t40 AVDD AVDD sg13_hv_pmos ad=0.85p pd=5.68u as=0.85p ps=5.68u w=2.5u l=1u
X41 AVDD comparator_body_0.m3_m4_diff_0.n1.t62 a_n5969_10204# AVDD sg13_hv_pmos ad=0.85p pd=5.68u as=0.85p ps=5.68u w=2.5u l=1u
X42 comparator_body_0.outx.t20 inn a_n2415_n5979# AVSS.t87 sg13_hv_nmos ad=0.85p pd=5.68u as=0.85p ps=5.68u w=2.5u l=1u
X43 a_n6869_4124# comparator_body_0.m3_m4_diff_0.n1.t50 comparator_body_0.m3_m4_diff_0.n1.t51 AVDD sg13_hv_pmos ad=0.85p pd=5.68u as=0.85p ps=5.68u w=2.5u l=1u
X44 a_n3898_8924# inn comparator_body_0.outx.t26 AVSS.t80 sg13_hv_nmos ad=0.85p pd=5.68u as=0.85p ps=5.68u w=2.5u l=1u
X45 comparator_body_0.outx.t51 comparator_body_0.m3_m4_diff_0.n1.t62 a_n5969_10204# AVDD sg13_hv_pmos ad=0.85p pd=5.68u as=0.85p ps=5.68u w=2.5u l=1u
X46 a_n3898_10164# inp comparator_body_0.m3_m4_diff_0.n1.t21 AVSS.t80 sg13_hv_nmos ad=0.85p pd=5.68u as=0.85p ps=5.68u w=2.5u l=1u
X47 comparator_body_0.mref_m5_diff_0.tail.t73 inn a_n3001_n7219# AVSS.t85 sg13_hv_nmos ad=0.85p pd=5.68u as=0.85p ps=5.68u w=2.5u l=1u
X48 comparator_body_0.mref_m5_diff_0.tail.t72 inn a_n3001_n4739# AVSS.t85 sg13_hv_nmos ad=0.85p pd=5.68u as=0.85p ps=5.68u w=2.5u l=1u
X49 a_n6869_4124# comparator_body_0.m3_m4_diff_0.n1.t50 AVDD AVDD sg13_hv_pmos ad=0.85p pd=5.68u as=0.85p ps=5.68u w=2.5u l=1u
X50 a_n421_10196# ibias.t40 ibias.t41 AVSS.t4 sg13_hv_nmos ad=0.85p pd=5.68u as=0.85p ps=5.68u w=2.5u l=1u
X51 a_n3898_2313# inp comparator_body_0.mref_m5_diff_0.tail.t61 AVSS.t84 sg13_hv_nmos ad=0.85p pd=5.68u as=0.85p ps=5.68u w=2.5u l=1u
X52 comparator_body_0.mref_m5_diff_0.tail.t93 inn a_n3001_3553# AVSS.t96 sg13_hv_nmos ad=0.85p pd=5.68u as=0.85p ps=5.68u w=2.5u l=1u
X53 comparator_body_0.mref_m5_diff_0.tail.t89 inn a_n3001_6033# AVSS.t81 sg13_hv_nmos ad=0.85p pd=5.68u as=0.85p ps=5.68u w=2.5u l=1u
X54 AVSS.t59 ibias.t42 a_479_n2176# AVSS.t43 sg13_hv_nmos ad=0.85p pd=5.68u as=0.85p ps=5.68u w=2.5u l=1u
X55 a_n421_1394# ibias.t16 comparator_body_0.mref_m5_diff_0.tail.t0 AVSS.t36 sg13_hv_nmos ad=0.85p pd=5.68u as=0.85p ps=5.68u w=2.5u l=1u
X56 AVSS.t25 ibias.t14 a_n105_5200# AVSS.t0 sg13_hv_nmos ad=0.85p pd=5.68u as=0.85p ps=5.68u w=2.5u l=1u
X57 comparator_body_0.m3_m4_diff_0.n1.t2 inp a_n3001_n3069# AVSS.t85 sg13_hv_nmos ad=0.85p pd=5.68u as=0.85p ps=5.68u w=2.5u l=1u
X58 a_n3898_2313# inp comparator_body_0.m3_m4_diff_0.n1.t29 AVSS.t84 sg13_hv_nmos ad=0.85p pd=5.68u as=0.85p ps=5.68u w=2.5u l=1u
X59 comparator_body_0.outx.t58 comparator_body_0.m3_m4_diff_0.n1.t90 a_n5969_n4466# AVDD sg13_hv_pmos ad=0.85p pd=5.68u as=0.85p ps=5.68u w=2.5u l=1u
X60 comparator_body_0.mref_m5_diff_0.tail.t68 inn a_n2415_n8459# AVSS.t87 sg13_hv_nmos ad=0.85p pd=5.68u as=0.85p ps=5.68u w=2.5u l=1u
X61 a_n3898_8924# inn comparator_body_0.mref_m5_diff_0.tail.t77 AVSS.t80 sg13_hv_nmos ad=0.85p pd=5.68u as=0.85p ps=5.68u w=2.5u l=1u
X62 comparator_body_0.outx.t29 inn a_n2415_10164# AVSS.t79 sg13_hv_nmos ad=0.85p pd=5.68u as=0.85p ps=5.68u w=2.5u l=1u
X63 comparator_body_0.mref_m5_diff_0.tail.t27 ibias.t14 a_n105_5200# AVSS.t0 sg13_hv_nmos ad=0.85p pd=5.68u as=0.85p ps=5.68u w=2.5u l=1u
X64 a_n1005_n4792# ibias.t34 AVSS.t64 AVSS.t38 sg13_hv_nmos ad=0.85p pd=5.68u as=0.85p ps=5.68u w=2.5u l=1u
X65 comparator_body_0.mref_m5_diff_0.tail.t26 ibias.t50 a_479_9006# AVSS.t8 sg13_hv_nmos ad=0.85p pd=5.68u as=0.85p ps=5.68u w=2.5u l=1u
X66 a_n3314_651# inp comparator_body_0.mref_m5_diff_0.tail.t60 AVSS.t86 sg13_hv_nmos ad=0.85p pd=5.68u as=0.85p ps=5.68u w=2.5u l=1u
X67 AVSS.t70 ibias.t0 a_n105_n5982# AVSS.t40 sg13_hv_nmos ad=0.85p pd=5.68u as=0.85p ps=5.68u w=2.5u l=1u
X68 a_n3898_n3069# inp comparator_body_0.mref_m5_diff_0.tail.t37 AVSS.t84 sg13_hv_nmos ad=0.85p pd=5.68u as=0.85p ps=5.68u w=2.5u l=1u
X69 comparator_body_0.mref_m5_diff_0.tail.t74 inn a_n3001_11404# AVSS.t81 sg13_hv_nmos ad=0.85p pd=5.68u as=0.85p ps=5.68u w=2.5u l=1u
X70 AVSS.t17 ibias.t50 a_479_9006# AVSS.t8 sg13_hv_nmos ad=0.85p pd=5.68u as=0.85p ps=5.68u w=2.5u l=1u
X71 a_n6285_n766# comparator_body_0.m3_m4_diff_0.n1.t60 AVDD AVDD sg13_hv_pmos ad=0.85p pd=5.68u as=0.85p ps=5.68u w=2.5u l=1u
X72 comparator_body_0.outx.t23 inn a_n3001_11404# AVSS.t81 sg13_hv_nmos ad=0.85p pd=5.68u as=0.85p ps=5.68u w=2.5u l=1u
X73 comparator_body_0.outx.t36 inn a_n3001_8924# AVSS.t81 sg13_hv_nmos ad=0.85p pd=5.68u as=0.85p ps=5.68u w=2.5u l=1u
X74 a_n3898_4793# inp comparator_body_0.mref_m5_diff_0.tail.t57 AVSS.t80 sg13_hv_nmos ad=0.85p pd=5.68u as=0.85p ps=5.68u w=2.5u l=1u
X75 a_n6869_n1956# comparator_body_0.m3_m4_diff_0.n1.t36 comparator_body_0.outx.t56 AVDD sg13_hv_pmos ad=0.85p pd=5.68u as=0.85p ps=5.68u w=2.5u l=1u
X76 comparator_body_0.mref_m5_diff_0.tail.t55 inp a_n3001_2313# AVSS.t85 sg13_hv_nmos ad=0.85p pd=5.68u as=0.85p ps=5.68u w=2.5u l=1u
X77 a_5133_1513# a_2989_2085# AVSS.t92 AVSS.t90 sg13_hv_nmos ad=0.85p pd=5.68u as=0.85p ps=5.68u w=2.5u l=1u
X78 a_n421_9006# ibias.t28 comparator_body_0.mref_m5_diff_0.tail.t11 AVSS.t4 sg13_hv_nmos ad=0.85p pd=5.68u as=0.85p ps=5.68u w=2.5u l=1u
X79 comparator_body_0.m3_m4_diff_0.n1.t85 comparator_body_0.m3_m4_diff_0.n1.t84 a_n5385_n6846# AVDD sg13_hv_pmos ad=0.85p pd=5.68u as=0.85p ps=5.68u w=2.5u l=1u
X80 comparator_body_0.m3_m4_diff_0.n1.t23 inp a_n3001_2313# AVSS.t85 sg13_hv_nmos ad=0.85p pd=5.68u as=0.85p ps=5.68u w=2.5u l=1u
X81 a_n6869_2934# comparator_body_0.m3_m4_diff_0.n1.t50 comparator_body_0.outx.t63 AVDD sg13_hv_pmos ad=0.85p pd=5.68u as=0.85p ps=5.68u w=2.5u l=1u
X82 a_n1005_4010# ibias.t38 ibias.t39 AVSS.t28 sg13_hv_nmos ad=0.85p pd=5.68u as=0.85p ps=5.68u w=2.5u l=1u
X83 comparator_body_0.mref_m5_diff_0.tail.t56 inp a_n3001_n589# AVSS.t85 sg13_hv_nmos ad=0.85p pd=5.68u as=0.85p ps=5.68u w=2.5u l=1u
X84 a_n421_9006# ibias.t28 AVSS.t15 AVSS.t4 sg13_hv_nmos ad=0.85p pd=5.68u as=0.85p ps=5.68u w=2.5u l=1u
X85 comparator_body_0.mref_m5_diff_0.tail.t87 inn a_n3001_8924# AVSS.t81 sg13_hv_nmos ad=0.85p pd=5.68u as=0.85p ps=5.68u w=2.5u l=1u
X86 AVDD comparator_body_0.m3_m4_diff_0.n1.t52 a_n5385_5314# AVDD sg13_hv_pmos ad=0.85p pd=5.68u as=0.85p ps=5.68u w=2.5u l=1u
X87 AVSS.t66 ibias.t46 a_n105_n4792# AVSS.t40 sg13_hv_nmos ad=0.85p pd=5.68u as=0.85p ps=5.68u w=2.5u l=1u
X88 comparator_body_0.m3_m4_diff_0.n1.t10 inp a_n2415_n7219# AVSS.t87 sg13_hv_nmos ad=0.85p pd=5.68u as=0.85p ps=5.68u w=2.5u l=1u
X89 comparator_body_0.mref_m5_diff_0.tail.t64 inn a_n3001_n1829# AVSS.t85 sg13_hv_nmos ad=0.85p pd=5.68u as=0.85p ps=5.68u w=2.5u l=1u
X90 a_n1005_4010# ibias.t38 AVSS.t32 AVSS.t28 sg13_hv_nmos ad=0.85p pd=5.68u as=0.85p ps=5.68u w=2.5u l=1u
X91 comparator_body_0.m3_m4_diff_0.n1.t8 inp a_n2415_n4739# AVSS.t87 sg13_hv_nmos ad=0.85p pd=5.68u as=0.85p ps=5.68u w=2.5u l=1u
X92 a_n3898_7684# inp comparator_body_0.m3_m4_diff_0.n1.t18 AVSS.t80 sg13_hv_nmos ad=0.85p pd=5.68u as=0.85p ps=5.68u w=2.5u l=1u
X93 comparator_body_0.m3_m4_diff_0.n1.t53 comparator_body_0.m3_m4_diff_0.n1.t52 a_n5385_5314# AVDD sg13_hv_pmos ad=0.85p pd=5.68u as=0.85p ps=5.68u w=2.5u l=1u
X94 a_3841_1513# comparator_body_0.outx.t64 AVSS.t77 AVSS.t76 sg13_hv_nmos ad=0.85p pd=5.68u as=0.85p ps=5.68u w=2.5u l=1u
X95 comparator_body_0.outx.t25 inn a_n2415_7684# AVSS.t79 sg13_hv_nmos ad=0.85p pd=5.68u as=0.85p ps=5.68u w=2.5u l=1u
X96 ibias.t9 ibias.t8 a_479_n4792# AVSS.t43 sg13_hv_nmos ad=0.85p pd=5.68u as=0.85p ps=5.68u w=2.5u l=1u
X97 a_n3897_n4739# inn comparator_body_0.mref_m5_diff_0.tail.t70 AVSS.t97 sg13_hv_nmos ad=0.85p pd=5.68u as=0.85p ps=5.68u w=2.5u l=1u
X98 a_5133_1513# a_2989_2085# out AVSS.t90 sg13_hv_nmos ad=0.85p pd=5.68u as=0.85p ps=5.68u w=2.5u l=1u
X99 comparator_body_0.mref_m5_diff_0.tail.t33 inp a_n3001_n8459# AVSS.t85 sg13_hv_nmos ad=0.85p pd=5.68u as=0.85p ps=5.68u w=2.5u l=1u
X100 a_5163_3330# a_2989_2085# out AVDD1V2 sg13_hv_pmos ad=0.85p pd=5.68u as=0.85p ps=5.68u w=2.5u l=1u
X101 a_n1005_n986# ibias.t18 AVSS.t52 AVSS.t38 sg13_hv_nmos ad=0.85p pd=5.68u as=0.85p ps=5.68u w=2.5u l=1u
X102 a_n1005_11386# ibias.t24 AVSS.t3 AVSS.t2 sg13_hv_nmos ad=0.85p pd=5.68u as=0.85p ps=5.68u w=2.5u l=1u
X103 comparator_body_0.mref_m5_diff_0.tail.t95 inn a_n2415_n3069# AVSS.t87 sg13_hv_nmos ad=0.85p pd=5.68u as=0.85p ps=5.68u w=2.5u l=1u
X104 comparator_body_0.mref_m5_diff_0.tail.t85 inn a_n3001_651# AVSS.t85 sg13_hv_nmos ad=0.85p pd=5.68u as=0.85p ps=5.68u w=2.5u l=1u
X105 comparator_body_0.mref_m5_diff_0.tail.t49 inp a_n3001_4793# AVSS.t81 sg13_hv_nmos ad=0.85p pd=5.68u as=0.85p ps=5.68u w=2.5u l=1u
X106 AVDD comparator_body_0.m3_m4_diff_0.n1.t86 a_n5969_2934# AVDD sg13_hv_pmos ad=0.85p pd=5.68u as=0.85p ps=5.68u w=2.5u l=1u
X107 a_n3898_n589# inp comparator_body_0.m3_m4_diff_0.n1.t31 AVSS.t84 sg13_hv_nmos ad=0.85p pd=5.68u as=0.85p ps=5.68u w=2.5u l=1u
X108 a_n1005_n986# ibias.t18 ibias.t19 AVSS.t38 sg13_hv_nmos ad=0.85p pd=5.68u as=0.85p ps=5.68u w=2.5u l=1u
X109 a_n3898_3553# inn comparator_body_0.outx.t39 AVSS.t95 sg13_hv_nmos ad=0.85p pd=5.68u as=0.85p ps=5.68u w=2.5u l=1u
X110 comparator_body_0.m3_m4_diff_0.n1.t67 comparator_body_0.m3_m4_diff_0.n1.t66 a_n5969_6504# AVDD sg13_hv_pmos ad=0.85p pd=5.68u as=0.85p ps=5.68u w=2.5u l=1u
X111 comparator_body_0.m3_m4_diff_0.n1.t27 inp a_n2415_3553# AVSS.t83 sg13_hv_nmos ad=0.85p pd=5.68u as=0.85p ps=5.68u w=2.5u l=1u
X112 comparator_body_0.m3_m4_diff_0.n1.t26 inp a_n2415_6033# AVSS.t79 sg13_hv_nmos ad=0.85p pd=5.68u as=0.85p ps=5.68u w=2.5u l=1u
X113 a_n6869_n4466# comparator_body_0.m3_m4_diff_0.n1.t54 AVDD AVDD sg13_hv_pmos ad=0.85p pd=5.68u as=0.85p ps=5.68u w=2.5u l=1u
X114 comparator_body_0.outx.t57 comparator_body_0.m3_m4_diff_0.n1.t70 a_n5969_n1956# AVDD sg13_hv_pmos ad=0.85p pd=5.68u as=0.85p ps=5.68u w=2.5u l=1u
X115 AVDD comparator_body_0.m3_m4_diff_0.n1.t68 a_n5385_11394# AVDD sg13_hv_pmos ad=0.85p pd=5.68u as=0.85p ps=5.68u w=2.5u l=1u
X116 comparator_body_0.m3_m4_diff_0.n1.t30 inp a_n2415_11404# AVSS.t79 sg13_hv_nmos ad=0.85p pd=5.68u as=0.85p ps=5.68u w=2.5u l=1u
X117 a_3841_1513# comparator_body_0.outx.t64 a_2989_2085# AVSS.t76 sg13_hv_nmos ad=0.85p pd=5.68u as=0.85p ps=5.68u w=2.5u l=1u
X118 a_3871_3330# comparator_body_0.outx.t66 a_2989_2085# AVDD sg13_hv_pmos ad=0.85p pd=5.68u as=0.85p ps=5.68u w=2.5u l=1u
X119 comparator_body_0.mref_m5_diff_0.tail.t62 inp a_n2415_11404# AVSS.t79 sg13_hv_nmos ad=0.85p pd=5.68u as=0.85p ps=5.68u w=2.5u l=1u
X120 a_n3897_11404# inn comparator_body_0.mref_m5_diff_0.tail.t86 AVSS.t94 sg13_hv_nmos ad=0.85p pd=5.68u as=0.85p ps=5.68u w=2.5u l=1u
X121 AVSS.t44 ibias.t30 a_479_2820# AVSS.t43 sg13_hv_nmos ad=0.85p pd=5.68u as=0.85p ps=5.68u w=2.5u l=1u
X122 a_n1005_n2176# ibias.t18 comparator_body_0.mref_m5_diff_0.tail.t29 AVSS.t38 sg13_hv_nmos ad=0.85p pd=5.68u as=0.85p ps=5.68u w=2.5u l=1u
X123 AVSS.t23 ibias.t58 a_479_6390# AVSS.t8 sg13_hv_nmos ad=0.85p pd=5.68u as=0.85p ps=5.68u w=2.5u l=1u
X124 a_n3897_11404# inn comparator_body_0.outx.t35 AVSS.t94 sg13_hv_nmos ad=0.85p pd=5.68u as=0.85p ps=5.68u w=2.5u l=1u
X125 comparator_body_0.mref_m5_diff_0.tail.t23 ibias.t48 a_479_11386# AVSS.t8 sg13_hv_nmos ad=0.85p pd=5.68u as=0.85p ps=5.68u w=2.5u l=1u
X126 comparator_body_0.m3_m4_diff_0.n1.t15 inp a_n3001_10164# AVSS.t81 sg13_hv_nmos ad=0.85p pd=5.68u as=0.85p ps=5.68u w=2.5u l=1u
X127 AVSS.t63 ibias.t8 a_479_n3602# AVSS.t43 sg13_hv_nmos ad=0.85p pd=5.68u as=0.85p ps=5.68u w=2.5u l=1u
X128 comparator_body_0.m3_m4_diff_0.n1.t13 inp a_n3001_7684# AVSS.t81 sg13_hv_nmos ad=0.85p pd=5.68u as=0.85p ps=5.68u w=2.5u l=1u
X129 a_n6285_11394# comparator_body_0.m3_m4_diff_0.n1.t76 comparator_body_0.outx.t12 AVDD sg13_hv_pmos ad=0.85p pd=5.68u as=0.85p ps=5.68u w=2.5u l=1u
X130 AVDD comparator_body_0.m3_m4_diff_0.n1.t66 a_n5969_6504# AVDD sg13_hv_pmos ad=0.85p pd=5.68u as=0.85p ps=5.68u w=2.5u l=1u
X131 AVDD comparator_body_0.m3_m4_diff_0.n1.t84 a_n5385_n5656# AVDD sg13_hv_pmos ad=0.85p pd=5.68u as=0.85p ps=5.68u w=2.5u l=1u
X132 a_n6285_n1956# comparator_body_0.m3_m4_diff_0.n1.t60 AVDD AVDD sg13_hv_pmos ad=0.85p pd=5.68u as=0.85p ps=5.68u w=2.5u l=1u
X133 a_n6285_5314# comparator_body_0.m3_m4_diff_0.n1.t58 AVDD AVDD sg13_hv_pmos ad=0.85p pd=5.68u as=0.85p ps=5.68u w=2.5u l=1u
X134 a_n1005_1394# ibias.t32 ibias.t33 AVSS.t38 sg13_hv_nmos ad=0.85p pd=5.68u as=0.85p ps=5.68u w=2.5u l=1u
X135 AVDD comparator_body_0.m3_m4_diff_0.n1.t34 a_n5385_7824# AVDD sg13_hv_pmos ad=0.85p pd=5.68u as=0.85p ps=5.68u w=2.5u l=1u
X136 AVSS.t7 ibias.t54 a_n105_11386# AVSS.t0 sg13_hv_nmos ad=0.85p pd=5.68u as=0.85p ps=5.68u w=2.5u l=1u
X137 a_n3897_6033# inn comparator_body_0.mref_m5_diff_0.tail.t88 AVSS.t94 sg13_hv_nmos ad=0.85p pd=5.68u as=0.85p ps=5.68u w=2.5u l=1u
X138 comparator_body_0.mref_m5_diff_0.tail.t44 inp a_n2415_8924# AVSS.t79 sg13_hv_nmos ad=0.85p pd=5.68u as=0.85p ps=5.68u w=2.5u l=1u
X139 a_n6285_5314# comparator_body_0.m3_m4_diff_0.n1.t58 comparator_body_0.m3_m4_diff_0.n1.t59 AVDD sg13_hv_pmos ad=0.85p pd=5.68u as=0.85p ps=5.68u w=2.5u l=1u
X140 comparator_body_0.m3_m4_diff_0.n1.t24 inp a_n3001_n589# AVSS.t85 sg13_hv_nmos ad=0.85p pd=5.68u as=0.85p ps=5.68u w=2.5u l=1u
X141 a_n3314_7684# inn comparator_body_0.outx.t27 AVSS.t78 sg13_hv_nmos ad=0.85p pd=5.68u as=0.85p ps=5.68u w=2.5u l=1u
X142 AVSS.t46 ibias.t22 a_n105_1394# AVSS.t40 sg13_hv_nmos ad=0.85p pd=5.68u as=0.85p ps=5.68u w=2.5u l=1u
X143 comparator_body_0.m3_m4_diff_0.n1.t6 inp a_n2415_n1829# AVSS.t87 sg13_hv_nmos ad=0.85p pd=5.68u as=0.85p ps=5.68u w=2.5u l=1u
X144 comparator_body_0.outx.t42 inn a_n3001_3553# AVSS.t96 sg13_hv_nmos ad=0.85p pd=5.68u as=0.85p ps=5.68u w=2.5u l=1u
X145 ibias.t31 ibias.t30 a_479_2820# AVSS.t31 sg13_hv_nmos ad=0.85p pd=5.68u as=0.85p ps=5.68u w=2.5u l=1u
X146 a_n1005_n2176# ibias.t18 AVSS.t57 AVSS.t38 sg13_hv_nmos ad=0.85p pd=5.68u as=0.85p ps=5.68u w=2.5u l=1u
X147 comparator_body_0.outx.t32 inn a_n2415_2313# AVSS.t87 sg13_hv_nmos ad=0.85p pd=5.68u as=0.85p ps=5.68u w=2.5u l=1u
X148 a_n6285_n5656# comparator_body_0.m3_m4_diff_0.n1.t94 comparator_body_0.outx.t46 AVDD sg13_hv_pmos ad=0.85p pd=5.68u as=0.85p ps=5.68u w=2.5u l=1u
X149 comparator_body_0.outx.t4 comparator_body_0.m3_m4_diff_0.n1.t56 a_n5385_n766# AVDD sg13_hv_pmos ad=0.85p pd=5.68u as=0.85p ps=5.68u w=2.5u l=1u
X150 comparator_body_0.mref_m5_diff_0.tail.t30 ibias.t8 a_479_n3602# AVSS.t43 sg13_hv_nmos ad=0.85p pd=5.68u as=0.85p ps=5.68u w=2.5u l=1u
X151 comparator_body_0.mref_m5_diff_0.tail.t34 inp a_n3001_n3069# AVSS.t85 sg13_hv_nmos ad=0.85p pd=5.68u as=0.85p ps=5.68u w=2.5u l=1u
X152 AVDD comparator_body_0.m3_m4_diff_0.n1.t90 a_n5969_n4466# AVDD sg13_hv_pmos ad=0.85p pd=5.68u as=0.85p ps=5.68u w=2.5u l=1u
X153 comparator_body_0.outx.t17 inn a_n2415_n8459# AVSS.t87 sg13_hv_nmos ad=0.85p pd=5.68u as=0.85p ps=5.68u w=2.5u l=1u
X154 a_n421_2820# ibias.t10 AVSS.t37 AVSS.t36 sg13_hv_nmos ad=0.85p pd=5.68u as=0.85p ps=5.68u w=2.5u l=1u
X155 comparator_body_0.mref_m5_diff_0.tail.t83 inn a_n2415_2313# AVSS.t87 sg13_hv_nmos ad=0.85p pd=5.68u as=0.85p ps=5.68u w=2.5u l=1u
X156 a_n421_6390# ibias.t60 AVSS.t22 AVSS.t4 sg13_hv_nmos ad=0.85p pd=5.68u as=0.85p ps=5.68u w=2.5u l=1u
X157 comparator_body_0.m3_m4_diff_0.n1.t35 comparator_body_0.m3_m4_diff_0.n1.t34 a_n5385_7824# AVDD sg13_hv_pmos ad=0.85p pd=5.68u as=0.85p ps=5.68u w=2.5u l=1u
X158 a_n3314_3553# inp comparator_body_0.m3_m4_diff_0.n1.t20 AVSS.t82 sg13_hv_nmos ad=0.85p pd=5.68u as=0.85p ps=5.68u w=2.5u l=1u
X159 a_n3314_6033# inp comparator_body_0.m3_m4_diff_0.n1.t19 AVSS.t78 sg13_hv_nmos ad=0.85p pd=5.68u as=0.85p ps=5.68u w=2.5u l=1u
X160 comparator_body_0.m3_m4_diff_0.n1.t12 inp a_n2415_8924# AVSS.t79 sg13_hv_nmos ad=0.85p pd=5.68u as=0.85p ps=5.68u w=2.5u l=1u
X161 comparator_body_0.mref_m5_diff_0.tail.t14 ibias.t20 a_n105_n2176# AVSS.t40 sg13_hv_nmos ad=0.85p pd=5.68u as=0.85p ps=5.68u w=2.5u l=1u
X162 AVSS.t51 ibias.t44 a_479_204# AVSS.t43 sg13_hv_nmos ad=0.85p pd=5.68u as=0.85p ps=5.68u w=2.5u l=1u
X163 a_n6869_n3276# comparator_body_0.m3_m4_diff_0.n1.t54 AVDD AVDD sg13_hv_pmos ad=0.85p pd=5.68u as=0.85p ps=5.68u w=2.5u l=1u
X164 a_n421_n5982# ibias.t62 AVSS.t69 AVSS.t36 sg13_hv_nmos ad=0.85p pd=5.68u as=0.85p ps=5.68u w=2.5u l=1u
X165 a_n6869_n6846# comparator_body_0.m3_m4_diff_0.n1.t80 AVDD AVDD sg13_hv_pmos ad=0.85p pd=5.68u as=0.85p ps=5.68u w=2.5u l=1u
X166 ibias.t45 ibias.t44 a_479_204# AVSS.t43 sg13_hv_nmos ad=0.85p pd=5.68u as=0.85p ps=5.68u w=2.5u l=1u
X167 AVDD comparator_body_0.m3_m4_diff_0.n1.t38 a_n5385_424# AVDD sg13_hv_pmos ad=0.85p pd=5.68u as=0.85p ps=5.68u w=2.5u l=1u
X168 a_n1005_9006# ibias.t26 ibias.t27 AVSS.t2 sg13_hv_nmos ad=0.85p pd=5.68u as=0.85p ps=5.68u w=2.5u l=1u
X169 comparator_body_0.m3_m4_diff_0.n1.t45 comparator_body_0.m3_m4_diff_0.n1.t44 a_n5969_9014# AVDD sg13_hv_pmos ad=0.85p pd=5.68u as=0.85p ps=5.68u w=2.5u l=1u
X170 a_n3898_4793# inp comparator_body_0.m3_m4_diff_0.n1.t25 AVSS.t80 sg13_hv_nmos ad=0.85p pd=5.68u as=0.85p ps=5.68u w=2.5u l=1u
X171 comparator_body_0.outx.t38 inn a_n3001_6033# AVSS.t81 sg13_hv_nmos ad=0.85p pd=5.68u as=0.85p ps=5.68u w=2.5u l=1u
X172 comparator_body_0.m3_m4_diff_0.n1.t22 inp a_n2415_651# AVSS.t87 sg13_hv_nmos ad=0.85p pd=5.68u as=0.85p ps=5.68u w=2.5u l=1u
X173 a_n421_2820# ibias.t10 ibias.t11 AVSS.t29 sg13_hv_nmos ad=0.85p pd=5.68u as=0.85p ps=5.68u w=2.5u l=1u
X174 comparator_body_0.outx.t24 inn a_n2415_4793# AVSS.t79 sg13_hv_nmos ad=0.85p pd=5.68u as=0.85p ps=5.68u w=2.5u l=1u
X175 comparator_body_0.m3_m4_diff_0.n1.t39 comparator_body_0.m3_m4_diff_0.n1.t38 a_n5385_424# AVDD sg13_hv_pmos ad=0.85p pd=5.68u as=0.85p ps=5.68u w=2.5u l=1u
X176 a_n1005_9006# ibias.t26 AVSS.t14 AVSS.t2 sg13_hv_nmos ad=0.85p pd=5.68u as=0.85p ps=5.68u w=2.5u l=1u
X177 AVSS.t13 ibias.t48 a_479_10196# AVSS.t8 sg13_hv_nmos ad=0.85p pd=5.68u as=0.85p ps=5.68u w=2.5u l=1u
X178 AVDD comparator_body_0.m3_m4_diff_0.n1.t44 a_n5969_9014# AVDD sg13_hv_pmos ad=0.85p pd=5.68u as=0.85p ps=5.68u w=2.5u l=1u
X179 a_n421_204# ibias.t16 AVSS.t49 AVSS.t36 sg13_hv_nmos ad=0.85p pd=5.68u as=0.85p ps=5.68u w=2.5u l=1u
X180 a_n6285_10204# comparator_body_0.m3_m4_diff_0.n1.t76 AVDD AVDD sg13_hv_pmos ad=0.85p pd=5.68u as=0.85p ps=5.68u w=2.5u l=1u
X181 a_n3314_n4739# inp comparator_body_0.mref_m5_diff_0.tail.t41 AVSS.t86 sg13_hv_nmos ad=0.85p pd=5.68u as=0.85p ps=5.68u w=2.5u l=1u
X182 a_n6285_7824# comparator_body_0.m3_m4_diff_0.n1.t40 AVDD AVDD sg13_hv_pmos ad=0.85p pd=5.68u as=0.85p ps=5.68u w=2.5u l=1u
X183 AVSS.t58 ibias.t20 a_n105_n2176# AVSS.t40 sg13_hv_nmos ad=0.85p pd=5.68u as=0.85p ps=5.68u w=2.5u l=1u
X184 comparator_body_0.mref_m5_diff_0.tail.t80 inn a_n2415_10164# AVSS.t79 sg13_hv_nmos ad=0.85p pd=5.68u as=0.85p ps=5.68u w=2.5u l=1u
X185 a_n3314_8924# inp comparator_body_0.mref_m5_diff_0.tail.t48 AVSS.t78 sg13_hv_nmos ad=0.85p pd=5.68u as=0.85p ps=5.68u w=2.5u l=1u
X186 a_n421_204# ibias.t16 ibias.t17 AVSS.t36 sg13_hv_nmos ad=0.85p pd=5.68u as=0.85p ps=5.68u w=2.5u l=1u
X187 a_n6285_10204# comparator_body_0.m3_m4_diff_0.n1.t76 comparator_body_0.m3_m4_diff_0.n1.t77 AVDD sg13_hv_pmos ad=0.85p pd=5.68u as=0.85p ps=5.68u w=2.5u l=1u
X188 a_n6869_n3276# comparator_body_0.m3_m4_diff_0.n1.t54 comparator_body_0.m3_m4_diff_0.n1.t55 AVDD sg13_hv_pmos ad=0.85p pd=5.68u as=0.85p ps=5.68u w=2.5u l=1u
X189 a_n6869_2934# comparator_body_0.m3_m4_diff_0.n1.t50 AVDD AVDD sg13_hv_pmos ad=0.85p pd=5.68u as=0.85p ps=5.68u w=2.5u l=1u
X190 a_n3314_2313# inn comparator_body_0.outx.t41 AVSS.t86 sg13_hv_nmos ad=0.85p pd=5.68u as=0.85p ps=5.68u w=2.5u l=1u
X191 a_n6285_n766# comparator_body_0.m3_m4_diff_0.n1.t60 comparator_body_0.outx.t53 AVDD sg13_hv_pmos ad=0.85p pd=5.68u as=0.85p ps=5.68u w=2.5u l=1u
X192 a_n6869_6504# comparator_body_0.m3_m4_diff_0.n1.t74 comparator_body_0.m3_m4_diff_0.n1.t75 AVDD sg13_hv_pmos ad=0.85p pd=5.68u as=0.85p ps=5.68u w=2.5u l=1u
X193 a_n421_n4792# ibias.t6 AVSS.t65 AVSS.t36 sg13_hv_nmos ad=0.85p pd=5.68u as=0.85p ps=5.68u w=2.5u l=1u
X194 a_n6285_n4466# comparator_body_0.m3_m4_diff_0.n1.t88 comparator_body_0.m3_m4_diff_0.n1.t89 AVDD sg13_hv_pmos ad=0.85p pd=5.68u as=0.85p ps=5.68u w=2.5u l=1u
X195 a_n6285_7824# comparator_body_0.m3_m4_diff_0.n1.t40 comparator_body_0.m3_m4_diff_0.n1.t41 AVDD sg13_hv_pmos ad=0.85p pd=5.68u as=0.85p ps=5.68u w=2.5u l=1u
X196 a_n3897_651# inn comparator_body_0.mref_m5_diff_0.tail.t91 AVSS.t97 sg13_hv_nmos ad=0.85p pd=5.68u as=0.85p ps=5.68u w=2.5u l=1u
X197 a_n3314_2313# inn comparator_body_0.mref_m5_diff_0.tail.t92 AVSS.t86 sg13_hv_nmos ad=0.85p pd=5.68u as=0.85p ps=5.68u w=2.5u l=1u
X198 comparator_body_0.mref_m5_diff_0.tail.t76 inn a_n2415_7684# AVSS.t79 sg13_hv_nmos ad=0.85p pd=5.68u as=0.85p ps=5.68u w=2.5u l=1u
X199 a_n1005_n4792# ibias.t34 comparator_body_0.mref_m5_diff_0.tail.t3 AVSS.t38 sg13_hv_nmos ad=0.85p pd=5.68u as=0.85p ps=5.68u w=2.5u l=1u
X200 a_n3314_8924# inp comparator_body_0.m3_m4_diff_0.n1.t16 AVSS.t78 sg13_hv_nmos ad=0.85p pd=5.68u as=0.85p ps=5.68u w=2.5u l=1u
X201 a_n3314_n7219# inp comparator_body_0.mref_m5_diff_0.tail.t43 AVSS.t86 sg13_hv_nmos ad=0.85p pd=5.68u as=0.85p ps=5.68u w=2.5u l=1u
X202 AVDD comparator_body_0.m3_m4_diff_0.n1.t90 a_n5969_n3276# AVDD sg13_hv_pmos ad=0.85p pd=5.68u as=0.85p ps=5.68u w=2.5u l=1u
X203 comparator_body_0.outx.t7 comparator_body_0.m3_m4_diff_0.n1.t38 a_n5385_1614# AVDD sg13_hv_pmos ad=0.85p pd=5.68u as=0.85p ps=5.68u w=2.5u l=1u
X204 a_5747_3330# a_2989_2085# AVDD1V2 AVDD1V2 sg13_hv_pmos ad=0.85p pd=5.68u as=0.85p ps=5.68u w=2.5u l=1u
X205 comparator_body_0.outx.t44 inn a_n2415_n3069# AVSS.t87 sg13_hv_nmos ad=0.85p pd=5.68u as=0.85p ps=5.68u w=2.5u l=1u
X206 AVDD comparator_body_0.m3_m4_diff_0.n1.t92 a_n5969_n6846# AVDD sg13_hv_pmos ad=0.85p pd=5.68u as=0.85p ps=5.68u w=2.5u l=1u
X207 comparator_body_0.m3_m4_diff_0.n1.t17 inp a_n3001_4793# AVSS.t81 sg13_hv_nmos ad=0.85p pd=5.68u as=0.85p ps=5.68u w=2.5u l=1u
X208 comparator_body_0.mref_m5_diff_0.tail.t84 inn a_n2415_n589# AVSS.t87 sg13_hv_nmos ad=0.85p pd=5.68u as=0.85p ps=5.68u w=2.5u l=1u
X209 AVSS.t20 ibias.t50 a_479_7816# AVSS.t8 sg13_hv_nmos ad=0.85p pd=5.68u as=0.85p ps=5.68u w=2.5u l=1u
X210 AVDD comparator_body_0.m3_m4_diff_0.n1.t70 a_n5969_n766# AVDD sg13_hv_pmos ad=0.85p pd=5.68u as=0.85p ps=5.68u w=2.5u l=1u
X211 a_n6869_6504# comparator_body_0.m3_m4_diff_0.n1.t74 AVDD AVDD sg13_hv_pmos ad=0.85p pd=5.68u as=0.85p ps=5.68u w=2.5u l=1u
X212 comparator_body_0.mref_m5_diff_0.tail.t59 inp a_n2415_3553# AVSS.t83 sg13_hv_nmos ad=0.85p pd=5.68u as=0.85p ps=5.68u w=2.5u l=1u
X213 comparator_body_0.outx.t33 inn a_n2415_n589# AVSS.t87 sg13_hv_nmos ad=0.85p pd=5.68u as=0.85p ps=5.68u w=2.5u l=1u
X214 a_n3314_651# inp comparator_body_0.m3_m4_diff_0.n1.t28 AVSS.t86 sg13_hv_nmos ad=0.85p pd=5.68u as=0.85p ps=5.68u w=2.5u l=1u
X215 a_n3314_4793# inn comparator_body_0.outx.t28 AVSS.t78 sg13_hv_nmos ad=0.85p pd=5.68u as=0.85p ps=5.68u w=2.5u l=1u
X216 ibias.t13 ibias.t12 a_n105_4010# AVSS.t30 sg13_hv_nmos ad=0.85p pd=5.68u as=0.85p ps=5.68u w=2.5u l=1u
X217 comparator_body_0.m3_m4_diff_0.n1.t91 comparator_body_0.m3_m4_diff_0.n1.t90 a_n5969_n3276# AVDD sg13_hv_pmos ad=0.85p pd=5.68u as=0.85p ps=5.68u w=2.5u l=1u
X218 AVDD comparator_body_0.m3_m4_diff_0.n1.t38 a_n5385_1614# AVDD sg13_hv_pmos ad=0.85p pd=5.68u as=0.85p ps=5.68u w=2.5u l=1u
X219 AVSS.t34 ibias.t12 a_n105_4010# AVSS.t30 sg13_hv_nmos ad=0.85p pd=5.68u as=0.85p ps=5.68u w=2.5u l=1u
X220 a_n1005_n3602# ibias.t34 AVSS.t60 AVSS.t38 sg13_hv_nmos ad=0.85p pd=5.68u as=0.85p ps=5.68u w=2.5u l=1u
X221 ibias.t37 ibias.t36 a_479_n7172# AVSS.t43 sg13_hv_nmos ad=0.85p pd=5.68u as=0.85p ps=5.68u w=2.5u l=1u
X222 ibias.t51 ibias.t50 a_479_7816# AVSS.t8 sg13_hv_nmos ad=0.85p pd=5.68u as=0.85p ps=5.68u w=2.5u l=1u
X223 a_n1005_11386# ibias.t24 ibias.t25 AVSS.t2 sg13_hv_nmos ad=0.85p pd=5.68u as=0.85p ps=5.68u w=2.5u l=1u
X224 a_n3314_n1829# inp comparator_body_0.mref_m5_diff_0.tail.t35 AVSS.t86 sg13_hv_nmos ad=0.85p pd=5.68u as=0.85p ps=5.68u w=2.5u l=1u
X225 comparator_body_0.mref_m5_diff_0.tail.t15 ibias.t46 a_n105_n4792# AVSS.t40 sg13_hv_nmos ad=0.85p pd=5.68u as=0.85p ps=5.68u w=2.5u l=1u
X226 a_n421_7816# ibias.t28 AVSS.t5 AVSS.t4 sg13_hv_nmos ad=0.85p pd=5.68u as=0.85p ps=5.68u w=2.5u l=1u
X227 a_n3314_n5979# inn comparator_body_0.mref_m5_diff_0.tail.t66 AVSS.t86 sg13_hv_nmos ad=0.85p pd=5.68u as=0.85p ps=5.68u w=2.5u l=1u
X228 comparator_body_0.outx.t34 inn a_n3001_651# AVSS.t85 sg13_hv_nmos ad=0.85p pd=5.68u as=0.85p ps=5.68u w=2.5u l=1u
X229 comparator_body_0.mref_m5_diff_0.tail.t58 inp a_n2415_6033# AVSS.t79 sg13_hv_nmos ad=0.85p pd=5.68u as=0.85p ps=5.68u w=2.5u l=1u
X230 comparator_body_0.outx.t3 comparator_body_0.m3_m4_diff_0.n1.t68 a_n5385_11394# AVDD sg13_hv_pmos ad=0.85p pd=5.68u as=0.85p ps=5.68u w=2.5u l=1u
X231 AVSS.t54 ibias.t20 a_n105_n986# AVSS.t40 sg13_hv_nmos ad=0.85p pd=5.68u as=0.85p ps=5.68u w=2.5u l=1u
X232 a_n1005_2820# ibias.t38 AVSS.t39 AVSS.t38 sg13_hv_nmos ad=0.85p pd=5.68u as=0.85p ps=5.68u w=2.5u l=1u
X233 AVDD comparator_body_0.m3_m4_diff_0.n1.t56 a_n5385_n1956# AVDD sg13_hv_pmos ad=0.85p pd=5.68u as=0.85p ps=5.68u w=2.5u l=1u
X234 a_n1005_6390# ibias.t52 AVSS.t21 AVSS.t2 sg13_hv_nmos ad=0.85p pd=5.68u as=0.85p ps=5.68u w=2.5u l=1u
X235 a_n3314_7684# inn comparator_body_0.mref_m5_diff_0.tail.t78 AVSS.t78 sg13_hv_nmos ad=0.85p pd=5.68u as=0.85p ps=5.68u w=2.5u l=1u
X236 a_n421_11386# ibias.t40 AVSS.t6 AVSS.t4 sg13_hv_nmos ad=0.85p pd=5.68u as=0.85p ps=5.68u w=2.5u l=1u
X237 a_n3314_n5979# inn comparator_body_0.outx.t15 AVSS.t86 sg13_hv_nmos ad=0.85p pd=5.68u as=0.85p ps=5.68u w=2.5u l=1u
X238 ibias.t21 ibias.t20 a_n105_n986# AVSS.t40 sg13_hv_nmos ad=0.85p pd=5.68u as=0.85p ps=5.68u w=2.5u l=1u
X239 a_n6285_1614# comparator_body_0.m3_m4_diff_0.n1.t42 comparator_body_0.outx.t48 AVDD sg13_hv_pmos ad=0.85p pd=5.68u as=0.85p ps=5.68u w=2.5u l=1u
X240 a_n1005_n3602# ibias.t34 ibias.t35 AVSS.t38 sg13_hv_nmos ad=0.85p pd=5.68u as=0.85p ps=5.68u w=2.5u l=1u
X241 a_n6869_9014# comparator_body_0.m3_m4_diff_0.n1.t64 comparator_body_0.m3_m4_diff_0.n1.t65 AVDD sg13_hv_pmos ad=0.85p pd=5.68u as=0.85p ps=5.68u w=2.5u l=1u
X242 comparator_body_0.mref_m5_diff_0.tail.t8 ibias.t58 a_479_6390# AVSS.t8 sg13_hv_nmos ad=0.85p pd=5.68u as=0.85p ps=5.68u w=2.5u l=1u
X243 a_n3314_n589# inn comparator_body_0.mref_m5_diff_0.tail.t82 AVSS.t86 sg13_hv_nmos ad=0.85p pd=5.68u as=0.85p ps=5.68u w=2.5u l=1u
X244 a_n421_7816# ibias.t28 ibias.t29 AVSS.t4 sg13_hv_nmos ad=0.85p pd=5.68u as=0.85p ps=5.68u w=2.5u l=1u
X245 a_n3314_3553# inp comparator_body_0.mref_m5_diff_0.tail.t52 AVSS.t82 sg13_hv_nmos ad=0.85p pd=5.68u as=0.85p ps=5.68u w=2.5u l=1u
X246 comparator_body_0.outx.t61 comparator_body_0.m3_m4_diff_0.n1.t84 a_n5385_n5656# AVDD sg13_hv_pmos ad=0.85p pd=5.68u as=0.85p ps=5.68u w=2.5u l=1u
X247 a_n6285_n1956# comparator_body_0.m3_m4_diff_0.n1.t60 comparator_body_0.m3_m4_diff_0.n1.t61 AVDD sg13_hv_pmos ad=0.85p pd=5.68u as=0.85p ps=5.68u w=2.5u l=1u
X248 a_n6869_9014# comparator_body_0.m3_m4_diff_0.n1.t64 AVDD AVDD sg13_hv_pmos ad=0.85p pd=5.68u as=0.85p ps=5.68u w=2.5u l=1u
X249 a_n1005_2820# ibias.t38 comparator_body_0.mref_m5_diff_0.tail.t18 AVSS.t28 sg13_hv_nmos ad=0.85p pd=5.68u as=0.85p ps=5.68u w=2.5u l=1u
X250 a_n3314_n8459# inn comparator_body_0.mref_m5_diff_0.tail.t67 AVSS.t86 sg13_hv_nmos ad=0.85p pd=5.68u as=0.85p ps=5.68u w=2.5u l=1u
X251 AVSS.t62 ibias.t46 a_n105_n3602# AVSS.t40 sg13_hv_nmos ad=0.85p pd=5.68u as=0.85p ps=5.68u w=2.5u l=1u
X252 ibias.t55 ibias.t54 a_n105_11386# AVSS.t0 sg13_hv_nmos ad=0.85p pd=5.68u as=0.85p ps=5.68u w=2.5u l=1u
X253 a_n3897_6033# inn comparator_body_0.outx.t37 AVSS.t94 sg13_hv_nmos ad=0.85p pd=5.68u as=0.85p ps=5.68u w=2.5u l=1u
X254 comparator_body_0.outx.t2 comparator_body_0.m3_m4_diff_0.n1.t78 a_n5385_4124# AVDD sg13_hv_pmos ad=0.85p pd=5.68u as=0.85p ps=5.68u w=2.5u l=1u
X255 a_n3314_10164# inn comparator_body_0.outx.t30 AVSS.t78 sg13_hv_nmos ad=0.85p pd=5.68u as=0.85p ps=5.68u w=2.5u l=1u
X256 a_n6285_1614# comparator_body_0.m3_m4_diff_0.n1.t42 AVDD AVDD sg13_hv_pmos ad=0.85p pd=5.68u as=0.85p ps=5.68u w=2.5u l=1u
X257 a_n421_n2176# ibias.t4 ibias.t5 AVSS.t36 sg13_hv_nmos ad=0.85p pd=5.68u as=0.85p ps=5.68u w=2.5u l=1u
X258 AVDD comparator_body_0.m3_m4_diff_0.n1.t78 a_n5385_4124# AVDD sg13_hv_pmos ad=0.85p pd=5.68u as=0.85p ps=5.68u w=2.5u l=1u
X259 ibias.t23 ibias.t22 a_n105_1394# AVSS.t40 sg13_hv_nmos ad=0.85p pd=5.68u as=0.85p ps=5.68u w=2.5u l=1u
X260 comparator_body_0.mref_m5_diff_0.tail.t75 inn a_n2415_4793# AVSS.t79 sg13_hv_nmos ad=0.85p pd=5.68u as=0.85p ps=5.68u w=2.5u l=1u
X261 a_n1005_10196# ibias.t24 AVSS.t10 AVSS.t2 sg13_hv_nmos ad=0.85p pd=5.68u as=0.85p ps=5.68u w=2.5u l=1u
X262 AVSS.t73 ibias.t36 a_479_n7172# AVSS.t43 sg13_hv_nmos ad=0.85p pd=5.68u as=0.85p ps=5.68u w=2.5u l=1u
X263 AVDD comparator_body_0.m3_m4_diff_0.n1.t66 a_n5969_5314# AVDD sg13_hv_pmos ad=0.85p pd=5.68u as=0.85p ps=5.68u w=2.5u l=1u
X264 a_n421_6390# ibias.t60 comparator_body_0.mref_m5_diff_0.tail.t6 AVSS.t4 sg13_hv_nmos ad=0.85p pd=5.68u as=0.85p ps=5.68u w=2.5u l=1u
X265 comparator_body_0.mref_m5_diff_0.tail.t10 ibias.t36 a_479_n5982# AVSS.t43 sg13_hv_nmos ad=0.85p pd=5.68u as=0.85p ps=5.68u w=2.5u l=1u
X266 a_n3314_6033# inp comparator_body_0.mref_m5_diff_0.tail.t51 AVSS.t78 sg13_hv_nmos ad=0.85p pd=5.68u as=0.85p ps=5.68u w=2.5u l=1u
X267 comparator_body_0.outx.t1 comparator_body_0.m3_m4_diff_0.n1.t66 a_n5969_5314# AVDD sg13_hv_pmos ad=0.85p pd=5.68u as=0.85p ps=5.68u w=2.5u l=1u
X268 AVDD comparator_body_0.m3_m4_diff_0.n1.t68 a_n5385_10204# AVDD sg13_hv_pmos ad=0.85p pd=5.68u as=0.85p ps=5.68u w=2.5u l=1u
X269 a_n421_n2176# ibias.t4 AVSS.t56 AVSS.t36 sg13_hv_nmos ad=0.85p pd=5.68u as=0.85p ps=5.68u w=2.5u l=1u
X270 ibias.t47 ibias.t46 a_n105_n3602# AVSS.t40 sg13_hv_nmos ad=0.85p pd=5.68u as=0.85p ps=5.68u w=2.5u l=1u
X271 comparator_body_0.m3_m4_diff_0.n1.t69 comparator_body_0.m3_m4_diff_0.n1.t68 a_n5385_10204# AVDD sg13_hv_pmos ad=0.85p pd=5.68u as=0.85p ps=5.68u w=2.5u l=1u
X272 a_n6869_n6846# comparator_body_0.m3_m4_diff_0.n1.t80 comparator_body_0.outx.t60 AVDD sg13_hv_pmos ad=0.85p pd=5.68u as=0.85p ps=5.68u w=2.5u l=1u
X273 a_n6869_n766# comparator_body_0.m3_m4_diff_0.n1.t36 AVDD AVDD sg13_hv_pmos ad=0.85p pd=5.68u as=0.85p ps=5.68u w=2.5u l=1u
X274 a_n6285_n4466# comparator_body_0.m3_m4_diff_0.n1.t88 AVDD AVDD sg13_hv_pmos ad=0.85p pd=5.68u as=0.85p ps=5.68u w=2.5u l=1u
X275 AVSS.t27 ibias.t58 a_479_5200# AVSS.t8 sg13_hv_nmos ad=0.85p pd=5.68u as=0.85p ps=5.68u w=2.5u l=1u
X276 ibias.t49 ibias.t48 a_479_10196# AVSS.t8 sg13_hv_nmos ad=0.85p pd=5.68u as=0.85p ps=5.68u w=2.5u l=1u
X277 a_n3314_n7219# inp comparator_body_0.m3_m4_diff_0.n1.t11 AVSS.t86 sg13_hv_nmos ad=0.85p pd=5.68u as=0.85p ps=5.68u w=2.5u l=1u
X278 a_n3314_n4739# inp comparator_body_0.m3_m4_diff_0.n1.t9 AVSS.t86 sg13_hv_nmos ad=0.85p pd=5.68u as=0.85p ps=5.68u w=2.5u l=1u
X279 a_3287_3330# comparator_body_0.outx.t67 AVDD AVDD sg13_hv_pmos ad=0.85p pd=5.68u as=0.85p ps=5.68u w=2.5u l=1u
X280 comparator_body_0.m3_m4_diff_0.n1.t83 comparator_body_0.m3_m4_diff_0.n1.t82 a_n5385_n4466# AVDD sg13_hv_pmos ad=0.85p pd=5.68u as=0.85p ps=5.68u w=2.5u l=1u
X281 a_n6285_4124# comparator_body_0.m3_m4_diff_0.n1.t32 comparator_body_0.outx.t8 AVDD sg13_hv_pmos ad=0.85p pd=5.68u as=0.85p ps=5.68u w=2.5u l=1u
X282 ibias.t59 ibias.t58 a_479_5200# AVSS.t8 sg13_hv_nmos ad=0.85p pd=5.68u as=0.85p ps=5.68u w=2.5u l=1u
X283 ibias.t57 ibias.t56 a_n105_9006# AVSS.t0 sg13_hv_nmos ad=0.85p pd=5.68u as=0.85p ps=5.68u w=2.5u l=1u
X284 a_5717_1513# a_2989_2085# AVSS.t93 AVSS.t91 sg13_hv_nmos ad=0.85p pd=5.68u as=0.85p ps=5.68u w=2.5u l=1u
X285 AVSS.t12 ibias.t54 a_n105_10196# AVSS.t0 sg13_hv_nmos ad=0.85p pd=5.68u as=0.85p ps=5.68u w=2.5u l=1u
X286 a_n6285_4124# comparator_body_0.m3_m4_diff_0.n1.t32 AVDD AVDD sg13_hv_pmos ad=0.85p pd=5.68u as=0.85p ps=5.68u w=2.5u l=1u
X287 AVSS.t16 ibias.t56 a_n105_9006# AVSS.t0 sg13_hv_nmos ad=0.85p pd=5.68u as=0.85p ps=5.68u w=2.5u l=1u
X288 a_n3314_n3069# inn comparator_body_0.mref_m5_diff_0.tail.t69 AVSS.t86 sg13_hv_nmos ad=0.85p pd=5.68u as=0.85p ps=5.68u w=2.5u l=1u
X289 comparator_body_0.m3_m4_diff_0.n1.t79 comparator_body_0.m3_m4_diff_0.n1.t78 a_n5385_2934# AVDD sg13_hv_pmos ad=0.85p pd=5.68u as=0.85p ps=5.68u w=2.5u l=1u
X290 a_n3314_4793# inn comparator_body_0.mref_m5_diff_0.tail.t79 AVSS.t78 sg13_hv_nmos ad=0.85p pd=5.68u as=0.85p ps=5.68u w=2.5u l=1u
X291 a_n6869_11394# comparator_body_0.m3_m4_diff_0.n1.t46 AVDD AVDD sg13_hv_pmos ad=0.85p pd=5.68u as=0.85p ps=5.68u w=2.5u l=1u
X292 a_n1005_7816# ibias.t26 AVSS.t18 AVSS.t2 sg13_hv_nmos ad=0.85p pd=5.68u as=0.85p ps=5.68u w=2.5u l=1u
X293 a_n6285_424# comparator_body_0.m3_m4_diff_0.n1.t42 AVDD AVDD sg13_hv_pmos ad=0.85p pd=5.68u as=0.85p ps=5.68u w=2.5u l=1u
X294 AVDD comparator_body_0.m3_m4_diff_0.n1.t44 a_n5969_7824# AVDD sg13_hv_pmos ad=0.85p pd=5.68u as=0.85p ps=5.68u w=2.5u l=1u
X295 a_n3314_11404# inp comparator_body_0.m3_m4_diff_0.n1.t14 AVSS.t78 sg13_hv_nmos ad=0.85p pd=5.68u as=0.85p ps=5.68u w=2.5u l=1u
X296 a_n421_5200# ibias.t60 AVSS.t26 AVSS.t4 sg13_hv_nmos ad=0.85p pd=5.68u as=0.85p ps=5.68u w=2.5u l=1u
X297 a_5717_1513# a_2989_2085# out AVSS.t91 sg13_hv_nmos ad=0.85p pd=5.68u as=0.85p ps=5.68u w=2.5u l=1u
X298 a_5747_3330# a_2989_2085# out AVDD1V2 sg13_hv_pmos ad=0.85p pd=5.68u as=0.85p ps=5.68u w=2.5u l=1u
X299 a_n6285_424# comparator_body_0.m3_m4_diff_0.n1.t42 comparator_body_0.m3_m4_diff_0.n1.t43 AVDD sg13_hv_pmos ad=0.85p pd=5.68u as=0.85p ps=5.68u w=2.5u l=1u
X300 a_n1005_n7172# ibias.t2 comparator_body_0.mref_m5_diff_0.tail.t31 AVSS.t38 sg13_hv_nmos ad=0.85p pd=5.68u as=0.85p ps=5.68u w=2.5u l=1u
X301 comparator_body_0.outx.t5 comparator_body_0.m3_m4_diff_0.n1.t92 a_n5969_n6846# AVDD sg13_hv_pmos ad=0.85p pd=5.68u as=0.85p ps=5.68u w=2.5u l=1u
X302 a_n3314_11404# inp comparator_body_0.mref_m5_diff_0.tail.t46 AVSS.t78 sg13_hv_nmos ad=0.85p pd=5.68u as=0.85p ps=5.68u w=2.5u l=1u
X303 a_n421_5200# ibias.t60 ibias.t61 AVSS.t4 sg13_hv_nmos ad=0.85p pd=5.68u as=0.85p ps=5.68u w=2.5u l=1u
X304 comparator_body_0.m3_m4_diff_0.n1.t71 comparator_body_0.m3_m4_diff_0.n1.t70 a_n5969_n766# AVDD sg13_hv_pmos ad=0.85p pd=5.68u as=0.85p ps=5.68u w=2.5u l=1u
X305 a_n421_n4792# ibias.t6 ibias.t7 AVSS.t36 sg13_hv_nmos ad=0.85p pd=5.68u as=0.85p ps=5.68u w=2.5u l=1u
X306 a_n6869_n5656# comparator_body_0.m3_m4_diff_0.n1.t80 AVDD AVDD sg13_hv_pmos ad=0.85p pd=5.68u as=0.85p ps=5.68u w=2.5u l=1u
X307 a_n1005_7816# ibias.t26 comparator_body_0.mref_m5_diff_0.tail.t25 AVSS.t2 sg13_hv_nmos ad=0.85p pd=5.68u as=0.85p ps=5.68u w=2.5u l=1u
X308 comparator_body_0.outx.t6 comparator_body_0.m3_m4_diff_0.n1.t44 a_n5969_7824# AVDD sg13_hv_pmos ad=0.85p pd=5.68u as=0.85p ps=5.68u w=2.5u l=1u
X309 a_n3898_n7219# inn comparator_body_0.outx.t14 AVSS.t84 sg13_hv_nmos ad=0.85p pd=5.68u as=0.85p ps=5.68u w=2.5u l=1u
X310 a_n6285_n6846# comparator_body_0.m3_m4_diff_0.n1.t94 AVDD AVDD sg13_hv_pmos ad=0.85p pd=5.68u as=0.85p ps=5.68u w=2.5u l=1u
X311 a_n6285_n3276# comparator_body_0.m3_m4_diff_0.n1.t88 AVDD AVDD sg13_hv_pmos ad=0.85p pd=5.68u as=0.85p ps=5.68u w=2.5u l=1u
X312 a_n1005_204# ibias.t32 AVSS.t48 AVSS.t38 sg13_hv_nmos ad=0.85p pd=5.68u as=0.85p ps=5.68u w=2.5u l=1u
X313 a_n3314_n1829# inp comparator_body_0.m3_m4_diff_0.n1.t3 AVSS.t86 sg13_hv_nmos ad=0.85p pd=5.68u as=0.85p ps=5.68u w=2.5u l=1u
X314 a_n6285_2934# comparator_body_0.m3_m4_diff_0.n1.t32 comparator_body_0.m3_m4_diff_0.n1.t33 AVDD sg13_hv_pmos ad=0.85p pd=5.68u as=0.85p ps=5.68u w=2.5u l=1u
X315 AVDD comparator_body_0.m3_m4_diff_0.n1.t62 a_n5969_11394# AVDD sg13_hv_pmos ad=0.85p pd=5.68u as=0.85p ps=5.68u w=2.5u l=1u
X316 a_n6869_5314# comparator_body_0.m3_m4_diff_0.n1.t74 AVDD AVDD sg13_hv_pmos ad=0.85p pd=5.68u as=0.85p ps=5.68u w=2.5u l=1u
X317 a_n1005_204# ibias.t32 comparator_body_0.mref_m5_diff_0.tail.t7 AVSS.t38 sg13_hv_nmos ad=0.85p pd=5.68u as=0.85p ps=5.68u w=2.5u l=1u
X318 a_n3314_n8459# inn comparator_body_0.outx.t16 AVSS.t86 sg13_hv_nmos ad=0.85p pd=5.68u as=0.85p ps=5.68u w=2.5u l=1u
X319 comparator_body_0.mref_m5_diff_0.tail.t54 inp a_n2415_651# AVSS.t87 sg13_hv_nmos ad=0.85p pd=5.68u as=0.85p ps=5.68u w=2.5u l=1u
X320 AVDD comparator_body_0.m3_m4_diff_0.n1.t48 a_n5969_424# AVDD sg13_hv_pmos ad=0.85p pd=5.68u as=0.85p ps=5.68u w=2.5u l=1u
X321 comparator_body_0.mref_m5_diff_0.tail.t4 ibias.t0 a_n105_n7172# AVSS.t40 sg13_hv_nmos ad=0.85p pd=5.68u as=0.85p ps=5.68u w=2.5u l=1u
X322 a_n6869_5314# comparator_body_0.m3_m4_diff_0.n1.t74 comparator_body_0.outx.t9 AVDD sg13_hv_pmos ad=0.85p pd=5.68u as=0.85p ps=5.68u w=2.5u l=1u
X323 comparator_body_0.m3_m4_diff_0.n1.t57 comparator_body_0.m3_m4_diff_0.n1.t56 a_n5385_n1956# AVDD sg13_hv_pmos ad=0.85p pd=5.68u as=0.85p ps=5.68u w=2.5u l=1u
X324 a_n1005_6390# ibias.t52 ibias.t53 AVSS.t2 sg13_hv_nmos ad=0.85p pd=5.68u as=0.85p ps=5.68u w=2.5u l=1u
X325 a_n421_11386# ibias.t40 comparator_body_0.mref_m5_diff_0.tail.t24 AVSS.t4 sg13_hv_nmos ad=0.85p pd=5.68u as=0.85p ps=5.68u w=2.5u l=1u
X326 a_n421_n3602# ibias.t6 AVSS.t61 AVSS.t36 sg13_hv_nmos ad=0.85p pd=5.68u as=0.85p ps=5.68u w=2.5u l=1u
X327 a_n6285_n3276# comparator_body_0.m3_m4_diff_0.n1.t88 comparator_body_0.outx.t47 AVDD sg13_hv_pmos ad=0.85p pd=5.68u as=0.85p ps=5.68u w=2.5u l=1u
X328 a_n3898_n589# inp comparator_body_0.mref_m5_diff_0.tail.t63 AVSS.t84 sg13_hv_nmos ad=0.85p pd=5.68u as=0.85p ps=5.68u w=2.5u l=1u
X329 comparator_body_0.outx.t62 comparator_body_0.m3_m4_diff_0.n1.t48 a_n5969_424# AVDD sg13_hv_pmos ad=0.85p pd=5.68u as=0.85p ps=5.68u w=2.5u l=1u
X330 AVSS.t41 ibias.t12 a_n105_2820# AVSS.t40 sg13_hv_nmos ad=0.85p pd=5.68u as=0.85p ps=5.68u w=2.5u l=1u
X331 a_n3898_n1829# inn comparator_body_0.outx.t43 AVSS.t84 sg13_hv_nmos ad=0.85p pd=5.68u as=0.85p ps=5.68u w=2.5u l=1u
X332 AVSS.t1 ibias.t14 a_n105_6390# AVSS.t0 sg13_hv_nmos ad=0.85p pd=5.68u as=0.85p ps=5.68u w=2.5u l=1u
X333 AVDD comparator_body_0.m3_m4_diff_0.n1.t92 a_n5969_n5656# AVDD sg13_hv_pmos ad=0.85p pd=5.68u as=0.85p ps=5.68u w=2.5u l=1u
X334 a_n1005_n7172# ibias.t2 AVSS.t72 AVSS.t38 sg13_hv_nmos ad=0.85p pd=5.68u as=0.85p ps=5.68u w=2.5u l=1u
X335 a_n1005_n5982# ibias.t2 ibias.t3 AVSS.t38 sg13_hv_nmos ad=0.85p pd=5.68u as=0.85p ps=5.68u w=2.5u l=1u
X336 a_n3898_n5979# inp comparator_body_0.m3_m4_diff_0.n1.t4 AVSS.t84 sg13_hv_nmos ad=0.85p pd=5.68u as=0.85p ps=5.68u w=2.5u l=1u
X337 a_n3898_n5979# inp comparator_body_0.mref_m5_diff_0.tail.t36 AVSS.t84 sg13_hv_nmos ad=0.85p pd=5.68u as=0.85p ps=5.68u w=2.5u l=1u
X338 a_n421_n3602# ibias.t6 comparator_body_0.mref_m5_diff_0.tail.t19 AVSS.t36 sg13_hv_nmos ad=0.85p pd=5.68u as=0.85p ps=5.68u w=2.5u l=1u
X339 a_n3314_10164# inn comparator_body_0.mref_m5_diff_0.tail.t81 AVSS.t78 sg13_hv_nmos ad=0.85p pd=5.68u as=0.85p ps=5.68u w=2.5u l=1u
X340 comparator_body_0.m3_m4_diff_0.n1.t49 comparator_body_0.m3_m4_diff_0.n1.t48 a_n5969_1614# AVDD sg13_hv_pmos ad=0.85p pd=5.68u as=0.85p ps=5.68u w=2.5u l=1u
X341 comparator_body_0.mref_m5_diff_0.tail.t2 ibias.t12 a_n105_2820# AVSS.t30 sg13_hv_nmos ad=0.85p pd=5.68u as=0.85p ps=5.68u w=2.5u l=1u
X342 AVSS.t47 ibias.t44 a_479_1394# AVSS.t43 sg13_hv_nmos ad=0.85p pd=5.68u as=0.85p ps=5.68u w=2.5u l=1u
X343 AVSS.t50 ibias.t22 a_n105_204# AVSS.t40 sg13_hv_nmos ad=0.85p pd=5.68u as=0.85p ps=5.68u w=2.5u l=1u
X344 a_n1005_10196# ibias.t24 comparator_body_0.mref_m5_diff_0.tail.t12 AVSS.t2 sg13_hv_nmos ad=0.85p pd=5.68u as=0.85p ps=5.68u w=2.5u l=1u
X345 comparator_body_0.mref_m5_diff_0.tail.t9 ibias.t22 a_n105_204# AVSS.t40 sg13_hv_nmos ad=0.85p pd=5.68u as=0.85p ps=5.68u w=2.5u l=1u
X346 AVDD comparator_body_0.m3_m4_diff_0.n1.t82 a_n5385_n4466# AVDD sg13_hv_pmos ad=0.85p pd=5.68u as=0.85p ps=5.68u w=2.5u l=1u
X347 a_n6869_7824# comparator_body_0.m3_m4_diff_0.n1.t64 AVDD AVDD sg13_hv_pmos ad=0.85p pd=5.68u as=0.85p ps=5.68u w=2.5u l=1u
X348 a_3257_1513# comparator_body_0.outx.t65 AVSS.t89 AVSS.t88 sg13_hv_nmos ad=0.85p pd=5.68u as=0.85p ps=5.68u w=2.5u l=1u
X349 a_n3898_n8459# inp comparator_body_0.m3_m4_diff_0.n1.t0 AVSS.t84 sg13_hv_nmos ad=0.85p pd=5.68u as=0.85p ps=5.68u w=2.5u l=1u
X350 a_n3314_n589# inn comparator_body_0.outx.t31 AVSS.t86 sg13_hv_nmos ad=0.85p pd=5.68u as=0.85p ps=5.68u w=2.5u l=1u
X351 a_n3898_10164# inp comparator_body_0.mref_m5_diff_0.tail.t53 AVSS.t80 sg13_hv_nmos ad=0.85p pd=5.68u as=0.85p ps=5.68u w=2.5u l=1u
X352 AVDD comparator_body_0.m3_m4_diff_0.n1.t48 a_n5969_1614# AVDD sg13_hv_pmos ad=0.85p pd=5.68u as=0.85p ps=5.68u w=2.5u l=1u
X353 AVSS.t75 ibias.t0 a_n105_n7172# AVSS.t40 sg13_hv_nmos ad=0.85p pd=5.68u as=0.85p ps=5.68u w=2.5u l=1u
X354 comparator_body_0.outx.t21 inn a_n3001_n4739# AVSS.t85 sg13_hv_nmos ad=0.85p pd=5.68u as=0.85p ps=5.68u w=2.5u l=1u
X355 a_n6869_424# comparator_body_0.m3_m4_diff_0.n1.t72 AVDD AVDD sg13_hv_pmos ad=0.85p pd=5.68u as=0.85p ps=5.68u w=2.5u l=1u
X356 a_n1005_5200# ibias.t52 AVSS.t24 AVSS.t2 sg13_hv_nmos ad=0.85p pd=5.68u as=0.85p ps=5.68u w=2.5u l=1u
X357 a_n421_10196# ibias.t40 AVSS.t11 AVSS.t4 sg13_hv_nmos ad=0.85p pd=5.68u as=0.85p ps=5.68u w=2.5u l=1u
X358 a_n3314_n3069# inn comparator_body_0.outx.t18 AVSS.t86 sg13_hv_nmos ad=0.85p pd=5.68u as=0.85p ps=5.68u w=2.5u l=1u
X359 AVDD comparator_body_0.m3_m4_diff_0.n1.t78 a_n5385_2934# AVDD sg13_hv_pmos ad=0.85p pd=5.68u as=0.85p ps=5.68u w=2.5u l=1u
X360 ibias.t1 ibias.t0 a_n105_n5982# AVSS.t40 sg13_hv_nmos ad=0.85p pd=5.68u as=0.85p ps=5.68u w=2.5u l=1u
X361 a_n6869_424# comparator_body_0.m3_m4_diff_0.n1.t72 comparator_body_0.outx.t0 AVDD sg13_hv_pmos ad=0.85p pd=5.68u as=0.85p ps=5.68u w=2.5u l=1u
X362 a_n1005_5200# ibias.t52 comparator_body_0.mref_m5_diff_0.tail.t22 AVSS.t2 sg13_hv_nmos ad=0.85p pd=5.68u as=0.85p ps=5.68u w=2.5u l=1u
X363 a_n6869_n766# comparator_body_0.m3_m4_diff_0.n1.t36 comparator_body_0.m3_m4_diff_0.n1.t37 AVDD sg13_hv_pmos ad=0.85p pd=5.68u as=0.85p ps=5.68u w=2.5u l=1u
X364 a_n421_1394# ibias.t16 AVSS.t42 AVSS.t36 sg13_hv_nmos ad=0.85p pd=5.68u as=0.85p ps=5.68u w=2.5u l=1u
X365 comparator_body_0.outx.t52 comparator_body_0.m3_m4_diff_0.n1.t52 a_n5385_6504# AVDD sg13_hv_pmos ad=0.85p pd=5.68u as=0.85p ps=5.68u w=2.5u l=1u
X366 a_n6869_7824# comparator_body_0.m3_m4_diff_0.n1.t64 comparator_body_0.outx.t11 AVDD sg13_hv_pmos ad=0.85p pd=5.68u as=0.85p ps=5.68u w=2.5u l=1u
X367 AVSS.t71 ibias.t36 a_479_n5982# AVSS.t43 sg13_hv_nmos ad=0.85p pd=5.68u as=0.85p ps=5.68u w=2.5u l=1u
X368 a_3257_1513# comparator_body_0.outx.t65 a_2989_2085# AVSS.t88 sg13_hv_nmos ad=0.85p pd=5.68u as=0.85p ps=5.68u w=2.5u l=1u
X369 a_n3897_651# inn comparator_body_0.outx.t40 AVSS.t97 sg13_hv_nmos ad=0.85p pd=5.68u as=0.85p ps=5.68u w=2.5u l=1u
X370 a_3287_3330# comparator_body_0.outx.t67 a_2989_2085# AVDD sg13_hv_pmos ad=0.85p pd=5.68u as=0.85p ps=5.68u w=2.5u l=1u
X371 comparator_body_0.mref_m5_diff_0.tail.t20 ibias.t54 a_n105_10196# AVSS.t0 sg13_hv_nmos ad=0.85p pd=5.68u as=0.85p ps=5.68u w=2.5u l=1u
X372 comparator_body_0.outx.t22 inn a_n3001_n7219# AVSS.t85 sg13_hv_nmos ad=0.85p pd=5.68u as=0.85p ps=5.68u w=2.5u l=1u
X373 AVDD comparator_body_0.m3_m4_diff_0.n1.t52 a_n5385_6504# AVDD sg13_hv_pmos ad=0.85p pd=5.68u as=0.85p ps=5.68u w=2.5u l=1u
X374 a_n6869_11394# comparator_body_0.m3_m4_diff_0.n1.t46 comparator_body_0.m3_m4_diff_0.n1.t47 AVDD sg13_hv_pmos ad=0.85p pd=5.68u as=0.85p ps=5.68u w=2.5u l=1u
X375 a_n6869_n1956# comparator_body_0.m3_m4_diff_0.n1.t36 AVDD AVDD sg13_hv_pmos ad=0.85p pd=5.68u as=0.85p ps=5.68u w=2.5u l=1u
X376 a_n3898_n7219# inn comparator_body_0.mref_m5_diff_0.tail.t65 AVSS.t84 sg13_hv_nmos ad=0.85p pd=5.68u as=0.85p ps=5.68u w=2.5u l=1u
X377 comparator_body_0.m3_m4_diff_0.n1.t87 comparator_body_0.m3_m4_diff_0.n1.t86 a_n5969_4124# AVDD sg13_hv_pmos ad=0.85p pd=5.68u as=0.85p ps=5.68u w=2.5u l=1u
X378 AVSS.t67 ibias.t8 a_479_n4792# AVSS.t43 sg13_hv_nmos ad=0.85p pd=5.68u as=0.85p ps=5.68u w=2.5u l=1u
X379 AVDD comparator_body_0.m3_m4_diff_0.n1.t86 a_n5969_4124# AVDD sg13_hv_pmos ad=0.85p pd=5.68u as=0.85p ps=5.68u w=2.5u l=1u
X380 AVDD comparator_body_0.m3_m4_diff_0.n1.t82 a_n5385_n3276# AVDD sg13_hv_pmos ad=0.85p pd=5.68u as=0.85p ps=5.68u w=2.5u l=1u
X381 AVDD comparator_body_0.m3_m4_diff_0.n1.t84 a_n5385_n6846# AVDD sg13_hv_pmos ad=0.85p pd=5.68u as=0.85p ps=5.68u w=2.5u l=1u
X382 a_n6285_2934# comparator_body_0.m3_m4_diff_0.n1.t32 AVDD AVDD sg13_hv_pmos ad=0.85p pd=5.68u as=0.85p ps=5.68u w=2.5u l=1u
X383 AVSS.t19 ibias.t56 a_n105_7816# AVSS.t0 sg13_hv_nmos ad=0.85p pd=5.68u as=0.85p ps=5.68u w=2.5u l=1u
X384 a_n3898_n3069# inp comparator_body_0.m3_m4_diff_0.n1.t5 AVSS.t84 sg13_hv_nmos ad=0.85p pd=5.68u as=0.85p ps=5.68u w=2.5u l=1u
X385 a_n6869_n5656# comparator_body_0.m3_m4_diff_0.n1.t80 comparator_body_0.m3_m4_diff_0.n1.t81 AVDD sg13_hv_pmos ad=0.85p pd=5.68u as=0.85p ps=5.68u w=2.5u l=1u
X386 a_n6285_6504# comparator_body_0.m3_m4_diff_0.n1.t58 comparator_body_0.outx.t59 AVDD sg13_hv_pmos ad=0.85p pd=5.68u as=0.85p ps=5.68u w=2.5u l=1u
X387 comparator_body_0.outx.t13 inn a_n3001_n1829# AVSS.t85 sg13_hv_nmos ad=0.85p pd=5.68u as=0.85p ps=5.68u w=2.5u l=1u
X388 comparator_body_0.mref_m5_diff_0.tail.t40 inp a_n2415_n4739# AVSS.t87 sg13_hv_nmos ad=0.85p pd=5.68u as=0.85p ps=5.68u w=2.5u l=1u
X389 a_n421_n7172# ibias.t62 ibias.t63 AVSS.t36 sg13_hv_nmos ad=0.85p pd=5.68u as=0.85p ps=5.68u w=2.5u l=1u
X390 a_n3897_n4739# inn comparator_body_0.outx.t19 AVSS.t97 sg13_hv_nmos ad=0.85p pd=5.68u as=0.85p ps=5.68u w=2.5u l=1u
X391 comparator_body_0.mref_m5_diff_0.tail.t13 ibias.t30 a_479_4010# AVSS.t31 sg13_hv_nmos ad=0.85p pd=5.68u as=0.85p ps=5.68u w=2.5u l=1u
X392 comparator_body_0.m3_m4_diff_0.n1.t7 inp a_n3001_n5979# AVSS.t85 sg13_hv_nmos ad=0.85p pd=5.68u as=0.85p ps=5.68u w=2.5u l=1u
X393 a_n6869_1614# comparator_body_0.m3_m4_diff_0.n1.t72 comparator_body_0.m3_m4_diff_0.n1.t73 AVDD sg13_hv_pmos ad=0.85p pd=5.68u as=0.85p ps=5.68u w=2.5u l=1u
X394 a_5163_3330# a_2989_2085# AVDD1V2 AVDD1V2 sg13_hv_pmos ad=0.85p pd=5.68u as=0.85p ps=5.68u w=2.5u l=1u
X395 a_n6285_n6846# comparator_body_0.m3_m4_diff_0.n1.t94 comparator_body_0.m3_m4_diff_0.n1.t95 AVDD sg13_hv_pmos ad=0.85p pd=5.68u as=0.85p ps=5.68u w=2.5u l=1u
X396 comparator_body_0.outx.t45 comparator_body_0.m3_m4_diff_0.n1.t82 a_n5385_n3276# AVDD sg13_hv_pmos ad=0.85p pd=5.68u as=0.85p ps=5.68u w=2.5u l=1u
X397 AVSS.t35 ibias.t30 a_479_4010# AVSS.t31 sg13_hv_nmos ad=0.85p pd=5.68u as=0.85p ps=5.68u w=2.5u l=1u
X398 comparator_body_0.mref_m5_diff_0.tail.t17 ibias.t56 a_n105_7816# AVSS.t0 sg13_hv_nmos ad=0.85p pd=5.68u as=0.85p ps=5.68u w=2.5u l=1u
X399 comparator_body_0.mref_m5_diff_0.tail.t39 inp a_n3001_n5979# AVSS.t85 sg13_hv_nmos ad=0.85p pd=5.68u as=0.85p ps=5.68u w=2.5u l=1u
R0 ibias ibias.n94 7.98298
R1 ibias.t54 ibias.n46 2.19376
R2 ibias.t14 ibias.n45 2.21734
R3 ibias.t22 ibias.n44 2.21734
R4 ibias.n49 ibias.n86 6.88138
R5 ibias.n94 ibias.n34 6.0005
R6 ibias.t3 ibias.n63 6.0005
R7 ibias.n11 ibias.n91 6.0005
R8 ibias.n92 ibias.n30 6.0005
R9 ibias.n69 ibias.n93 6.0005
R10 ibias.n83 ibias.n82 6.0005
R11 ibias.n84 ibias.n42 6.0005
R12 ibias.n80 ibias.n79 6.0005
R13 ibias.n86 ibias.n85 6.0005
R14 ibias.n50 ibias.n36 0.572908
R15 ibias.t40 ibias.n50 4.96805
R16 ibias.n48 ibias.n46 0.573518
R17 ibias.n48 ibias.t48 4.96805
R18 ibias.n62 ibias.t26 4.96805
R19 ibias.n53 ibias.t28 5.06482
R20 ibias.n53 ibias.t56 4.96805
R21 ibias.n62 ibias.t52 4.96805
R22 ibias.n62 ibias.t60 4.96805
R23 ibias.n53 ibias.n45 0.579673
R24 ibias.n4 ibias.t58 2.12712
R25 ibias.n51 ibias.t38 4.96805
R26 ibias.n52 ibias.t10 5.06482
R27 ibias.t12 ibias.n52 4.96805
R28 ibias.t32 ibias.n51 4.96805
R29 ibias.n51 ibias.t16 4.96805
R30 ibias.n52 ibias.n44 0.579673
R31 ibias.n7 ibias.t44 2.12712
R32 ibias.n30 ibias.t18 4.96805
R33 ibias.t20 ibias.n30 4.96805
R34 ibias.n30 ibias.t6 5.06482
R35 ibias.n30 ibias.t46 5.06482
R36 ibias.n30 ibias.n9 1.45552
R37 ibias.n41 ibias.t2 4.96805
R38 ibias.n14 ibias.t0 2.18956
R39 ibias.n47 ibias.t36 4.96805
R40 ibias.n36 ibias.t24 2.19672
R41 ibias.n42 ibias.t52 4.95855
R42 ibias.n37 ibias.t32 4.95855
R43 ibias.n58 ibias.t50 2.13398
R44 ibias.t30 ibias.n57 2.13398
R45 ibias.t42 ibias.n55 2.13398
R46 ibias.t37 ibias.t36 4.95754
R47 ibias.t28 ibias.n20 4.95753
R48 ibias.n22 ibias.t10 4.95753
R49 ibias.n61 ibias.t4 2.19647
R50 ibias.n60 ibias.t62 2.19647
R51 ibias.t47 ibias.t46 4.9466
R52 ibias.t56 ibias.n18 4.92968
R53 ibias.t26 ibias.n20 4.92968
R54 ibias.n22 ibias.t38 4.92968
R55 ibias.n27 ibias.t12 4.92968
R56 ibias.n28 ibias.t18 4.92968
R57 ibias.n33 ibias.t20 4.92968
R58 ibias.t63 ibias.t2 4.92968
R59 ibias.n13 ibias.n14 0.569955
R60 ibias.n17 ibias.t40 4.92968
R61 ibias.n0 ibias.t48 4.92968
R62 ibias.t60 ibias.n24 4.92968
R63 ibias.n3 ibias.n4 0.694361
R64 ibias.t16 ibias.n29 4.92968
R65 ibias.n7 ibias.n6 0.694361
R66 ibias.t35 ibias.t6 4.92968
R67 ibias.t8 ibias.n9 2.12712
R68 ibias.n0 ibias.t55 2.56873
R69 ibias.n3 ibias.t15 2.56873
R70 ibias.n6 ibias.t23 2.56873
R71 ibias.n59 ibias.t51 2.53664
R72 ibias.n64 ibias.t57 2.53664
R73 ibias.n20 ibias.t29 2.53664
R74 ibias.n66 ibias.t27 2.53664
R75 ibias.n67 ibias.t39 2.53664
R76 ibias.n56 ibias.t31 2.53664
R77 ibias.n75 ibias.t13 2.53664
R78 ibias.n22 ibias.t11 2.53664
R79 ibias.n70 ibias.t19 2.53664
R80 ibias.n32 ibias.t43 2.53664
R81 ibias.n78 ibias.t21 2.53664
R82 ibias.n28 ibias.t5 2.53664
R83 ibias.n93 ibias.n90 2.53314
R84 ibias.n72 ibias.t41 2.52538
R85 ibias.n65 ibias.t49 2.52538
R86 ibias.n74 ibias.t61 2.52538
R87 ibias.n68 ibias.t59 2.52538
R88 ibias.n77 ibias.t17 2.52538
R89 ibias.n71 ibias.t45 2.52538
R90 ibias.n16 ibias.t25 2.52299
R91 ibias.n42 ibias.t53 2.52299
R92 ibias.n37 ibias.t33 2.52299
R93 ibias.n84 ibias.n82 2.38882
R94 ibias.n79 ibias.n84 2.15738
R95 ibias.n50 ibias.n48 1.93146
R96 ibias.n90 ibias.n82 1.82298
R97 ibias.n86 ibias.n79 1.65402
R98 ibias.n48 ibias.n2 0.490555
R99 ibias.n59 ibias.n58 0.696597
R100 ibias.n56 ibias.n57 0.696597
R101 ibias.n32 ibias.n55 0.696597
R102 ibias.t47 ibias.n9 0.694361
R103 ibias.n54 ibias.t37 0.431997
R104 ibias.n21 ibias.n62 0.462804
R105 ibias.n30 ibias.n69 1.61796
R106 ibias.n51 ibias.n23 0.460837
R107 ibias.n92 ibias.n91 1.45426
R108 ibias.t63 ibias.n34 1.41848
R109 ibias.n43 ibias.n81 0.449131
R110 ibias.n78 ibias.n8 0.376415
R111 ibias.n39 ibias.n70 0.44795
R112 ibias.n75 ibias.n5 0.376415
R113 ibias.n74 ibias.n67 1.36629
R114 ibias.n1 ibias.n64 0.376415
R115 ibias.n30 ibias.n55 1.36397
R116 ibias.n2 ibias.n0 0.517319
R117 ibias.n24 ibias.n3 1.3625
R118 ibias.n6 ibias.n29 1.3625
R119 ibias.n93 ibias.n92 1.33722
R120 ibias.n94 ibias.n63 1.3293
R121 ibias.n65 ibias.n59 1.3095
R122 ibias.n20 ibias.n72 1.3095
R123 ibias.n88 ibias.n87 1.3095
R124 ibias.n64 ibias.n18 1.3095
R125 ibias.n68 ibias.n56 1.3095
R126 ibias.n74 ibias.n22 1.3095
R127 ibias.n83 ibias.n67 1.3095
R128 ibias.n73 ibias.n25 1.3095
R129 ibias.n27 ibias.n75 1.3095
R130 ibias.n71 ibias.n32 1.3095
R131 ibias.n77 ibias.n28 1.3095
R132 ibias.n70 ibias.n69 1.3095
R133 ibias.n76 ibias.n89 1.3095
R134 ibias.n33 ibias.n78 1.3095
R135 ibias.t37 ibias.t9 1.3095
R136 ibias.t7 ibias.t63 1.3095
R137 ibias.n15 ibias.n13 0.458635
R138 ibias.n72 ibias.n16 1.2941
R139 ibias.n87 ibias.n17 1.2941
R140 ibias.n1 ibias.n0 0.563614
R141 ibias.n81 ibias.n74 1.2941
R142 ibias.n67 ibias.n42 1.2941
R143 ibias.n73 ibias.n24 1.2941
R144 ibias.n5 ibias.n3 0.563614
R145 ibias.n39 ibias.n77 0.44795
R146 ibias.n37 ibias.n39 0.424325
R147 ibias.n76 ibias.n29 1.2941
R148 ibias.n8 ibias.n6 0.563614
R149 ibias.n10 ibias.t47 0.449148
R150 ibias.t7 ibias.n12 0.393325
R151 ibias.n12 ibias.t35 0.451637
R152 ibias.t1 ibias.n10 0.398303
R153 ibias.n21 ibias.n20 0.462386
R154 ibias.n36 ibias.n16 0.571814
R155 ibias.n19 ibias.n53 0.412947
R156 ibias.n17 ibias.n2 0.41259
R157 ibias.n19 ibias.n18 0.468505
R158 ibias.n23 ibias.n22 0.4533
R159 ibias.n43 ibias.n62 0.42253
R160 ibias.n52 ibias.n26 0.412947
R161 ibias.n24 ibias.n53 1.2919
R162 ibias.n27 ibias.n26 0.468505
R163 ibias.n38 ibias.n51 0.41928
R164 ibias.n31 ibias.n30 0.412947
R165 ibias.n33 ibias.n31 0.468505
R166 ibias.n41 ibias.n14 0.574384
R167 ibias.n30 ibias.n35 0.423762
R168 ibias.n47 ibias.n54 0.528401
R169 ibias.n43 ibias.n42 0.448908
R170 ibias.n41 ibias.n47 1.28781
R171 ibias.n40 ibias.t34 2.60499
R172 ibias.n37 ibias.n29 1.41932
R173 ibias.n41 ibias.n60 1.21661
R174 ibias.n30 ibias.n40 0.414668
R175 ibias.n66 ibias.n80 1.1775
R176 ibias.n58 ibias.n53 1.17068
R177 ibias.n52 ibias.n57 1.17068
R178 ibias.t3 ibias.t7 1.14733
R179 ibias.t9 ibias.n10 0.398303
R180 ibias.n85 ibias.n66 1.12998
R181 ibias.n12 ibias.n15 0.787555
R182 ibias.n15 ibias.t1 0.39473
R183 ibias.n72 ibias.n66 1.12671
R184 ibias.n90 ibias.n38 6.29848
R185 ibias.n1 ibias.n65 0.595011
R186 ibias.n5 ibias.n68 0.595011
R187 ibias.n8 ibias.n71 0.595011
R188 ibias.n52 ibias.n29 2.02451
R189 ibias.n35 ibias.t47 1.93307
R190 ibias.n13 ibias.t63 1.76817
R191 ibias.n80 ibias.n21 0.579665
R192 ibias.n83 ibias.n23 0.549391
R193 ibias.n81 ibias.n24 1.46607
R194 ibias.n17 ibias.n16 1.46607
R195 ibias.n19 ibias.n88 0.468505
R196 ibias.n26 ibias.n25 0.468505
R197 ibias.n89 ibias.n31 0.468505
R198 ibias.n49 ibias.n16 1.38377
R199 ibias.n60 ibias.t63 1.30436
R200 ibias.n61 ibias.n28 1.30436
R201 ibias.n46 ibias.n0 1.304
R202 ibias.n6 ibias.n44 1.29912
R203 ibias.n45 ibias.n3 1.29912
R204 ibias.t35 ibias.n35 1.17949
R205 ibias.n40 ibias.t35 1.16196
R206 ibias.n54 ibias.n13 1.07719
R207 ibias.n59 ibias.n18 1.05584
R208 ibias.n56 ibias.n27 1.05584
R209 ibias.n33 ibias.n32 1.05584
R210 ibias.n88 ibias.n20 1.03522
R211 ibias.n22 ibias.n25 1.03522
R212 ibias.n89 ibias.n28 1.03522
R213 ibias.n11 ibias.t3 1.0092
R214 ibias.t3 ibias.n34 0.9971
R215 ibias.n61 ibias.n30 0.972717
R216 ibias.n34 ibias.n41 0.955758
R217 ibias.t35 ibias.n11 0.955246
R218 ibias.n50 ibias.n49 0.922757
R219 ibias.n38 ibias.n37 0.363882
R220 ibias.n87 ibias.n72 0.90775
R221 ibias.n87 ibias.n64 0.90775
R222 ibias.n74 ibias.n73 0.90775
R223 ibias.n73 ibias.n75 0.90775
R224 ibias.n77 ibias.n76 0.90775
R225 ibias.n76 ibias.n78 0.90775
R226 ibias.n52 ibias.n51 0.837435
R227 ibias.n62 ibias.n53 0.837435
R228 ibias.n91 ibias.n63 0.80746
R229 ibias.n85 ibias.n16 0.761646
R230 ibias.n69 ibias.n28 0.75628
R231 ibias.n53 ibias.n4 1.45552
R232 ibias.n52 ibias.n7 1.45552
R233 AVSS.n267 AVSS.n93 30105.9
R234 AVSS.n87 AVSS.n267 1134.72
R235 AVSS.t96 AVSS.t83 1030.48
R236 AVSS.t95 AVSS.t82 1026.96
R237 AVSS.t30 AVSS.t29 1026.96
R238 AVSS.t31 AVSS.t30 1026.96
R239 AVSS.t82 AVSS.t96 1021.69
R240 AVSS.n9 AVSS.t95 927.409
R241 AVSS.t29 AVSS.n268 877.491
R242 AVSS.t28 AVSS.n17 875.734
R243 AVSS.n322 AVSS.t83 830.013
R244 AVSS.n322 AVSS.n17 302.462
R245 AVSS.n268 AVSS.t28 149.472
R246 AVSS.n314 AVSS.n9 59.87
R247 AVSS.n31 AVSS.n18 41.0303
R248 AVSS.n65 AVSS.n93 39.4939
R249 AVSS.n28 AVSS.t4 9.59169
R250 AVSS.t80 AVSS.n45 0.218695
R251 AVSS.n349 AVSS.n12 6.439
R252 AVSS.t40 AVSS.n18 7.83873
R253 AVSS.n19 AVSS.n31 0.141705
R254 AVSS.n9 AVSS.n11 8.63668
R255 AVSS.n9 AVSS.t78 11.3148
R256 AVSS.n268 AVSS.n40 8.67924
R257 AVSS.n10 AVSS.t85 9.19921
R258 AVSS.n28 AVSS.t8 11.3676
R259 AVSS.n9 AVSS.n45 10.6645
R260 AVSS.n268 AVSS.n14 17.2493
R261 AVSS.n76 AVSS.n42 1.07427
R262 AVSS.t43 AVSS.n12 9.06287
R263 AVSS.n40 AVSS.t2 8.37195
R264 AVSS.n10 AVSS.t86 9.03828
R265 AVSS.n89 AVSS.n18 6.09076
R266 AVSS.t97 AVSS.n11 0.0923234
R267 AVSS.t76 AVSS.n65 7.12282
R268 AVSS.t79 AVSS.n9 9.29724
R269 AVSS.t0 AVSS.n28 9.29356
R270 AVSS.n14 AVSS.t36 8.00658
R271 AVSS.n28 AVSS.n40 2.88497
R272 AVSS.n9 AVSS.t87 7.83925
R273 AVSS.t91 AVSS.n51 7.12007
R274 AVSS.n89 AVSS.t38 3.92095
R275 AVSS.n66 AVSS.n349 370.63
R276 AVSS.n268 AVSS.n89 13.5512
R277 AVSS.n65 AVSS.n66 0.00631206
R278 AVSS.n349 AVSS.n74 0.392528
R279 AVSS.n8 AVSS.n24 0.00821591
R280 AVSS.n8 AVSS.n7 0.0101481
R281 AVSS.n349 AVSS.n8 0.198226
R282 AVSS.n349 AVSS.n6 0.67779
R283 AVSS.n1 AVSS.n0 0.00318596
R284 AVSS.t31 AVSS.n32 879.928
R285 AVSS.n69 AVSS.n87 0.300066
R286 AVSS.n4 AVSS.n39 0.0237945
R287 AVSS.n39 AVSS.n87 0.280159
R288 AVSS.n314 AVSS.n29 0.180316
R289 AVSS.n29 AVSS.n80 0.0386443
R290 AVSS.n314 AVSS.n18 0.546757
R291 AVSS.n173 AVSS.n34 5.71119
R292 AVSS.n34 AVSS.n82 1.25197
R293 AVSS.n82 AVSS.n20 3.3033
R294 AVSS.n70 AVSS.n37 1.717
R295 AVSS.n85 AVSS.n70 1.07789
R296 AVSS.n172 AVSS.n79 0.98187
R297 AVSS.n346 AVSS.n79 0.961993
R298 AVSS.n346 AVSS.n22 0.633013
R299 AVSS.n225 AVSS.n104 8.46995
R300 AVSS.n225 AVSS.n71 0.374001
R301 AVSS.n71 AVSS.n42 4.17416
R302 AVSS.n224 AVSS.n76 0.691489
R303 AVSS.n221 AVSS.n43 0.624383
R304 AVSS.n119 AVSS.n9 8.46995
R305 AVSS.n262 AVSS.n75 1.45291
R306 AVSS.n75 AVSS.n68 2.60226
R307 AVSS.n68 AVSS.n35 2.32284
R308 AVSS.n77 AVSS.n7 1.97072
R309 AVSS.n35 AVSS.n77 1.53405
R310 AVSS.n47 AVSS.n7 0.134324
R311 AVSS.n47 AVSS.n73 2.32299
R312 AVSS.n50 AVSS.n48 0.654314
R313 AVSS.n269 AVSS.n48 8.46995
R314 AVSS.n49 AVSS.n345 0.602015
R315 AVSS.n44 AVSS.n9 1.34058
R316 AVSS.n64 AVSS.n9 1.71695
R317 AVSS.n269 AVSS.n46 0.997754
R318 AVSS.n46 AVSS.n3 2.27683
R319 AVSS.n3 AVSS.n86 1.99758
R320 AVSS.n3 AVSS.n2 0.0624714
R321 AVSS.n4 AVSS.n86 1.51106
R322 AVSS.n141 AVSS.n5 1.2817
R323 AVSS.n5 AVSS.n4 0.134403
R324 AVSS.n5 AVSS.n26 2.64023
R325 AVSS.n30 AVSS.n312 1.43906
R326 AVSS.n30 AVSS.n28 0.0216115
R327 AVSS.n38 AVSS.n28 1.34056
R328 AVSS.n83 AVSS.n88 1.3287
R329 AVSS.n88 AVSS.n80 3.3033
R330 AVSS.n81 AVSS.n80 1.34102
R331 AVSS.n313 AVSS.n103 0.298562
R332 AVSS.n103 AVSS.n80 4.17416
R333 AVSS.n18 AVSS.n52 1.51128
R334 AVSS.n36 AVSS.n18 0.65417
R335 AVSS.n167 AVSS.t89 7.37859
R336 AVSS.n166 AVSS.t92 7.37418
R337 AVSS.n166 AVSS.t93 7.29586
R338 AVSS.n167 AVSS.t77 7.29147
R339 AVSS.n0 AVSS.n267 47200.6
R340 AVSS.n19 AVSS.n20 0.0122749
R341 AVSS.n31 AVSS.n41 0.291013
R342 AVSS.n41 AVSS.n104 0.00806391
R343 AVSS.n74 AVSS.n23 0.0107193
R344 AVSS.n85 AVSS.n20 1.71688
R345 AVSS.n84 AVSS.n37 1.0746
R346 AVSS.n102 AVSS.n37 4.17435
R347 AVSS.n67 AVSS.n21 0.792077
R348 AVSS.n79 AVSS.n21 0.654791
R349 AVSS.n22 AVSS.n21 1.34064
R350 AVSS.n92 AVSS.n21 2.7169
R351 AVSS.n43 AVSS.n42 1.34074
R352 AVSS.n78 AVSS.n42 1.07414
R353 AVSS.n72 AVSS.n42 1.32879
R354 AVSS.n75 AVSS.n18 0.13746
R355 AVSS.n68 AVSS.n23 0.206783
R356 AVSS.n35 AVSS.n24 0.496391
R357 AVSS.n73 AVSS.n6 0.596033
R358 AVSS.n25 AVSS.n26 0.173814
R359 AVSS.n27 AVSS.n26 2.4992
R360 AVSS.n83 AVSS.n28 0.543644
R361 AVSS.t90 AVSS.n51 11.1614
R362 AVSS.n51 AVSS.n0 0.00585259
R363 AVSS.n159 AVSS.t14 5.47994
R364 AVSS.n157 AVSS.t5 5.47994
R365 AVSS.n127 AVSS.t32 5.47994
R366 AVSS.n125 AVSS.t37 5.47994
R367 AVSS.n198 AVSS.t52 5.47994
R368 AVSS.n196 AVSS.t56 5.47994
R369 AVSS.n177 AVSS.t68 5.47994
R370 AVSS.n176 AVSS.t74 5.47994
R371 AVSS.n187 AVSS.t75 5.47994
R372 AVSS.n188 AVSS.t73 5.47994
R373 AVSS.n258 AVSS.t72 5.47994
R374 AVSS.n191 AVSS.t70 5.47994
R375 AVSS.n186 AVSS.t71 5.47994
R376 AVSS.n255 AVSS.t69 5.47994
R377 AVSS.n205 AVSS.t58 5.47994
R378 AVSS.n206 AVSS.t59 5.47994
R379 AVSS.n241 AVSS.t57 5.47994
R380 AVSS.n209 AVSS.t54 5.47994
R381 AVSS.n204 AVSS.t55 5.47994
R382 AVSS.n238 AVSS.t53 5.47994
R383 AVSS.n145 AVSS.t41 5.47994
R384 AVSS.n147 AVSS.t44 5.47994
R385 AVSS.n338 AVSS.t39 5.47994
R386 AVSS.n150 AVSS.t34 5.47994
R387 AVSS.n143 AVSS.t35 5.47994
R388 AVSS.n335 AVSS.t33 5.47994
R389 AVSS.n274 AVSS.t19 5.47994
R390 AVSS.n276 AVSS.t20 5.47994
R391 AVSS.n302 AVSS.t18 5.47994
R392 AVSS.n279 AVSS.t16 5.47994
R393 AVSS.n272 AVSS.t17 5.47994
R394 AVSS.n299 AVSS.t15 5.47994
R395 AVSS.n163 AVSS.t3 5.4798
R396 AVSS.n161 AVSS.t11 5.4798
R397 AVSS.n131 AVSS.t21 5.4798
R398 AVSS.n129 AVSS.t26 5.4798
R399 AVSS.n124 AVSS.t45 5.4798
R400 AVSS.n200 AVSS.t49 5.4798
R401 AVSS.n182 AVSS.t60 5.4798
R402 AVSS.n179 AVSS.t65 5.4798
R403 AVSS.n185 AVSS.t66 5.4798
R404 AVSS.n194 AVSS.t67 5.4798
R405 AVSS.n252 AVSS.t64 5.4798
R406 AVSS.n183 AVSS.t61 5.4798
R407 AVSS.n184 AVSS.t62 5.4798
R408 AVSS.n246 AVSS.t63 5.4798
R409 AVSS.n203 AVSS.t50 5.4798
R410 AVSS.n212 AVSS.t51 5.4798
R411 AVSS.n235 AVSS.t48 5.4798
R412 AVSS.n123 AVSS.t42 5.4798
R413 AVSS.n202 AVSS.t46 5.4798
R414 AVSS.n213 AVSS.t47 5.4798
R415 AVSS.n144 AVSS.t25 5.4798
R416 AVSS.n153 AVSS.t27 5.4798
R417 AVSS.n332 AVSS.t24 5.4798
R418 AVSS.n132 AVSS.t22 5.4798
R419 AVSS.n142 AVSS.t1 5.4798
R420 AVSS.n155 AVSS.t23 5.4798
R421 AVSS.n273 AVSS.t12 5.4798
R422 AVSS.n282 AVSS.t13 5.4798
R423 AVSS.n296 AVSS.t10 5.4798
R424 AVSS.n164 AVSS.t6 5.4798
R425 AVSS.n271 AVSS.t7 5.4798
R426 AVSS.n284 AVSS.t9 5.4798
R427 AVSS.n53 AVSS.n351 5.4005
R428 AVSS.n312 AVSS.n311 5.4005
R429 AVSS.n55 AVSS.n54 5.4005
R430 AVSS.n313 AVSS.n101 5.4005
R431 AVSS.n316 AVSS.n315 5.4005
R432 AVSS.n62 AVSS.n135 5.4005
R433 AVSS.n63 AVSS.n320 5.4005
R434 AVSS.n61 AVSS.n134 5.4005
R435 AVSS.n99 AVSS.n217 5.4005
R436 AVSS.n97 AVSS.n218 5.4005
R437 AVSS.n96 AVSS.n222 5.4005
R438 AVSS.n90 AVSS.n216 5.4005
R439 AVSS.n91 AVSS.n227 5.4005
R440 AVSS.n60 AVSS.n59 5.4005
R441 AVSS.n58 AVSS.n170 5.4005
R442 AVSS.n57 AVSS.n169 5.4005
R443 AVSS.n55 AVSS.n310 5.4005
R444 AVSS.n138 AVSS.n101 5.4005
R445 AVSS.n317 AVSS.n316 5.4005
R446 AVSS.n62 AVSS.n319 5.4005
R447 AVSS.n321 AVSS.n63 5.4005
R448 AVSS.n324 AVSS.n323 5.4005
R449 AVSS.n219 AVSS.n99 5.4005
R450 AVSS.n220 AVSS.n95 5.4005
R451 AVSS.n96 AVSS.n221 5.4005
R452 AVSS.n224 AVSS.n223 5.4005
R453 AVSS.n91 AVSS.n226 5.4005
R454 AVSS.n172 AVSS.n53 5.4005
R455 AVSS.n171 AVSS.n60 5.4005
R456 AVSS.n58 AVSS.n94 5.4005
R457 AVSS.n57 AVSS.n56 5.4005
R458 AVSS.n87 AVSS.n28 4.88121
R459 AVSS.n322 AVSS.n9 0.68007
R460 AVSS.n266 AVSS.n265 4.20617
R461 AVSS.n49 AVSS.n9 1.5111
R462 AVSS.n46 AVSS.n32 0.791973
R463 AVSS.n265 AVSS.n168 3.52087
R464 AVSS.n93 AVSS.n1 39.4914
R465 AVSS.n288 AVSS.n270 3.03229
R466 AVSS.n263 AVSS.n262 3.0005
R467 AVSS.n348 AVSS.n347 3.0005
R468 AVSS.n344 AVSS.n121 3.0005
R469 AVSS.n307 AVSS.n141 3.0005
R470 AVSS.n307 AVSS.n137 3.0005
R471 AVSS.n344 AVSS.n343 3.0005
R472 AVSS.n347 AVSS.n118 3.0005
R473 AVSS.n308 AVSS.n307 3.0005
R474 AVSS.n345 AVSS.n344 3.0005
R475 AVSS.n347 AVSS.n346 3.0005
R476 AVSS.n18 AVSS.n115 1.71723
R477 AVSS.n289 AVSS 1.7088
R478 AVSS.n18 AVSS.n108 1.5116
R479 AVSS.n18 AVSS.n114 1.51113
R480 AVSS.n33 AVSS.n9 0.186336
R481 AVSS.n139 AVSS.n9 1.34116
R482 AVSS.n18 AVSS.n111 1.34098
R483 AVSS.n18 AVSS.n116 1.34098
R484 AVSS.n265 AVSS.n264 1.25393
R485 AVSS.n168 AVSS.n65 9.75378
R486 AVSS.n325 AVSS 1.15891
R487 AVSS.n270 AVSS.n27 1.20665
R488 AVSS.n169 AVSS.n13 1.11406
R489 AVSS.n310 AVSS.n309 1.11288
R490 AVSS.n262 AVSS.n13 1.10944
R491 AVSS.n309 AVSS.n308 1.10275
R492 AVSS.n266 AVSS.n0 9.75127
R493 AVSS.n18 AVSS.n110 1.07451
R494 AVSS.n18 AVSS.n113 1.07427
R495 AVSS.n18 AVSS.n109 1.07427
R496 AVSS.n18 AVSS.n107 1.07427
R497 AVSS.n18 AVSS.n112 1.07408
R498 AVSS.n351 AVSS.n350 1.06464
R499 AVSS.n350 AVSS.n59 1.01239
R500 AVSS.n261 AVSS.n260 1.0005
R501 AVSS.n178 AVSS.n174 1.0005
R502 AVSS.n181 AVSS.n180 1.0005
R503 AVSS.n249 AVSS.n106 1.0005
R504 AVSS.n244 AVSS.n105 1.0005
R505 AVSS.n197 AVSS.n117 1.0005
R506 AVSS.n229 AVSS.n199 1.0005
R507 AVSS.n230 AVSS.n201 1.0005
R508 AVSS.n232 AVSS.n231 1.0005
R509 AVSS.n342 AVSS.n341 1.0005
R510 AVSS.n126 AVSS.n120 1.0005
R511 AVSS.n326 AVSS.n128 1.0005
R512 AVSS.n327 AVSS.n130 1.0005
R513 AVSS.n329 AVSS.n328 1.0005
R514 AVSS.n306 AVSS.n305 1.0005
R515 AVSS.n158 AVSS.n140 1.0005
R516 AVSS.n290 AVSS.n160 1.0005
R517 AVSS.n291 AVSS.n162 1.0005
R518 AVSS.n293 AVSS.n292 1.0005
R519 AVSS.n288 AVSS.n287 1.0005
R520 AVSS.n318 AVSS.n317 0.984823
R521 AVSS.n169 AVSS.n15 0.967919
R522 AVSS.n136 AVSS.n9 0.967162
R523 AVSS.n351 AVSS.n16 0.940449
R524 AVSS.n118 AVSS.n16 0.935724
R525 AVSS.n170 AVSS.n15 0.9254
R526 AVSS.n319 AVSS.n318 0.890957
R527 AVSS.n138 AVSS.n136 0.833312
R528 AVSS.n218 AVSS.n112 0.797966
R529 AVSS.n216 AVSS.n110 0.769104
R530 AVSS.n317 AVSS.n136 0.753113
R531 AVSS.n107 AVSS.n59 0.750156
R532 AVSS.n299 AVSS.n298 0.74762
R533 AVSS.n297 AVSS.n159 0.74762
R534 AVSS.n335 AVSS.n334 0.74762
R535 AVSS.n333 AVSS.n127 0.74762
R536 AVSS.n238 AVSS.n237 0.74762
R537 AVSS.n236 AVSS.n198 0.74762
R538 AVSS.n255 AVSS.n254 0.74762
R539 AVSS.n253 AVSS.n177 0.74762
R540 AVSS.n192 AVSS.n191 0.74762
R541 AVSS.n193 AVSS.n186 0.74762
R542 AVSS.n210 AVSS.n209 0.74762
R543 AVSS.n211 AVSS.n204 0.74762
R544 AVSS.n151 AVSS.n150 0.74762
R545 AVSS.n152 AVSS.n143 0.74762
R546 AVSS.n280 AVSS.n279 0.74762
R547 AVSS.n281 AVSS.n272 0.74762
R548 AVSS.n217 AVSS.n113 0.746808
R549 AVSS.n284 AVSS.n283 0.74674
R550 AVSS.n295 AVSS.n163 0.74674
R551 AVSS.n155 AVSS.n154 0.74674
R552 AVSS.n331 AVSS.n131 0.74674
R553 AVSS.n214 AVSS.n213 0.74674
R554 AVSS.n234 AVSS.n124 0.74674
R555 AVSS.n247 AVSS.n246 0.74674
R556 AVSS.n251 AVSS.n182 0.74674
R557 AVSS.n250 AVSS.n183 0.74674
R558 AVSS.n248 AVSS.n184 0.74674
R559 AVSS.n233 AVSS.n123 0.74674
R560 AVSS.n215 AVSS.n202 0.74674
R561 AVSS.n330 AVSS.n132 0.74674
R562 AVSS.n142 AVSS.n133 0.74674
R563 AVSS.n294 AVSS.n164 0.74674
R564 AVSS.n271 AVSS.n165 0.74674
R565 AVSS.n343 AVSS.n113 0.746489
R566 AVSS.n302 AVSS.n301 0.74586
R567 AVSS.n300 AVSS.n157 0.74586
R568 AVSS.n338 AVSS.n337 0.74586
R569 AVSS.n336 AVSS.n125 0.74586
R570 AVSS.n241 AVSS.n240 0.74586
R571 AVSS.n239 AVSS.n196 0.74586
R572 AVSS.n258 AVSS.n257 0.74586
R573 AVSS.n256 AVSS.n176 0.74586
R574 AVSS.n190 AVSS.n187 0.74586
R575 AVSS.n189 AVSS.n188 0.74586
R576 AVSS.n208 AVSS.n205 0.74586
R577 AVSS.n207 AVSS.n206 0.74586
R578 AVSS.n149 AVSS.n145 0.74586
R579 AVSS.n148 AVSS.n147 0.74586
R580 AVSS.n278 AVSS.n274 0.74586
R581 AVSS.n277 AVSS.n276 0.74586
R582 AVSS.n297 AVSS.n296 0.7441
R583 AVSS.n298 AVSS.n161 0.7441
R584 AVSS.n333 AVSS.n332 0.7441
R585 AVSS.n334 AVSS.n129 0.7441
R586 AVSS.n236 AVSS.n235 0.7441
R587 AVSS.n237 AVSS.n200 0.7441
R588 AVSS.n253 AVSS.n252 0.7441
R589 AVSS.n254 AVSS.n179 0.7441
R590 AVSS.n192 AVSS.n185 0.7441
R591 AVSS.n194 AVSS.n193 0.7441
R592 AVSS.n210 AVSS.n203 0.7441
R593 AVSS.n212 AVSS.n211 0.7441
R594 AVSS.n151 AVSS.n144 0.7441
R595 AVSS.n153 AVSS.n152 0.7441
R596 AVSS.n280 AVSS.n273 0.7441
R597 AVSS.n282 AVSS.n281 0.7441
R598 AVSS.n217 AVSS.n112 0.737477
R599 AVSS.n227 AVSS.n109 0.730308
R600 AVSS.n170 AVSS.n107 0.728475
R601 AVSS.n18 AVSS.n15 0.720216
R602 AVSS.n216 AVSS.n109 0.715322
R603 AVSS.n222 AVSS.n110 0.698555
R604 AVSS.n308 AVSS.n139 0.698521
R605 AVSS.n310 AVSS.n33 1.29367
R606 AVSS.n222 AVSS.n111 0.687462
R607 AVSS.n18 AVSS.n17 0.6805
R608 AVSS.n285 AVSS.n284 0.67634
R609 AVSS.n286 AVSS.n163 0.67634
R610 AVSS.n303 AVSS.n302 0.67634
R611 AVSS.n156 AVSS.n155 0.67634
R612 AVSS.n304 AVSS.n131 0.67634
R613 AVSS.n339 AVSS.n338 0.67634
R614 AVSS.n213 AVSS.n122 0.67634
R615 AVSS.n340 AVSS.n124 0.67634
R616 AVSS.n242 AVSS.n241 0.67634
R617 AVSS.n246 AVSS.n245 0.67634
R618 AVSS.n243 AVSS.n182 0.67634
R619 AVSS.n259 AVSS.n258 0.67634
R620 AVSS.n188 AVSS.n175 0.67634
R621 AVSS.n206 AVSS.n195 0.67634
R622 AVSS.n147 AVSS.n146 0.67634
R623 AVSS.n276 AVSS.n275 0.67634
R624 AVSS.n318 AVSS.n9 0.65451
R625 AVSS.n134 AVSS.n114 0.651192
R626 AVSS.n118 AVSS.n108 0.641396
R627 AVSS.n228 AVSS 0.60968
R628 AVSS.n227 AVSS.n108 0.604804
R629 AVSS.n320 AVSS.n116 0.603409
R630 AVSS.n343 AVSS.n114 0.602292
R631 AVSS.n139 AVSS.n138 0.599693
R632 AVSS.n135 AVSS.n115 0.599082
R633 AVSS.n18 AVSS.n16 0.597225
R634 AVSS.n218 AVSS.n111 0.588742
R635 AVSS.n134 AVSS.n116 0.586629
R636 AVSS.n320 AVSS.n115 0.580483
R637 AVSS.n270 AVSS.n30 1.50476
R638 AVSS.n350 AVSS.n18 0.544719
R639 AVSS.n295 AVSS.n294 0.51442
R640 AVSS.n283 AVSS.n165 0.51442
R641 AVSS.n298 AVSS.n297 0.51442
R642 AVSS.n281 AVSS.n280 0.51442
R643 AVSS.n301 AVSS.n300 0.51442
R644 AVSS.n278 AVSS.n277 0.51442
R645 AVSS.n331 AVSS.n330 0.51442
R646 AVSS.n154 AVSS.n133 0.51442
R647 AVSS.n334 AVSS.n333 0.51442
R648 AVSS.n152 AVSS.n151 0.51442
R649 AVSS.n337 AVSS.n336 0.51442
R650 AVSS.n149 AVSS.n148 0.51442
R651 AVSS.n234 AVSS.n233 0.51442
R652 AVSS.n215 AVSS.n214 0.51442
R653 AVSS.n237 AVSS.n236 0.51442
R654 AVSS.n211 AVSS.n210 0.51442
R655 AVSS.n240 AVSS.n239 0.51442
R656 AVSS.n208 AVSS.n207 0.51442
R657 AVSS.n251 AVSS.n250 0.51442
R658 AVSS.n248 AVSS.n247 0.51442
R659 AVSS.n254 AVSS.n253 0.51442
R660 AVSS.n193 AVSS.n192 0.51442
R661 AVSS.n257 AVSS.n256 0.51442
R662 AVSS.n190 AVSS.n189 0.51442
R663 AVSS.n287 AVSS.n285 0.45106
R664 AVSS.n293 AVSS.n165 0.45106
R665 AVSS.n280 AVSS.n162 0.45106
R666 AVSS.n278 AVSS.n160 0.45106
R667 AVSS.n275 AVSS.n158 0.45106
R668 AVSS.n305 AVSS.n156 0.45106
R669 AVSS.n329 AVSS.n133 0.45106
R670 AVSS.n151 AVSS.n130 0.45106
R671 AVSS.n149 AVSS.n128 0.45106
R672 AVSS.n146 AVSS.n126 0.45106
R673 AVSS.n341 AVSS.n122 0.45106
R674 AVSS.n232 AVSS.n215 0.45106
R675 AVSS.n208 AVSS.n199 0.45106
R676 AVSS.n197 AVSS.n195 0.45106
R677 AVSS.n245 AVSS.n244 0.45106
R678 AVSS.n249 AVSS.n248 0.45106
R679 AVSS.n192 AVSS.n181 0.45106
R680 AVSS.n190 AVSS.n178 0.45106
R681 AVSS.n260 AVSS.n175 0.45106
R682 AVSS.n210 AVSS.n201 0.45018
R683 AVSS.n100 AVSS 0.432005
R684 AVSS.n60 AVSS.n53 0.430443
R685 AVSS.n289 AVSS.n55 0.3899
R686 AVSS.n316 AVSS.n62 0.380786
R687 AVSS.n58 AVSS.n57 0.373871
R688 AVSS.n219 AVSS.n72 0.638334
R689 AVSS.n28 AVSS.n27 0.272367
R690 AVSS.n309 AVSS.n9 0.347739
R691 AVSS.t94 AVSS.n45 0.127936
R692 AVSS.n18 AVSS.n13 0.325852
R693 AVSS.n92 AVSS.n225 0.494611
R694 AVSS.n220 AVSS.n78 0.760048
R695 AVSS.n72 AVSS.n119 0.785607
R696 AVSS.n47 AVSS.n348 1.38538
R697 AVSS.n50 AVSS.n73 1.93404
R698 AVSS.n64 AVSS.n321 0.588871
R699 AVSS.n237 AVSS.n201 0.30762
R700 AVSS.n287 AVSS.n286 0.30674
R701 AVSS.n294 AVSS.n293 0.30674
R702 AVSS.n298 AVSS.n162 0.30674
R703 AVSS.n300 AVSS.n160 0.30674
R704 AVSS.n303 AVSS.n158 0.30674
R705 AVSS.n305 AVSS.n304 0.30674
R706 AVSS.n330 AVSS.n329 0.30674
R707 AVSS.n334 AVSS.n130 0.30674
R708 AVSS.n336 AVSS.n128 0.30674
R709 AVSS.n339 AVSS.n126 0.30674
R710 AVSS.n341 AVSS.n340 0.30674
R711 AVSS.n233 AVSS.n232 0.30674
R712 AVSS.n239 AVSS.n199 0.30674
R713 AVSS.n242 AVSS.n197 0.30674
R714 AVSS.n244 AVSS.n243 0.30674
R715 AVSS.n250 AVSS.n249 0.30674
R716 AVSS.n254 AVSS.n181 0.30674
R717 AVSS.n256 AVSS.n178 0.30674
R718 AVSS.n260 AVSS.n259 0.30674
R719 AVSS.n316 AVSS.n101 0.301586
R720 AVSS.n99 AVSS.n97 0.2865
R721 AVSS.n98 AVSS 0.285563
R722 AVSS.n223 AVSS.n96 0.272671
R723 AVSS.n91 AVSS.n90 0.270786
R724 AVSS.n315 AVSS.n36 0.985004
R725 AVSS.n52 AVSS.n103 0.841607
R726 AVSS.n313 AVSS.n81 0.595115
R727 AVSS.n102 AVSS.n67 1.12204
R728 AVSS.n321 AVSS.n44 0.594921
R729 AVSS.n84 AVSS.n171 0.695117
R730 AVSS.n44 AVSS.n323 0.606002
R731 AVSS.t84 AVSS.n11 0.14603
R732 AVSS.n304 AVSS.n303 0.22402
R733 AVSS.n340 AVSS.n339 0.22402
R734 AVSS.n243 AVSS.n242 0.22402
R735 AVSS.n245 AVSS.n195 0.22402
R736 AVSS.n146 AVSS.n122 0.22402
R737 AVSS.n275 AVSS.n156 0.22402
R738 AVSS.n63 AVSS.n61 0.217043
R739 AVSS.n300 AVSS.n299 0.21434
R740 AVSS.n301 AVSS.n159 0.21434
R741 AVSS.n336 AVSS.n335 0.21434
R742 AVSS.n337 AVSS.n127 0.21434
R743 AVSS.n239 AVSS.n238 0.21434
R744 AVSS.n240 AVSS.n198 0.21434
R745 AVSS.n256 AVSS.n255 0.21434
R746 AVSS.n257 AVSS.n177 0.21434
R747 AVSS.n191 AVSS.n190 0.21434
R748 AVSS.n189 AVSS.n186 0.21434
R749 AVSS.n209 AVSS.n208 0.21434
R750 AVSS.n207 AVSS.n204 0.21434
R751 AVSS.n150 AVSS.n149 0.21434
R752 AVSS.n148 AVSS.n143 0.21434
R753 AVSS.n279 AVSS.n278 0.21434
R754 AVSS.n277 AVSS.n272 0.21434
R755 AVSS.n296 AVSS.n295 0.21346
R756 AVSS.n294 AVSS.n161 0.21346
R757 AVSS.n332 AVSS.n331 0.21346
R758 AVSS.n330 AVSS.n129 0.21346
R759 AVSS.n235 AVSS.n234 0.21346
R760 AVSS.n233 AVSS.n200 0.21346
R761 AVSS.n252 AVSS.n251 0.21346
R762 AVSS.n250 AVSS.n179 0.21346
R763 AVSS.n248 AVSS.n185 0.21346
R764 AVSS.n247 AVSS.n194 0.21346
R765 AVSS.n215 AVSS.n203 0.21346
R766 AVSS.n214 AVSS.n212 0.21346
R767 AVSS.n144 AVSS.n133 0.21346
R768 AVSS.n154 AVSS.n153 0.21346
R769 AVSS.n273 AVSS.n165 0.21346
R770 AVSS.n283 AVSS.n282 0.21346
R771 AVSS.n137 AVSS.n88 0.254647
R772 AVSS.n38 AVSS.n312 0.649931
R773 AVSS.n82 AVSS.n56 0.324314
R774 AVSS.n319 AVSS.n64 0.597976
R775 AVSS.n86 AVSS.n141 0.647836
R776 AVSS.n78 AVSS.n219 0.793567
R777 AVSS.n71 AVSS.n224 0.298562
R778 AVSS.n303 AVSS.n157 0.16242
R779 AVSS.n339 AVSS.n125 0.16242
R780 AVSS.n242 AVSS.n196 0.16242
R781 AVSS.n259 AVSS.n176 0.16242
R782 AVSS.n187 AVSS.n175 0.16242
R783 AVSS.n243 AVSS.n183 0.16242
R784 AVSS.n245 AVSS.n184 0.16242
R785 AVSS.n205 AVSS.n195 0.16242
R786 AVSS.n340 AVSS.n123 0.16242
R787 AVSS.n202 AVSS.n122 0.16242
R788 AVSS.n146 AVSS.n145 0.16242
R789 AVSS.n304 AVSS.n132 0.16242
R790 AVSS.n156 AVSS.n142 0.16242
R791 AVSS.n275 AVSS.n274 0.16242
R792 AVSS.n286 AVSS.n164 0.16242
R793 AVSS.n285 AVSS.n271 0.16242
R794 AVSS.n67 AVSS.n172 0.839845
R795 AVSS.n264 AVSS.n173 0.15186
R796 AVSS AVSS.n352 0.139296
R797 AVSS.n269 AVSS.n121 0.134606
R798 AVSS.n180 AVSS.n174 0.13162
R799 AVSS.n230 AVSS.n229 0.13162
R800 AVSS.n327 AVSS.n326 0.13162
R801 AVSS.n291 AVSS.n290 0.13162
R802 AVSS.n180 AVSS.n106 0.13107
R803 AVSS.n231 AVSS.n230 0.13107
R804 AVSS.n328 AVSS.n327 0.13107
R805 AVSS.n292 AVSS.n291 0.13107
R806 AVSS.n121 AVSS.n50 0.956267
R807 AVSS.n34 AVSS.n9 0.520597
R808 AVSS.n135 AVSS.n36 0.88936
R809 AVSS.n292 AVSS.n288 0.12502
R810 AVSS.n261 AVSS.n174 0.12491
R811 AVSS.n38 AVSS.n54 0.701338
R812 AVSS.n81 AVSS.n137 0.699324
R813 AVSS.n345 AVSS.n119 0.116272
R814 AVSS.n84 AVSS.n94 0.788908
R815 AVSS.n102 AVSS.n171 0.296346
R816 AVSS.n226 AVSS.n92 0.416293
R817 AVSS.n43 AVSS.n220 0.626031
R818 AVSS.n323 AVSS.n49 0.631257
R819 AVSS.n352 AVSS.n106 0.10082
R820 AVSS.n328 AVSS.n100 0.10082
R821 AVSS.n231 AVSS.n98 0.10049
R822 AVSS.n326 AVSS.n325 0.10038
R823 AVSS.n229 AVSS.n228 0.10005
R824 AVSS.n290 AVSS.n289 0.10005
R825 AVSS.n325 AVSS.n324 0.0966714
R826 AVSS.n315 AVSS.n52 0.557747
R827 AVSS.n221 AVSS.n76 0.763308
R828 AVSS.n348 AVSS.n77 0.436904
R829 AVSS.n266 AVSS.n166 0.0764
R830 AVSS.n168 AVSS.n167 0.0756667
R831 AVSS.n18 AVSS.n14 0.0175432
R832 AVSS.n85 AVSS.n56 0.524476
R833 AVSS.n264 AVSS.n263 0.03504
R834 AVSS.n263 AVSS.n261 0.03174
R835 AVSS.n96 AVSS.n95 0.229614
R836 AVSS.n99 AVSS.n98 0.154814
R837 AVSS.n18 AVSS.n12 0.0161843
R838 AVSS.n70 AVSS.n94 0.492186
R839 AVSS.n226 AVSS.n22 0.597266
R840 AVSS.n101 AVSS.n100 0.111443
R841 AVSS.n228 AVSS.n91 0.0998143
R842 AVSS.n228 AVSS.n117 0.00712051
R843 AVSS.n289 AVSS.n140 0.00712051
R844 AVSS.n342 AVSS.n98 0.00703262
R845 AVSS.n325 AVSS.n120 0.00703262
R846 AVSS.n352 AVSS.n105 0.00694474
R847 AVSS.n306 AVSS.n100 0.00694474
R848 AVSS.n66 AVSS.t88 6.79719
R849 AVSS.n311 AVSS.n33 1.76015
R850 AVSS.n83 AVSS.n54 0.96121
R851 AVSS.n347 AVSS.n105 0.00577297
R852 AVSS.n307 AVSS.n306 0.00577297
R853 AVSS.n344 AVSS.n342 0.00568509
R854 AVSS.n344 AVSS.n120 0.00568509
R855 AVSS.n347 AVSS.n117 0.0055972
R856 AVSS.n307 AVSS.n140 0.0055972
R857 AVSS.n97 AVSS.n95 0.00427143
R858 AVSS.n324 AVSS.n61 0.00395714
R859 AVSS.n223 AVSS.n90 0.00332857
R860 AVSS.t81 AVSS.n9 11.5855
R861 AVSS.n60 AVSS.n58 0.278957
R862 AVSS.n352 AVSS.n53 0.267014
R863 AVSS.n311 AVSS.n55 0.246271
R864 AVSS.n173 AVSS.n57 0.229929
R865 AVSS.n63 AVSS.n62 0.2117
R866 AVSS.n18 AVSS.n80 0.0377371
R867 AVSS.n24 AVSS.n23 0.0357147
R868 AVSS.n29 AVSS.n28 0.025201
R869 AVSS.n28 AVSS.n25 0.0344738
R870 AVSS.n19 AVSS.n9 0.0344286
R871 AVSS.n7 AVSS.n6 0.0313833
R872 AVSS.n10 AVSS.n9 0.00874906
R873 AVSS.n37 AVSS.n21 0.0305485
R874 AVSS.n9 AVSS.n42 0.0299896
R875 AVSS.n6 AVSS.n48 0.0290416
R876 AVSS.n4 AVSS.n69 0.0289576
R877 AVSS.n25 AVSS.n39 0.0272913
R878 AVSS.n20 AVSS.n37 0.0270242
R879 AVSS.n2 AVSS.n32 0.0261703
R880 AVSS.n41 AVSS.n21 0.0244812
R881 AVSS.n48 AVSS.n32 0.0229568
R882 AVSS.n104 AVSS.n42 0.0200644
R883 AVSS.n2 AVSS.n69 0.00965283
R884 AVSS.n18 AVSS.n74 0.0193291
R885 AVSS.n1 AVSS.t90 17.3429
R886 comparator_body_0.mref_m5_diff_0.mref_m5_array_3/n1_2$1_12.D comparator_body_0.mref_m5_diff_0.tail.t0 5.77616
R887 comparator_body_0.mref_m5_diff_0.mref_m5_array_3/n1_2$1_12.D comparator_body_0.mref_m5_diff_0.tail.t0 4.31837
R888 comparator_body_0.mref_m5_diff_0.tail.n0 comparator_body_0.mref_m5_diff_0.tail.n89 3.7177
R889 comparator_body_0.mref_m5_diff_0.tail.n92 comparator_body_0.mref_m5_diff_0.tail.n91 3.7177
R890 comparator_body_0.mref_m5_diff_0.tail.n24 comparator_body_0.mref_m5_diff_0.tail.n81 3.7177
R891 comparator_body_0.mref_m5_diff_0.tail.n1 comparator_body_0.mref_m5_diff_0.tail.n17 3.7177
R892 comparator_body_0.mref_m5_diff_0.tail.n116 comparator_body_0.mref_m5_diff_0.tail.n115 3.7177
R893 comparator_body_0.mref_m5_diff_0.tail.n3 comparator_body_0.mref_m5_diff_0.tail.n114 3.7177
R894 comparator_body_0.mref_m5_diff_0.tail.n6 comparator_body_0.mref_m5_diff_0.tail.n46 3.7177
R895 comparator_body_0.mref_m5_diff_0.tail.n6 comparator_body_0.mref_m5_diff_0.tail.n85 3.7177
R896 comparator_body_0.mref_m5_diff_0.tail.n64 comparator_body_0.m1_m2_diff_0.m1_m2_array_1/n1_2_10.S 3.01738
R897 comparator_body_0.mref_m5_diff_0.tail.n66 comparator_body_0.m1_m2_diff_0.m1_m2_array_1/n1_2_0.S 3.01738
R898 comparator_body_0.mref_m5_diff_0.tail.n68 comparator_body_0.m1_m2_diff_0.m1_m2_array_1/n1_2_11.S 3.01738
R899 comparator_body_0.mref_m5_diff_0.tail.n20 comparator_body_0.m1_m2_diff_0.m1_m2_array_1/n1_2_12.S 3.01738
R900 comparator_body_0.mref_m5_diff_0.tail.n84 comparator_body_0.m1_m2_diff_0.m1_m2_array_0/n1_2_10.S 3.01738
R901 comparator_body_0.mref_m5_diff_0.tail.n6 comparator_body_0.m1_m2_diff_0.m1_m2_array_0/n1_2_12.S 3.47694
R902 comparator_body_0.mref_m5_diff_0.tail.n88 comparator_body_0.m1_m2_diff_0.m1_m2_array_2/n1_2_10.S 3.01738
R903 comparator_body_0.mref_m5_diff_0.tail.n87 comparator_body_0.m1_m2_diff_0.m1_m2_array_2/n1_2_0.S 3.01738
R904 comparator_body_0.mref_m5_diff_0.tail.n86 comparator_body_0.m1_m2_diff_0.m1_m2_array_2/n1_2_11.S 3.01738
R905 comparator_body_0.mref_m5_diff_0.tail.n6 comparator_body_0.m1_m2_diff_0.m1_m2_array_3/n1_2_12.S 3.01738
R906 comparator_body_0.mref_m5_diff_0.tail.n6 comparator_body_0.m1_m2_diff_0.m1_m2_array_2/n1_2_12.S 3.01738
R907 comparator_body_0.mref_m5_diff_0.tail.n45 comparator_body_0.m1_m2_diff_0.m1_m2_array_3/n1_2_0.S 3.01738
R908 comparator_body_0.mref_m5_diff_0.tail.n43 comparator_body_0.m1_m2_diff_0.m1_m2_array_3/n1_2_11.S 3.01738
R909 comparator_body_0.mref_m5_diff_0.tail.n19 comparator_body_0.m1_m2_diff_0.m1_m2_array_1/n1_2_15.S 3.01696
R910 comparator_body_0.mref_m5_diff_0.tail.n6 comparator_body_0.m1_m2_diff_0.m1_m2_array_1/n1_2_6.S 3.00226
R911 comparator_body_0.mref_m5_diff_0.tail.n6 comparator_body_0.m1_m2_diff_0.m1_m2_array_1/n1_2_1.S 3.00226
R912 comparator_body_0.mref_m5_diff_0.tail.n10 comparator_body_0.m1_m2_diff_0.m1_m2_array_1/n1_2_9.S 3.00226
R913 comparator_body_0.mref_m5_diff_0.tail.n90 comparator_body_0.m1_m2_diff_0.m1_m2_array_1/n1_2_8.S 3.00226
R914 comparator_body_0.mref_m5_diff_0.tail.n13 comparator_body_0.m1_m2_diff_0.m1_m2_array_1/n1_2_2.S 3.00226
R915 comparator_body_0.mref_m5_diff_0.tail.n24 comparator_body_0.m1_m2_diff_0.m1_m2_array_1/n1_2_5.S 3.00226
R916 comparator_body_0.mref_m5_diff_0.tail.n83 comparator_body_0.m1_m2_diff_0.m1_m2_array_1/n1_2_13.S 3.00226
R917 comparator_body_0.mref_m5_diff_0.tail.n6 comparator_body_0.m1_m2_diff_0.m1_m2_array_0/n1_2_6.S 3.00226
R918 comparator_body_0.mref_m5_diff_0.tail.n6 comparator_body_0.m1_m2_diff_0.m1_m2_array_0/n1_2_1.S 3.00226
R919 comparator_body_0.mref_m5_diff_0.tail.n14 comparator_body_0.m1_m2_diff_0.m1_m2_array_0/n1_2_9.S 3.00226
R920 comparator_body_0.mref_m5_diff_0.tail.n6 comparator_body_0.m1_m2_diff_0.m1_m2_array_0/n1_2_14.S 3.00226
R921 comparator_body_0.mref_m5_diff_0.tail.n6 comparator_body_0.m1_m2_diff_0.m1_m2_array_2/n1_2_6.S 3.00226
R922 comparator_body_0.mref_m5_diff_0.tail.n6 comparator_body_0.m1_m2_diff_0.m1_m2_array_2/n1_2_1.S 3.00226
R923 comparator_body_0.mref_m5_diff_0.tail.n9 comparator_body_0.m1_m2_diff_0.m1_m2_array_2/n1_2_9.S 3.00226
R924 comparator_body_0.mref_m5_diff_0.tail.n6 comparator_body_0.m1_m2_diff_0.m1_m2_array_2/n1_2_14.S 3.00226
R925 comparator_body_0.mref_m5_diff_0.tail.n6 comparator_body_0.m1_m2_diff_0.m1_m2_array_3/n1_2_2.S 3.1514
R926 comparator_body_0.mref_m5_diff_0.tail.n6 comparator_body_0.m1_m2_diff_0.m1_m2_array_3/n1_2_5.S 3.00226
R927 comparator_body_0.mref_m5_diff_0.tail.n3 comparator_body_0.m1_m2_diff_0.m1_m2_array_3/n1_2_13.S 3.00226
R928 comparator_body_0.mref_m5_diff_0.tail.n23 comparator_body_0.m1_m2_diff_0.m1_m2_array_2/n1_2_2.S 3.00226
R929 comparator_body_0.mref_m5_diff_0.tail.n6 comparator_body_0.m1_m2_diff_0.m1_m2_array_2/n1_2_5.S 3.00226
R930 comparator_body_0.mref_m5_diff_0.tail.n6 comparator_body_0.m1_m2_diff_0.m1_m2_array_3/n1_2_6.S 3.00226
R931 comparator_body_0.mref_m5_diff_0.tail.n6 comparator_body_0.m1_m2_diff_0.m1_m2_array_3/n1_2_1.S 3.00226
R932 comparator_body_0.mref_m5_diff_0.tail.n6 comparator_body_0.m1_m2_diff_0.m1_m2_array_3/n1_2_9.S 3.00226
R933 comparator_body_0.mref_m5_diff_0.tail.n6 comparator_body_0.m1_m2_diff_0.m1_m2_array_3/n1_2_14.S 3.00226
R934 comparator_body_0.mref_m5_diff_0.tail.n0 comparator_body_0.m1_m2_diff_0.m1_m2_array_0/n1_2_2.S 3.00226
R935 comparator_body_0.mref_m5_diff_0.tail.n1 comparator_body_0.m1_m2_diff_0.m1_m2_array_0/n1_2_5.S 3.00226
R936 comparator_body_0.m1_m2_diff_0.m1_m2_array_0/n1_2_13.S comparator_body_0.mref_m5_diff_0.tail.t58 2.47757
R937 comparator_body_0.m1_m2_diff_0.m1_m2_array_0/n1_2_5.S comparator_body_0.mref_m5_diff_0.tail.t75 2.47757
R938 comparator_body_0.m1_m2_diff_0.m1_m2_array_0/n1_2_2.S comparator_body_0.mref_m5_diff_0.tail.t59 2.47757
R939 comparator_body_0.m1_m2_diff_0.m1_m2_array_0/n1_2_8.S comparator_body_0.mref_m5_diff_0.tail.t83 2.47757
R940 comparator_body_0.m1_m2_diff_0.m1_m2_array_3/n1_2_14.S comparator_body_0.mref_m5_diff_0.tail.t41 2.47757
R941 comparator_body_0.m1_m2_diff_0.m1_m2_array_3/n1_2_9.S comparator_body_0.mref_m5_diff_0.tail.t67 2.47757
R942 comparator_body_0.m1_m2_diff_0.m1_m2_array_3/n1_2_1.S comparator_body_0.mref_m5_diff_0.tail.t43 2.47757
R943 comparator_body_0.m1_m2_diff_0.m1_m2_array_3/n1_2_6.S comparator_body_0.mref_m5_diff_0.tail.t66 2.47757
R944 comparator_body_0.m1_m2_diff_0.m1_m2_array_2/n1_2_13.S comparator_body_0.mref_m5_diff_0.tail.t54 2.47757
R945 comparator_body_0.m1_m2_diff_0.m1_m2_array_2/n1_2_5.S comparator_body_0.mref_m5_diff_0.tail.t84 2.47757
R946 comparator_body_0.m1_m2_diff_0.m1_m2_array_2/n1_2_2.S comparator_body_0.mref_m5_diff_0.tail.t38 2.47757
R947 comparator_body_0.m1_m2_diff_0.m1_m2_array_2/n1_2_8.S comparator_body_0.mref_m5_diff_0.tail.t95 2.47757
R948 comparator_body_0.m1_m2_diff_0.m1_m2_array_3/n1_2_13.S comparator_body_0.mref_m5_diff_0.tail.t40 2.47757
R949 comparator_body_0.m1_m2_diff_0.m1_m2_array_3/n1_2_5.S comparator_body_0.mref_m5_diff_0.tail.t71 2.47757
R950 comparator_body_0.m1_m2_diff_0.m1_m2_array_3/n1_2_2.S comparator_body_0.mref_m5_diff_0.tail.t42 2.47757
R951 comparator_body_0.m1_m2_diff_0.m1_m2_array_3/n1_2_8.S comparator_body_0.mref_m5_diff_0.tail.t68 2.47757
R952 comparator_body_0.m1_m2_diff_0.m1_m2_array_2/n1_2_14.S comparator_body_0.mref_m5_diff_0.tail.t60 2.47757
R953 comparator_body_0.m1_m2_diff_0.m1_m2_array_2/n1_2_9.S comparator_body_0.mref_m5_diff_0.tail.t69 2.47757
R954 comparator_body_0.m1_m2_diff_0.m1_m2_array_2/n1_2_1.S comparator_body_0.mref_m5_diff_0.tail.t35 2.47757
R955 comparator_body_0.m1_m2_diff_0.m1_m2_array_2/n1_2_6.S comparator_body_0.mref_m5_diff_0.tail.t82 2.47757
R956 comparator_body_0.m1_m2_diff_0.m1_m2_array_0/n1_2_14.S comparator_body_0.mref_m5_diff_0.tail.t51 2.47757
R957 comparator_body_0.m1_m2_diff_0.m1_m2_array_0/n1_2_9.S comparator_body_0.mref_m5_diff_0.tail.t92 2.47757
R958 comparator_body_0.m1_m2_diff_0.m1_m2_array_0/n1_2_1.S comparator_body_0.mref_m5_diff_0.tail.t52 2.47757
R959 comparator_body_0.m1_m2_diff_0.m1_m2_array_0/n1_2_6.S comparator_body_0.mref_m5_diff_0.tail.t79 2.47757
R960 comparator_body_0.m1_m2_diff_0.m1_m2_array_1/n1_2_13.S comparator_body_0.mref_m5_diff_0.tail.t62 2.47757
R961 comparator_body_0.m1_m2_diff_0.m1_m2_array_1/n1_2_5.S comparator_body_0.mref_m5_diff_0.tail.t80 2.47757
R962 comparator_body_0.m1_m2_diff_0.m1_m2_array_1/n1_2_2.S comparator_body_0.mref_m5_diff_0.tail.t44 2.47757
R963 comparator_body_0.m1_m2_diff_0.m1_m2_array_1/n1_2_8.S comparator_body_0.mref_m5_diff_0.tail.t76 2.47757
R964 comparator_body_0.m1_m2_diff_0.m1_m2_array_1/n1_2_14.S comparator_body_0.mref_m5_diff_0.tail.t46 2.47757
R965 comparator_body_0.m1_m2_diff_0.m1_m2_array_1/n1_2_9.S comparator_body_0.mref_m5_diff_0.tail.t78 2.47757
R966 comparator_body_0.m1_m2_diff_0.m1_m2_array_1/n1_2_1.S comparator_body_0.mref_m5_diff_0.tail.t48 2.47757
R967 comparator_body_0.m1_m2_diff_0.m1_m2_array_1/n1_2_6.S comparator_body_0.mref_m5_diff_0.tail.t81 2.47757
R968 comparator_body_0.mref_m5_diff_0.mref_m5_array_0/n1_2$1_15.D comparator_body_0.mref_m5_diff_0.tail.t23 2.46703
R969 comparator_body_0.mref_m5_diff_0.mref_m5_array_0/n1_2$1_6.D comparator_body_0.mref_m5_diff_0.tail.t12 2.46703
R970 comparator_body_0.mref_m5_diff_0.mref_m5_array_0/n1_2$1_12.D comparator_body_0.mref_m5_diff_0.tail.t24 2.46703
R971 comparator_body_0.mref_m5_diff_0.mref_m5_array_1/n1_2$1_6.D comparator_body_0.mref_m5_diff_0.tail.t22 2.46703
R972 comparator_body_0.mref_m5_diff_0.mref_m5_array_1/n1_2$1_15.D comparator_body_0.mref_m5_diff_0.tail.t8 2.46703
R973 comparator_body_0.mref_m5_diff_0.mref_m5_array_1/n1_2$1_5.D comparator_body_0.mref_m5_diff_0.tail.t27 2.46703
R974 comparator_body_0.mref_m5_diff_0.mref_m5_array_1/n1_2$1_12.D comparator_body_0.mref_m5_diff_0.tail.t6 2.46703
R975 comparator_body_0.mref_m5_diff_0.mref_m5_array_0/n1_2$1_5.D comparator_body_0.mref_m5_diff_0.tail.t20 2.46703
R976 comparator_body_0.mref_m5_diff_0.mref_m5_array_3/n1_2$1_15.D comparator_body_0.mref_m5_diff_0.tail.t28 2.46703
R977 comparator_body_0.mref_m5_diff_0.mref_m5_array_2/n1_2$1_15.D comparator_body_0.mref_m5_diff_0.tail.t30 2.46703
R978 comparator_body_0.mref_m5_diff_0.mref_m5_array_2/n1_2$1_5.D comparator_body_0.mref_m5_diff_0.tail.t15 2.46703
R979 comparator_body_0.mref_m5_diff_0.mref_m5_array_2/n1_2$1_6.D comparator_body_0.mref_m5_diff_0.tail.t3 2.46703
R980 comparator_body_0.mref_m5_diff_0.mref_m5_array_2/n1_2$1_12.D comparator_body_0.mref_m5_diff_0.tail.t19 2.46703
R981 comparator_body_0.mref_m5_diff_0.mref_m5_array_3/n1_2$1_5.D comparator_body_0.mref_m5_diff_0.tail.t9 2.46703
R982 comparator_body_0.mref_m5_diff_0.mref_m5_array_3/n1_2$1_6.D comparator_body_0.mref_m5_diff_0.tail.t7 2.46703
R983 comparator_body_0.m1_m2_diff_0.m1_m2_array_0/n1_2_7.S comparator_body_0.mref_m5_diff_0.tail.t55 2.46281
R984 comparator_body_0.m1_m2_diff_0.m1_m2_array_3/n1_2_15.S comparator_body_0.mref_m5_diff_0.tail.t70 2.46281
R985 comparator_body_0.m1_m2_diff_0.m1_m2_array_3/n1_2_11.S comparator_body_0.mref_m5_diff_0.tail.t36 2.46281
R986 comparator_body_0.m1_m2_diff_0.m1_m2_array_3/n1_2_0.S comparator_body_0.mref_m5_diff_0.tail.t65 2.46281
R987 comparator_body_0.m1_m2_diff_0.m1_m2_array_3/n1_2_10.S comparator_body_0.mref_m5_diff_0.tail.t32 2.46281
R988 comparator_body_0.m1_m2_diff_0.m1_m2_array_2/n1_2_12.S comparator_body_0.mref_m5_diff_0.tail.t85 2.46281
R989 comparator_body_0.m1_m2_diff_0.m1_m2_array_3/n1_2_7.S comparator_body_0.mref_m5_diff_0.tail.t33 2.46281
R990 comparator_body_0.m1_m2_diff_0.m1_m2_array_3/n1_2_3.S comparator_body_0.mref_m5_diff_0.tail.t73 2.46281
R991 comparator_body_0.m1_m2_diff_0.m1_m2_array_3/n1_2_4.S comparator_body_0.mref_m5_diff_0.tail.t39 2.46281
R992 comparator_body_0.m1_m2_diff_0.m1_m2_array_3/n1_2_12.S comparator_body_0.mref_m5_diff_0.tail.t72 2.46281
R993 comparator_body_0.m1_m2_diff_0.m1_m2_array_2/n1_2_7.S comparator_body_0.mref_m5_diff_0.tail.t34 2.46281
R994 comparator_body_0.m1_m2_diff_0.m1_m2_array_2/n1_2_3.S comparator_body_0.mref_m5_diff_0.tail.t64 2.46281
R995 comparator_body_0.m1_m2_diff_0.m1_m2_array_2/n1_2_4.S comparator_body_0.mref_m5_diff_0.tail.t56 2.46281
R996 comparator_body_0.m1_m2_diff_0.m1_m2_array_2/n1_2_15.S comparator_body_0.mref_m5_diff_0.tail.t91 2.46281
R997 comparator_body_0.m1_m2_diff_0.m1_m2_array_2/n1_2_11.S comparator_body_0.mref_m5_diff_0.tail.t63 2.46281
R998 comparator_body_0.m1_m2_diff_0.m1_m2_array_2/n1_2_0.S comparator_body_0.mref_m5_diff_0.tail.t94 2.46281
R999 comparator_body_0.m1_m2_diff_0.m1_m2_array_2/n1_2_10.S comparator_body_0.mref_m5_diff_0.tail.t37 2.46281
R1000 comparator_body_0.m1_m2_diff_0.m1_m2_array_0/n1_2_12.S comparator_body_0.mref_m5_diff_0.tail.t89 2.46281
R1001 comparator_body_0.m1_m2_diff_0.m1_m2_array_0/n1_2_4.S comparator_body_0.mref_m5_diff_0.tail.t49 2.46281
R1002 comparator_body_0.m1_m2_diff_0.m1_m2_array_0/n1_2_3.S comparator_body_0.mref_m5_diff_0.tail.t93 2.46281
R1003 comparator_body_0.m1_m2_diff_0.m1_m2_array_0/n1_2_15.S comparator_body_0.mref_m5_diff_0.tail.t88 2.46281
R1004 comparator_body_0.m1_m2_diff_0.m1_m2_array_0/n1_2_11.S comparator_body_0.mref_m5_diff_0.tail.t57 2.46281
R1005 comparator_body_0.m1_m2_diff_0.m1_m2_array_0/n1_2_0.S comparator_body_0.mref_m5_diff_0.tail.t90 2.46281
R1006 comparator_body_0.m1_m2_diff_0.m1_m2_array_0/n1_2_10.S comparator_body_0.mref_m5_diff_0.tail.t61 2.46281
R1007 comparator_body_0.m1_m2_diff_0.m1_m2_array_1/n1_2_12.S comparator_body_0.mref_m5_diff_0.tail.t74 2.46281
R1008 comparator_body_0.m1_m2_diff_0.m1_m2_array_1/n1_2_7.S comparator_body_0.mref_m5_diff_0.tail.t45 2.46281
R1009 comparator_body_0.m1_m2_diff_0.m1_m2_array_1/n1_2_3.S comparator_body_0.mref_m5_diff_0.tail.t87 2.46281
R1010 comparator_body_0.m1_m2_diff_0.m1_m2_array_1/n1_2_4.S comparator_body_0.mref_m5_diff_0.tail.t47 2.46281
R1011 comparator_body_0.m1_m2_diff_0.m1_m2_array_1/n1_2_11.S comparator_body_0.mref_m5_diff_0.tail.t53 2.46281
R1012 comparator_body_0.m1_m2_diff_0.m1_m2_array_1/n1_2_0.S comparator_body_0.mref_m5_diff_0.tail.t77 2.46281
R1013 comparator_body_0.m1_m2_diff_0.m1_m2_array_1/n1_2_10.S comparator_body_0.mref_m5_diff_0.tail.t50 2.46281
R1014 comparator_body_0.m1_m2_diff_0.m1_m2_array_1/n1_2_15.S comparator_body_0.mref_m5_diff_0.tail.t86 2.46277
R1015 comparator_body_0.mref_m5_diff_0.mref_m5_array_0/n1_2$1_11.D comparator_body_0.mref_m5_diff_0.tail.t26 2.45485
R1016 comparator_body_0.mref_m5_diff_0.mref_m5_array_0/n1_2$1_2.D comparator_body_0.mref_m5_diff_0.tail.t17 2.45485
R1017 comparator_body_0.mref_m5_diff_0.mref_m5_array_1/n1_2$1_11.D comparator_body_0.mref_m5_diff_0.tail.t13 2.45485
R1018 comparator_body_0.mref_m5_diff_0.mref_m5_array_1/n1_2$1_2.D comparator_body_0.mref_m5_diff_0.tail.t2 2.45485
R1019 comparator_body_0.mref_m5_diff_0.mref_m5_array_1/n1_2$1_8.D comparator_body_0.mref_m5_diff_0.tail.t1 2.45485
R1020 comparator_body_0.mref_m5_diff_0.mref_m5_array_0/n1_2$1_8.D comparator_body_0.mref_m5_diff_0.tail.t11 2.45485
R1021 comparator_body_0.mref_m5_diff_0.mref_m5_array_0/n1_2$1_3.D comparator_body_0.mref_m5_diff_0.tail.t25 2.45485
R1022 comparator_body_0.mref_m5_diff_0.mref_m5_array_3/n1_2$1_11.D comparator_body_0.mref_m5_diff_0.tail.t21 2.45485
R1023 comparator_body_0.mref_m5_diff_0.mref_m5_array_3/n1_2$1_2.D comparator_body_0.mref_m5_diff_0.tail.t14 2.45485
R1024 comparator_body_0.mref_m5_diff_0.mref_m5_array_2/n1_2$1_11.D comparator_body_0.mref_m5_diff_0.tail.t10 2.45485
R1025 comparator_body_0.mref_m5_diff_0.mref_m5_array_2/n1_2$1_2.D comparator_body_0.mref_m5_diff_0.tail.t4 2.45485
R1026 comparator_body_0.mref_m5_diff_0.mref_m5_array_2/n1_2$1_8.D comparator_body_0.mref_m5_diff_0.tail.t16 2.45485
R1027 comparator_body_0.mref_m5_diff_0.mref_m5_array_2/n1_2$1_3.D comparator_body_0.mref_m5_diff_0.tail.t31 2.45485
R1028 comparator_body_0.mref_m5_diff_0.mref_m5_array_3/n1_2$1_8.D comparator_body_0.mref_m5_diff_0.tail.t5 2.45485
R1029 comparator_body_0.mref_m5_diff_0.mref_m5_array_3/n1_2$1_3.D comparator_body_0.mref_m5_diff_0.tail.t29 2.45485
R1030 comparator_body_0.mref_m5_diff_0.mref_m5_array_1/n1_2$1_3.D comparator_body_0.mref_m5_diff_0.tail.t18 2.45485
R1031 comparator_body_0.mref_m5_diff_0.tail.n53 comparator_body_0.mref_m5_diff_0.mref_m5_array_2/n1_2$1_11.D 2.04455
R1032 comparator_body_0.mref_m5_diff_0.tail.n106 comparator_body_0.mref_m5_diff_0.mref_m5_array_3/n1_2$1_11.D 2.04455
R1033 comparator_body_0.mref_m5_diff_0.tail.n101 comparator_body_0.mref_m5_diff_0.mref_m5_array_1/n1_2$1_11.D 2.04455
R1034 comparator_body_0.mref_m5_diff_0.tail.n74 comparator_body_0.mref_m5_diff_0.mref_m5_array_0/n1_2$1_11.D 2.04455
R1035 comparator_body_0.mref_m5_diff_0.tail.n56 comparator_body_0.mref_m5_diff_0.mref_m5_array_2/n1_2$1_15.D 2.03194
R1036 comparator_body_0.mref_m5_diff_0.tail.n104 comparator_body_0.mref_m5_diff_0.mref_m5_array_3/n1_2$1_15.D 2.03194
R1037 comparator_body_0.mref_m5_diff_0.tail.n59 comparator_body_0.mref_m5_diff_0.mref_m5_array_1/n1_2$1_15.D 2.03194
R1038 comparator_body_0.mref_m5_diff_0.tail.n72 comparator_body_0.mref_m5_diff_0.mref_m5_array_0/n1_2$1_15.D 2.03194
R1039 comparator_body_0.mref_m5_diff_0.tail.n89 comparator_body_0.mref_m5_diff_0.mref_m5_array_1/n1_2$1_3.D 1.52623
R1040 comparator_body_0.mref_m5_diff_0.tail.n116 comparator_body_0.mref_m5_diff_0.mref_m5_array_3/n1_2$1_3.D 1.52623
R1041 comparator_body_0.mref_m5_diff_0.tail.n46 comparator_body_0.mref_m5_diff_0.mref_m5_array_2/n1_2$1_3.D 1.52623
R1042 comparator_body_0.mref_m5_diff_0.tail.n92 comparator_body_0.mref_m5_diff_0.mref_m5_array_0/n1_2$1_3.D 1.52623
R1043 comparator_body_0.mref_m5_diff_0.tail.n35 comparator_body_0.mref_m5_diff_0.mref_m5_array_3/n1_2$1_8.D 1.52535
R1044 comparator_body_0.mref_m5_diff_0.tail.n37 comparator_body_0.mref_m5_diff_0.mref_m5_array_2/n1_2$1_8.D 1.52535
R1045 comparator_body_0.mref_m5_diff_0.tail.n51 comparator_body_0.mref_m5_diff_0.mref_m5_array_2/n1_2$1_2.D 1.52535
R1046 comparator_body_0.mref_m5_diff_0.tail.n57 comparator_body_0.mref_m5_diff_0.mref_m5_array_3/n1_2$1_2.D 1.52535
R1047 comparator_body_0.mref_m5_diff_0.tail.n27 comparator_body_0.mref_m5_diff_0.mref_m5_array_0/n1_2$1_8.D 1.52535
R1048 comparator_body_0.mref_m5_diff_0.tail.n31 comparator_body_0.mref_m5_diff_0.mref_m5_array_1/n1_2$1_8.D 1.52535
R1049 comparator_body_0.mref_m5_diff_0.tail.n58 comparator_body_0.mref_m5_diff_0.mref_m5_array_1/n1_2$1_2.D 1.52535
R1050 comparator_body_0.mref_m5_diff_0.tail.n76 comparator_body_0.mref_m5_diff_0.mref_m5_array_0/n1_2$1_2.D 1.52535
R1051 comparator_body_0.mref_m5_diff_0.mref_m5_array_3/n1_2$1_12.D comparator_body_0.mref_m5_diff_0.tail.n120 1.52106
R1052 comparator_body_0.mref_m5_diff_0.tail.n85 comparator_body_0.mref_m5_diff_0.mref_m5_array_3/n1_2$1_6.D 1.51362
R1053 comparator_body_0.mref_m5_diff_0.tail.n114 comparator_body_0.mref_m5_diff_0.mref_m5_array_2/n1_2$1_6.D 1.51362
R1054 comparator_body_0.mref_m5_diff_0.tail.n17 comparator_body_0.mref_m5_diff_0.mref_m5_array_1/n1_2$1_6.D 1.51362
R1055 comparator_body_0.mref_m5_diff_0.tail.n81 comparator_body_0.mref_m5_diff_0.mref_m5_array_0/n1_2$1_6.D 1.51362
R1056 comparator_body_0.mref_m5_diff_0.tail.n33 comparator_body_0.mref_m5_diff_0.mref_m5_array_3/n1_2$1_5.D 1.51274
R1057 comparator_body_0.mref_m5_diff_0.tail.n111 comparator_body_0.mref_m5_diff_0.mref_m5_array_2/n1_2$1_12.D 1.51274
R1058 comparator_body_0.mref_m5_diff_0.tail.n54 comparator_body_0.mref_m5_diff_0.mref_m5_array_2/n1_2$1_5.D 1.51274
R1059 comparator_body_0.mref_m5_diff_0.tail.n25 comparator_body_0.mref_m5_diff_0.mref_m5_array_0/n1_2$1_5.D 1.51274
R1060 comparator_body_0.mref_m5_diff_0.tail.n95 comparator_body_0.mref_m5_diff_0.mref_m5_array_1/n1_2$1_12.D 1.51274
R1061 comparator_body_0.mref_m5_diff_0.tail.n99 comparator_body_0.mref_m5_diff_0.mref_m5_array_1/n1_2$1_5.D 1.51274
R1062 comparator_body_0.mref_m5_diff_0.tail.n78 comparator_body_0.mref_m5_diff_0.mref_m5_array_0/n1_2$1_12.D 1.51274
R1063 comparator_body_0.mref_m5_diff_0.tail.n72 comparator_body_0.mref_m5_diff_0.tail.n70 1.46922
R1064 comparator_body_0.mref_m5_diff_0.tail.n49 comparator_body_0.mref_m5_diff_0.tail.n48 1.43754
R1065 comparator_body_0.mref_m5_diff_0.tail.n80 comparator_body_0.mref_m5_diff_0.tail.n79 1.3557
R1066 comparator_body_0.mref_m5_diff_0.tail.n75 comparator_body_0.mref_m5_diff_0.tail.n74 1.3557
R1067 comparator_body_0.mref_m5_diff_0.tail.n97 comparator_body_0.mref_m5_diff_0.tail.n96 1.3557
R1068 comparator_body_0.mref_m5_diff_0.tail.n102 comparator_body_0.mref_m5_diff_0.tail.n101 1.3557
R1069 comparator_body_0.mref_m5_diff_0.tail.n107 comparator_body_0.mref_m5_diff_0.tail.n106 1.3557
R1070 comparator_body_0.mref_m5_diff_0.tail.n113 comparator_body_0.mref_m5_diff_0.tail.n112 1.3557
R1071 comparator_body_0.mref_m5_diff_0.tail.n53 comparator_body_0.mref_m5_diff_0.tail.n52 1.3557
R1072 comparator_body_0.mref_m5_diff_0.tail.n41 comparator_body_0.mref_m5_diff_0.tail.n39 1.3557
R1073 comparator_body_0.mref_m5_diff_0.tail.n20 comparator_body_0.mref_m5_diff_0.tail.n83 1.20056
R1074 comparator_body_0.m1_m2_diff_0.m1_m2_array_0/n1_2_13.S comparator_body_0.mref_m5_diff_0.tail.n6 3.1331
R1075 comparator_body_0.mref_m5_diff_0.tail.n64 comparator_body_0.mref_m5_diff_0.tail.n10 1.15699
R1076 comparator_body_0.mref_m5_diff_0.tail.n14 comparator_body_0.mref_m5_diff_0.tail.n84 1.15699
R1077 comparator_body_0.mref_m5_diff_0.tail.n88 comparator_body_0.mref_m5_diff_0.tail.n9 1.15699
R1078 comparator_body_0.mref_m5_diff_0.tail.n7 comparator_body_0.m1_m2_diff_0.m1_m2_array_3/n1_2_10.S 3.2398
R1079 comparator_body_0.mref_m5_diff_0.tail.n79 comparator_body_0.mref_m5_diff_0.tail.n70 1.07322
R1080 comparator_body_0.mref_m5_diff_0.tail.n52 comparator_body_0.mref_m5_diff_0.tail.n49 1.05738
R1081 comparator_body_0.m1_m2_diff_0.m1_m2_array_2/n1_2_13.S comparator_body_0.mref_m5_diff_0.tail.n2 3.21614
R1082 comparator_body_0.mref_m5_diff_0.tail.n119 comparator_body_0.mref_m5_diff_0.tail.n36 0.9597
R1083 comparator_body_0.mref_m5_diff_0.tail.n77 comparator_body_0.mref_m5_diff_0.tail.n28 0.9597
R1084 comparator_body_0.mref_m5_diff_0.tail.n32 comparator_body_0.mref_m5_diff_0.tail.n29 0.9597
R1085 comparator_body_0.mref_m5_diff_0.tail.n110 comparator_body_0.mref_m5_diff_0.tail.n38 0.9597
R1086 comparator_body_0.mref_m5_diff_0.tail.n28 comparator_body_0.mref_m5_diff_0.tail.n26 0.95794
R1087 comparator_body_0.mref_m5_diff_0.tail.n32 comparator_body_0.mref_m5_diff_0.tail.n30 0.95794
R1088 comparator_body_0.mref_m5_diff_0.tail.n36 comparator_body_0.mref_m5_diff_0.tail.n34 0.95794
R1089 comparator_body_0.mref_m5_diff_0.tail.n50 comparator_body_0.mref_m5_diff_0.tail.n38 0.95794
R1090 comparator_body_0.mref_m5_diff_0.tail.n119 comparator_body_0.mref_m5_diff_0.tail.n40 0.9553
R1091 comparator_body_0.mref_m5_diff_0.tail.n77 comparator_body_0.mref_m5_diff_0.tail.n70 0.9553
R1092 comparator_body_0.mref_m5_diff_0.tail.n62 comparator_body_0.mref_m5_diff_0.tail.n29 0.9553
R1093 comparator_body_0.mref_m5_diff_0.tail.n71 comparator_body_0.mref_m5_diff_0.tail.n59 0.9553
R1094 comparator_body_0.mref_m5_diff_0.tail.n104 comparator_body_0.mref_m5_diff_0.tail.n103 0.9553
R1095 comparator_body_0.mref_m5_diff_0.tail.n110 comparator_body_0.mref_m5_diff_0.tail.n109 0.9553
R1096 comparator_body_0.mref_m5_diff_0.tail.n108 comparator_body_0.mref_m5_diff_0.tail.n56 0.9553
R1097 comparator_body_0.mref_m5_diff_0.tail.n26 comparator_body_0.mref_m5_diff_0.tail.n62 0.93946
R1098 comparator_body_0.mref_m5_diff_0.tail.n30 comparator_body_0.mref_m5_diff_0.tail.n40 0.93946
R1099 comparator_body_0.mref_m5_diff_0.tail.n109 comparator_body_0.mref_m5_diff_0.tail.n34 0.93946
R1100 comparator_body_0.mref_m5_diff_0.tail.n50 comparator_body_0.mref_m5_diff_0.tail.n49 0.93946
R1101 comparator_body_0.mref_m5_diff_0.tail.n61 comparator_body_0.mref_m5_diff_0.tail.n60 0.92362
R1102 comparator_body_0.mref_m5_diff_0.tail.n94 comparator_body_0.mref_m5_diff_0.tail.n93 0.92362
R1103 comparator_body_0.mref_m5_diff_0.tail.n117 comparator_body_0.mref_m5_diff_0.tail.n42 0.92362
R1104 comparator_body_0.m1_m2_diff_0.m1_m2_array_0/n1_2_8.S comparator_body_0.mref_m5_diff_0.tail.n6 3.26694
R1105 comparator_body_0.mref_m5_diff_0.tail.n16 comparator_body_0.m1_m2_diff_0.m1_m2_array_2/n1_2_8.S 3.28899
R1106 comparator_body_0.m1_m2_diff_0.m1_m2_array_3/n1_2_8.S comparator_body_0.mref_m5_diff_0.tail.n6 3.31599
R1107 comparator_body_0.mref_m5_diff_0.tail.n14 comparator_body_0.mref_m5_diff_0.tail.n6 0.201428
R1108 comparator_body_0.mref_m5_diff_0.tail.n6 comparator_body_0.mref_m5_diff_0.tail.n1 0.134237
R1109 comparator_body_0.mref_m5_diff_0.tail.n12 comparator_body_0.mref_m5_diff_0.tail.n13 0.226949
R1110 comparator_body_0.mref_m5_diff_0.tail.n19 comparator_body_0.mref_m5_diff_0.tail.n69 0.782916
R1111 comparator_body_0.mref_m5_diff_0.tail.n6 comparator_body_0.m1_m2_diff_0.m1_m2_array_0/n1_2_15.S 3.33028
R1112 comparator_body_0.mref_m5_diff_0.tail.n8 comparator_body_0.m1_m2_diff_0.m1_m2_array_2/n1_2_15.S 3.33126
R1113 comparator_body_0.mref_m5_diff_0.tail.n43 comparator_body_0.mref_m5_diff_0.tail.n15 0.474721
R1114 comparator_body_0.mref_m5_diff_0.tail.n82 comparator_body_0.mref_m5_diff_0.tail.n24 0.76549
R1115 comparator_body_0.mref_m5_diff_0.tail.n20 comparator_body_0.mref_m5_diff_0.tail.n22 0.74674
R1116 comparator_body_0.mref_m5_diff_0.tail.n68 comparator_body_0.mref_m5_diff_0.tail.n67 0.736738
R1117 comparator_body_0.mref_m5_diff_0.tail.n6 comparator_body_0.m1_m2_diff_0.m1_m2_array_0/n1_2_11.S 3.2259
R1118 comparator_body_0.mref_m5_diff_0.tail.n4 comparator_body_0.mref_m5_diff_0.tail.n86 0.736738
R1119 comparator_body_0.mref_m5_diff_0.tail.n44 comparator_body_0.mref_m5_diff_0.tail.n43 0.736738
R1120 comparator_body_0.mref_m5_diff_0.tail.n6 comparator_body_0.m1_m2_diff_0.m1_m2_array_0/n1_2_4.S 3.15002
R1121 comparator_body_0.mref_m5_diff_0.tail.n66 comparator_body_0.mref_m5_diff_0.tail.n65 0.694916
R1122 comparator_body_0.mref_m5_diff_0.tail.n11 comparator_body_0.m1_m2_diff_0.m1_m2_array_0/n1_2_0.S 3.24084
R1123 comparator_body_0.mref_m5_diff_0.tail.n5 comparator_body_0.mref_m5_diff_0.tail.n87 0.694916
R1124 comparator_body_0.mref_m5_diff_0.tail.n7 comparator_body_0.mref_m5_diff_0.tail.n45 0.785418
R1125 comparator_body_0.mref_m5_diff_0.tail.n21 comparator_body_0.mref_m5_diff_0.tail.n6 0.230649
R1126 comparator_body_0.mref_m5_diff_0.tail.n21 comparator_body_0.mref_m5_diff_0.tail.n19 0.673421
R1127 comparator_body_0.mref_m5_diff_0.tail.n91 comparator_body_0.mref_m5_diff_0.tail.n90 0.651351
R1128 comparator_body_0.mref_m5_diff_0.tail.n6 comparator_body_0.mref_m5_diff_0.tail.n0 0.17416
R1129 comparator_body_0.mref_m5_diff_0.tail.n90 comparator_body_0.mref_m5_diff_0.tail.n6 0.632488
R1130 comparator_body_0.mref_m5_diff_0.tail.n115 comparator_body_0.mref_m5_diff_0.tail.n6 0.613015
R1131 comparator_body_0.mref_m5_diff_0.tail.n93 comparator_body_0.mref_m5_diff_0.tail.n63 0.57778
R1132 comparator_body_0.mref_m5_diff_0.tail.n98 comparator_body_0.mref_m5_diff_0.tail.n61 0.57778
R1133 comparator_body_0.mref_m5_diff_0.tail.n118 comparator_body_0.mref_m5_diff_0.tail.n117 0.57778
R1134 comparator_body_0.mref_m5_diff_0.tail.n48 comparator_body_0.mref_m5_diff_0.tail.n47 0.57778
R1135 comparator_body_0.mref_m5_diff_0.tail.n38 comparator_body_0.mref_m5_diff_0.tail.n37 0.5769
R1136 comparator_body_0.mref_m5_diff_0.tail.n36 comparator_body_0.mref_m5_diff_0.tail.n35 0.5769
R1137 comparator_body_0.mref_m5_diff_0.tail.n32 comparator_body_0.mref_m5_diff_0.tail.n31 0.5769
R1138 comparator_body_0.mref_m5_diff_0.tail.n28 comparator_body_0.mref_m5_diff_0.tail.n27 0.5769
R1139 comparator_body_0.mref_m5_diff_0.tail.n73 comparator_body_0.mref_m5_diff_0.tail.n72 0.5637
R1140 comparator_body_0.mref_m5_diff_0.tail.n100 comparator_body_0.mref_m5_diff_0.tail.n59 0.5637
R1141 comparator_body_0.mref_m5_diff_0.tail.n105 comparator_body_0.mref_m5_diff_0.tail.n104 0.5637
R1142 comparator_body_0.mref_m5_diff_0.tail.n56 comparator_body_0.mref_m5_diff_0.tail.n55 0.5637
R1143 comparator_body_0.mref_m5_diff_0.tail.n60 comparator_body_0.mref_m5_diff_0.tail.n39 0.5593
R1144 comparator_body_0.mref_m5_diff_0.tail.n96 comparator_body_0.mref_m5_diff_0.tail.n94 0.5593
R1145 comparator_body_0.mref_m5_diff_0.tail.n112 comparator_body_0.mref_m5_diff_0.tail.n42 0.5593
R1146 comparator_body_0.mref_m5_diff_0.tail.n75 comparator_body_0.mref_m5_diff_0.tail.n71 0.54346
R1147 comparator_body_0.mref_m5_diff_0.tail.n103 comparator_body_0.mref_m5_diff_0.tail.n102 0.54346
R1148 comparator_body_0.mref_m5_diff_0.tail.n108 comparator_body_0.mref_m5_diff_0.tail.n107 0.54346
R1149 comparator_body_0.mref_m5_diff_0.tail.n120 comparator_body_0.mref_m5_diff_0.tail.n119 0.52058
R1150 comparator_body_0.mref_m5_diff_0.tail.n78 comparator_body_0.mref_m5_diff_0.tail.n77 0.52058
R1151 comparator_body_0.mref_m5_diff_0.tail.n95 comparator_body_0.mref_m5_diff_0.tail.n29 0.52058
R1152 comparator_body_0.mref_m5_diff_0.tail.n111 comparator_body_0.mref_m5_diff_0.tail.n110 0.52058
R1153 comparator_body_0.mref_m5_diff_0.tail.n28 comparator_body_0.mref_m5_diff_0.tail.n25 0.5197
R1154 comparator_body_0.mref_m5_diff_0.tail.n26 comparator_body_0.mref_m5_diff_0.tail.n76 0.5197
R1155 comparator_body_0.mref_m5_diff_0.tail.n99 comparator_body_0.mref_m5_diff_0.tail.n32 0.5197
R1156 comparator_body_0.mref_m5_diff_0.tail.n30 comparator_body_0.mref_m5_diff_0.tail.n58 0.5197
R1157 comparator_body_0.mref_m5_diff_0.tail.n36 comparator_body_0.mref_m5_diff_0.tail.n33 0.5197
R1158 comparator_body_0.mref_m5_diff_0.tail.n57 comparator_body_0.mref_m5_diff_0.tail.n34 0.5197
R1159 comparator_body_0.mref_m5_diff_0.tail.n54 comparator_body_0.mref_m5_diff_0.tail.n38 0.5197
R1160 comparator_body_0.mref_m5_diff_0.tail.n51 comparator_body_0.mref_m5_diff_0.tail.n50 0.5197
R1161 comparator_body_0.mref_m5_diff_0.tail.n114 comparator_body_0.mref_m5_diff_0.tail.n113 0.51354
R1162 comparator_body_0.mref_m5_diff_0.tail.n81 comparator_body_0.mref_m5_diff_0.tail.n80 0.50826
R1163 comparator_body_0.mref_m5_diff_0.tail.n85 comparator_body_0.mref_m5_diff_0.tail.n41 0.49858
R1164 comparator_body_0.mref_m5_diff_0.tail.n97 comparator_body_0.mref_m5_diff_0.tail.n17 0.49242
R1165 comparator_body_0.mref_m5_diff_0.tail.n82 comparator_body_0.mref_m5_diff_0.tail.n22 0.47042
R1166 comparator_body_0.mref_m5_diff_0.tail.n24 comparator_body_0.mref_m5_diff_0.tail.n12 0.496177
R1167 comparator_body_0.mref_m5_diff_0.tail.n23 comparator_body_0.mref_m5_diff_0.tail.n16 0.213834
R1168 comparator_body_0.mref_m5_diff_0.tail.n69 comparator_body_0.mref_m5_diff_0.tail.n6 0.46954
R1169 comparator_body_0.mref_m5_diff_0.tail.n65 comparator_body_0.mref_m5_diff_0.tail.n6 0.46954
R1170 comparator_body_0.mref_m5_diff_0.tail.n67 comparator_body_0.mref_m5_diff_0.tail.n6 0.46954
R1171 comparator_body_0.mref_m5_diff_0.tail.n84 comparator_body_0.mref_m5_diff_0.tail.n11 0.577045
R1172 comparator_body_0.mref_m5_diff_0.tail.n6 comparator_body_0.mref_m5_diff_0.tail.n5 0.46954
R1173 comparator_body_0.mref_m5_diff_0.tail.n6 comparator_body_0.mref_m5_diff_0.tail.n4 0.46954
R1174 comparator_body_0.mref_m5_diff_0.tail.n7 comparator_body_0.mref_m5_diff_0.tail.n6 0.270668
R1175 comparator_body_0.mref_m5_diff_0.tail.n44 comparator_body_0.mref_m5_diff_0.tail.n6 0.46954
R1176 comparator_body_0.mref_m5_diff_0.tail.n48 comparator_body_0.mref_m5_diff_0.tail.n46 0.46074
R1177 comparator_body_0.mref_m5_diff_0.tail.n89 comparator_body_0.mref_m5_diff_0.tail.n61 0.45722
R1178 comparator_body_0.mref_m5_diff_0.tail.n80 comparator_body_0.mref_m5_diff_0.tail.n63 0.45458
R1179 comparator_body_0.mref_m5_diff_0.tail.n98 comparator_body_0.mref_m5_diff_0.tail.n97 0.45458
R1180 comparator_body_0.mref_m5_diff_0.tail.n113 comparator_body_0.mref_m5_diff_0.tail.n47 0.45458
R1181 comparator_body_0.mref_m5_diff_0.tail.n118 comparator_body_0.mref_m5_diff_0.tail.n41 0.45458
R1182 comparator_body_0.mref_m5_diff_0.tail.n74 comparator_body_0.mref_m5_diff_0.tail.n73 0.45282
R1183 comparator_body_0.mref_m5_diff_0.tail.n101 comparator_body_0.mref_m5_diff_0.tail.n100 0.45282
R1184 comparator_body_0.mref_m5_diff_0.tail.n106 comparator_body_0.mref_m5_diff_0.tail.n105 0.45282
R1185 comparator_body_0.mref_m5_diff_0.tail.n55 comparator_body_0.mref_m5_diff_0.tail.n53 0.45282
R1186 comparator_body_0.mref_m5_diff_0.tail.n93 comparator_body_0.mref_m5_diff_0.tail.n92 0.45106
R1187 comparator_body_0.mref_m5_diff_0.tail.n91 comparator_body_0.mref_m5_diff_0.tail.n13 0.430045
R1188 comparator_body_0.mref_m5_diff_0.tail.n115 comparator_body_0.mref_m5_diff_0.tail.n23 0.426559
R1189 comparator_body_0.mref_m5_diff_0.tail.n117 comparator_body_0.mref_m5_diff_0.tail.n116 0.42642
R1190 comparator_body_0.mref_m5_diff_0.tail.n18 comparator_body_0.mref_m5_diff_0.tail.n22 0.0772902
R1191 comparator_body_0.mref_m5_diff_0.tail.n65 comparator_body_0.mref_m5_diff_0.tail.n64 0.38648
R1192 comparator_body_0.mref_m5_diff_0.tail.n5 comparator_body_0.mref_m5_diff_0.tail.n88 0.38648
R1193 comparator_body_0.mref_m5_diff_0.tail.n21 comparator_body_0.mref_m5_diff_0.tail.n20 0.3657
R1194 comparator_body_0.m1_m2_diff_0.tail comparator_body_0.mref_m5_diff_0.tail.n2 0.20886
R1195 comparator_body_0.mref_m5_diff_0.tail.n6 comparator_body_0.m1_m2_diff_0.m1_m2_array_0/n1_2_7.S 3.19528
R1196 comparator_body_0.mref_m5_diff_0.tail.n6 comparator_body_0.m1_m2_diff_0.m1_m2_array_1/n1_2_7.S 3.19528
R1197 comparator_body_0.m1_m2_diff_0.m1_m2_array_2/n1_2_7.S comparator_body_0.mref_m5_diff_0.tail.n6 3.19528
R1198 comparator_body_0.m1_m2_diff_0.m1_m2_array_3/n1_2_7.S comparator_body_0.mref_m5_diff_0.tail.n6 3.17074
R1199 comparator_body_0.mref_m5_diff_0.tail.n67 comparator_body_0.mref_m5_diff_0.tail.n66 0.344658
R1200 comparator_body_0.mref_m5_diff_0.tail.n87 comparator_body_0.mref_m5_diff_0.tail.n4 0.344658
R1201 comparator_body_0.mref_m5_diff_0.tail.n45 comparator_body_0.mref_m5_diff_0.tail.n44 0.344658
R1202 comparator_body_0.mref_m5_diff_0.tail.n15 comparator_body_0.m1_m2_diff_0.m1_m2_array_3/n1_2_15.S 3.3314
R1203 comparator_body_0.mref_m5_diff_0.tail.n6 comparator_body_0.m1_m2_diff_0.m1_m2_array_1/n1_2_3.S 3.15779
R1204 comparator_body_0.mref_m5_diff_0.tail.n27 comparator_body_0.mref_m5_diff_0.tail.n63 0.3041
R1205 comparator_body_0.mref_m5_diff_0.tail.n31 comparator_body_0.mref_m5_diff_0.tail.n98 0.3041
R1206 comparator_body_0.m1_m2_diff_0.m1_m2_array_0/n1_2_3.S comparator_body_0.mref_m5_diff_0.tail.n6 3.15779
R1207 comparator_body_0.mref_m5_diff_0.tail.n6 comparator_body_0.m1_m2_diff_0.m1_m2_array_2/n1_2_3.S 3.15779
R1208 comparator_body_0.mref_m5_diff_0.tail.n35 comparator_body_0.mref_m5_diff_0.tail.n118 0.3041
R1209 comparator_body_0.m1_m2_diff_0.m1_m2_array_3/n1_2_3.S comparator_body_0.mref_m5_diff_0.tail.n6 3.15779
R1210 comparator_body_0.mref_m5_diff_0.tail.n37 comparator_body_0.mref_m5_diff_0.tail.n47 0.3041
R1211 comparator_body_0.mref_m5_diff_0.tail.n73 comparator_body_0.mref_m5_diff_0.tail.n25 0.30322
R1212 comparator_body_0.mref_m5_diff_0.tail.n76 comparator_body_0.mref_m5_diff_0.tail.n75 0.30322
R1213 comparator_body_0.mref_m5_diff_0.tail.n100 comparator_body_0.mref_m5_diff_0.tail.n99 0.30322
R1214 comparator_body_0.mref_m5_diff_0.tail.n102 comparator_body_0.mref_m5_diff_0.tail.n58 0.30322
R1215 comparator_body_0.mref_m5_diff_0.tail.n105 comparator_body_0.mref_m5_diff_0.tail.n33 0.30322
R1216 comparator_body_0.mref_m5_diff_0.tail.n107 comparator_body_0.mref_m5_diff_0.tail.n57 0.30322
R1217 comparator_body_0.mref_m5_diff_0.tail.n55 comparator_body_0.mref_m5_diff_0.tail.n54 0.30322
R1218 comparator_body_0.mref_m5_diff_0.tail.n52 comparator_body_0.mref_m5_diff_0.tail.n51 0.30322
R1219 comparator_body_0.mref_m5_diff_0.tail.n79 comparator_body_0.mref_m5_diff_0.tail.n78 0.30234
R1220 comparator_body_0.mref_m5_diff_0.tail.n96 comparator_body_0.mref_m5_diff_0.tail.n95 0.30234
R1221 comparator_body_0.mref_m5_diff_0.tail.n112 comparator_body_0.mref_m5_diff_0.tail.n111 0.30234
R1222 comparator_body_0.mref_m5_diff_0.tail.n120 comparator_body_0.mref_m5_diff_0.tail.n39 0.30234
R1223 comparator_body_0.mref_m5_diff_0.tail.n69 comparator_body_0.mref_m5_diff_0.tail.n68 0.29848
R1224 comparator_body_0.mref_m5_diff_0.tail.n86 comparator_body_0.mref_m5_diff_0.tail.n8 0.474775
R1225 comparator_body_0.mref_m5_diff_0.tail.n60 comparator_body_0.mref_m5_diff_0.tail.n40 0.25746
R1226 comparator_body_0.mref_m5_diff_0.tail.n103 comparator_body_0.mref_m5_diff_0.tail.n40 0.25746
R1227 comparator_body_0.mref_m5_diff_0.tail.n18 comparator_body_0.m1_m2_diff_0.m1_m2_array_1/n1_2_4.S 3.15002
R1228 comparator_body_0.mref_m5_diff_0.tail.n94 comparator_body_0.mref_m5_diff_0.tail.n62 0.25746
R1229 comparator_body_0.mref_m5_diff_0.tail.n71 comparator_body_0.mref_m5_diff_0.tail.n62 0.25746
R1230 comparator_body_0.m1_m2_diff_0.m1_m2_array_2/n1_2_4.S comparator_body_0.mref_m5_diff_0.tail.n6 3.37712
R1231 comparator_body_0.mref_m5_diff_0.tail.n109 comparator_body_0.mref_m5_diff_0.tail.n42 0.25746
R1232 comparator_body_0.mref_m5_diff_0.tail.n109 comparator_body_0.mref_m5_diff_0.tail.n108 0.25746
R1233 comparator_body_0.m1_m2_diff_0.m1_m2_array_3/n1_2_4.S comparator_body_0.mref_m5_diff_0.tail.n6 3.17121
R1234 comparator_body_0.mref_m5_diff_0.tail.n83 comparator_body_0.mref_m5_diff_0.tail.n82 0.256658
R1235 comparator_body_0.mref_m5_diff_0.tail.n6 comparator_body_0.mref_m5_diff_0.tail.n3 0.246191
R1236 comparator_body_0.m1_m2_diff_0.m1_m2_array_1/n1_2_14.S comparator_body_0.mref_m5_diff_0.tail.n6 3.11241
R1237 comparator_body_0.mref_m5_diff_0.tail.n6 comparator_body_0.m1_m2_diff_0.tail 1.14283
R1238 comparator_body_0.mref_m5_diff_0.tail.n6 comparator_body_0.mref_m5_diff_0.tail.n9 1.11101
R1239 comparator_body_0.mref_m5_diff_0.tail.n15 comparator_body_0.mref_m5_diff_0.tail.n6 1.09838
R1240 comparator_body_0.mref_m5_diff_0.tail.n6 comparator_body_0.mref_m5_diff_0.tail.n10 1.0887
R1241 comparator_body_0.mref_m5_diff_0.tail.n11 comparator_body_0.mref_m5_diff_0.tail.n6 1.07734
R1242 comparator_body_0.mref_m5_diff_0.tail.n6 comparator_body_0.mref_m5_diff_0.tail.n2 1.05355
R1243 comparator_body_0.mref_m5_diff_0.tail.n16 comparator_body_0.mref_m5_diff_0.tail.n6 1.04446
R1244 comparator_body_0.mref_m5_diff_0.tail.n6 comparator_body_0.mref_m5_diff_0.tail.n12 1.02602
R1245 comparator_body_0.mref_m5_diff_0.tail.n18 comparator_body_0.mref_m5_diff_0.tail.n6 1.00271
R1246 comparator_body_0.mref_m5_diff_0.tail.n6 comparator_body_0.mref_m5_diff_0.tail.n8 1.00094
R1247 comparator_body_0.outx comparator_body_0.outx.t0 5.77616
R1248 comparator_body_0.outx comparator_body_0.outx.t12 5.77616
R1249 comparator_body_0.outx comparator_body_0.outx.n45 5.69938
R1250 comparator_body_0.outx.n1 comparator_body_0.outx 4.84798
R1251 comparator_body_0.outx.t12 comparator_body_0.outx 4.33663
R1252 comparator_body_0.outx comparator_body_0.outx.t0 4.33464
R1253 comparator_body_0.outx.n45 comparator_body_0.outx.t65 4.1228
R1254 comparator_body_0.outx.n44 comparator_body_0.outx.t66 4.12103
R1255 comparator_body_0.outx.n44 comparator_body_0.outx.t67 4.11911
R1256 comparator_body_0.outx.n45 comparator_body_0.outx.t64 4.10479
R1257 comparator_body_0.outx.n39 comparator_body_0.outx.n33 2.82266
R1258 comparator_body_0.outx.n2 comparator_body_0.outx.n65 2.59122
R1259 comparator_body_0.outx.n49 comparator_body_0.outx.n37 2.57098
R1260 comparator_body_0.outx comparator_body_0.outx.t3 2.47695
R1261 comparator_body_0.outx comparator_body_0.outx.t9 2.47695
R1262 comparator_body_0.outx comparator_body_0.outx.t59 2.47695
R1263 comparator_body_0.outx comparator_body_0.outx.t49 2.47695
R1264 comparator_body_0.outx comparator_body_0.outx.t51 2.47695
R1265 comparator_body_0.outx comparator_body_0.outx.t7 2.47695
R1266 comparator_body_0.outx comparator_body_0.outx.t45 2.47695
R1267 comparator_body_0.outx comparator_body_0.outx.t58 2.47695
R1268 comparator_body_0.outx comparator_body_0.outx.t10 2.47695
R1269 comparator_body_0.outx comparator_body_0.outx.t47 2.47695
R1270 comparator_body_0.outx comparator_body_0.outx.t48 2.47695
R1271 comparator_body_0.outx comparator_body_0.outx.t62 2.47695
R1272 comparator_body_0.outx comparator_body_0.outx.t52 2.47695
R1273 comparator_body_0.outx comparator_body_0.outx.t1 2.47695
R1274 comparator_body_0.outx comparator_body_0.outx.t38 2.46703
R1275 comparator_body_0.outx comparator_body_0.outx.t42 2.46703
R1276 comparator_body_0.outx comparator_body_0.outx.t37 2.46703
R1277 comparator_body_0.outx comparator_body_0.outx.t39 2.46703
R1278 comparator_body_0.outx comparator_body_0.outx.t23 2.46703
R1279 comparator_body_0.outx comparator_body_0.outx.t36 2.46703
R1280 comparator_body_0.outx comparator_body_0.outx.t35 2.46703
R1281 comparator_body_0.outx comparator_body_0.outx.t26 2.46703
R1282 comparator_body_0.outx comparator_body_0.outx.t34 2.46703
R1283 comparator_body_0.outx comparator_body_0.outx.t13 2.46703
R1284 comparator_body_0.outx comparator_body_0.outx.t21 2.46703
R1285 comparator_body_0.outx comparator_body_0.outx.t22 2.46703
R1286 comparator_body_0.outx comparator_body_0.outx.t19 2.46703
R1287 comparator_body_0.outx comparator_body_0.outx.t14 2.46703
R1288 comparator_body_0.outx comparator_body_0.outx.t40 2.46703
R1289 comparator_body_0.outx comparator_body_0.outx.t43 2.46703
R1290 comparator_body_0.outx comparator_body_0.outx.t55 2.46234
R1291 comparator_body_0.outx comparator_body_0.outx.t6 2.46234
R1292 comparator_body_0.outx comparator_body_0.outx.t11 2.46234
R1293 comparator_body_0.outx comparator_body_0.outx.t54 2.46234
R1294 comparator_body_0.outx comparator_body_0.outx.t2 2.46234
R1295 comparator_body_0.outx comparator_body_0.outx.t50 2.46234
R1296 comparator_body_0.outx comparator_body_0.outx.t53 2.46234
R1297 comparator_body_0.outx comparator_body_0.outx.t56 2.46234
R1298 comparator_body_0.outx comparator_body_0.outx.t57 2.46234
R1299 comparator_body_0.outx comparator_body_0.outx.t61 2.46234
R1300 comparator_body_0.outx comparator_body_0.outx.t5 2.46234
R1301 comparator_body_0.outx comparator_body_0.outx.t46 2.46234
R1302 comparator_body_0.outx comparator_body_0.outx.t60 2.46234
R1303 comparator_body_0.outx comparator_body_0.outx.t4 2.46234
R1304 comparator_body_0.outx comparator_body_0.outx.t8 2.46234
R1305 comparator_body_0.outx comparator_body_0.outx.t63 2.46234
R1306 comparator_body_0.outx comparator_body_0.outx.t24 2.45485
R1307 comparator_body_0.outx comparator_body_0.outx.t32 2.45485
R1308 comparator_body_0.outx comparator_body_0.outx.t28 2.45485
R1309 comparator_body_0.outx comparator_body_0.outx.t41 2.45485
R1310 comparator_body_0.outx comparator_body_0.outx.t29 2.45485
R1311 comparator_body_0.outx comparator_body_0.outx.t25 2.45485
R1312 comparator_body_0.outx comparator_body_0.outx.t30 2.45485
R1313 comparator_body_0.outx comparator_body_0.outx.t27 2.45485
R1314 comparator_body_0.outx comparator_body_0.outx.t33 2.45485
R1315 comparator_body_0.outx comparator_body_0.outx.t44 2.45485
R1316 comparator_body_0.outx comparator_body_0.outx.t20 2.45485
R1317 comparator_body_0.outx comparator_body_0.outx.t17 2.45485
R1318 comparator_body_0.outx comparator_body_0.outx.t15 2.45485
R1319 comparator_body_0.outx comparator_body_0.outx.t16 2.45485
R1320 comparator_body_0.outx comparator_body_0.outx.t31 2.45485
R1321 comparator_body_0.outx comparator_body_0.outx.t18 2.45485
R1322 comparator_body_0.outx.n56 comparator_body_0.outx 2.37543
R1323 comparator_body_0.outx.n59 comparator_body_0.outx 2.37543
R1324 comparator_body_0.outx.n62 comparator_body_0.outx 2.37543
R1325 comparator_body_0.outx.n64 comparator_body_0.outx 2.37543
R1326 comparator_body_0.outx.n58 comparator_body_0.outx 2.16951
R1327 comparator_body_0.outx.n55 comparator_body_0.outx 2.16951
R1328 comparator_body_0.outx.n61 comparator_body_0.outx 2.16951
R1329 comparator_body_0.outx.n63 comparator_body_0.outx 2.16951
R1330 comparator_body_0.outx.n43 comparator_body_0.outx 1.90375
R1331 comparator_body_0.outx.n4 comparator_body_0.outx 1.90375
R1332 comparator_body_0.outx.n42 comparator_body_0.outx 1.90375
R1333 comparator_body_0.outx.n41 comparator_body_0.outx 1.90375
R1334 comparator_body_0.outx.n58 comparator_body_0.outx 1.89026
R1335 comparator_body_0.outx.n55 comparator_body_0.outx 1.89026
R1336 comparator_body_0.outx.n61 comparator_body_0.outx 1.89026
R1337 comparator_body_0.outx.n63 comparator_body_0.outx 1.89026
R1338 comparator_body_0.outx.n37 comparator_body_0.outx.n41 1.84762
R1339 comparator_body_0.outx.n17 comparator_body_0.outx.n42 1.84762
R1340 comparator_body_0.outx.n50 comparator_body_0.outx 1.70793
R1341 comparator_body_0.outx.n36 comparator_body_0.outx 1.66175
R1342 comparator_body_0.outx.n46 comparator_body_0.outx 1.66175
R1343 comparator_body_0.outx.n16 comparator_body_0.outx 1.66175
R1344 comparator_body_0.outx.n35 comparator_body_0.outx 1.66175
R1345 comparator_body_0.outx.n13 comparator_body_0.outx 1.65953
R1346 comparator_body_0.outx.n56 comparator_body_0.outx 1.65002
R1347 comparator_body_0.outx.n43 comparator_body_0.outx 1.65002
R1348 comparator_body_0.outx.n59 comparator_body_0.outx 1.65002
R1349 comparator_body_0.outx.n4 comparator_body_0.outx 1.65002
R1350 comparator_body_0.outx.n62 comparator_body_0.outx 1.65002
R1351 comparator_body_0.outx.n42 comparator_body_0.outx 1.65002
R1352 comparator_body_0.outx.n64 comparator_body_0.outx 1.65002
R1353 comparator_body_0.outx.n41 comparator_body_0.outx 1.65002
R1354 comparator_body_0.outx.n48 comparator_body_0.outx 1.62872
R1355 comparator_body_0.outx.n14 comparator_body_0.outx 1.62872
R1356 comparator_body_0.outx.n40 comparator_body_0.outx 1.51873
R1357 comparator_body_0.outx.n38 comparator_body_0.outx 1.51873
R1358 comparator_body_0.outx.n57 comparator_body_0.outx 1.51839
R1359 comparator_body_0.outx.n8 comparator_body_0.outx 1.51785
R1360 comparator_body_0.outx.n26 comparator_body_0.outx 1.51785
R1361 comparator_body_0.outx.n14 comparator_body_0.outx 1.51785
R1362 comparator_body_0.outx.n53 comparator_body_0.outx 1.51785
R1363 comparator_body_0.outx.n14 comparator_body_0.outx 1.51785
R1364 comparator_body_0.outx.n7 comparator_body_0.outx 1.51785
R1365 comparator_body_0.outx.n21 comparator_body_0.outx 1.51785
R1366 comparator_body_0.outx.n12 comparator_body_0.outx 1.51785
R1367 comparator_body_0.outx.n1 comparator_body_0.outx 1.51785
R1368 comparator_body_0.outx.n9 comparator_body_0.outx 1.51785
R1369 comparator_body_0.outx.n24 comparator_body_0.outx 1.51785
R1370 comparator_body_0.outx.n2 comparator_body_0.outx 1.51274
R1371 comparator_body_0.outx.n47 comparator_body_0.outx 1.51274
R1372 comparator_body_0.outx.n19 comparator_body_0.outx 1.51274
R1373 comparator_body_0.outx.n34 comparator_body_0.outx 1.51274
R1374 comparator_body_0.outx.n51 comparator_body_0.outx 1.5038
R1375 comparator_body_0.outx comparator_body_0.outx.n7 1.5038
R1376 comparator_body_0.outx.n26 comparator_body_0.outx 1.50288
R1377 comparator_body_0.outx.n21 comparator_body_0.outx 1.50288
R1378 comparator_body_0.outx.n30 comparator_body_0.outx 1.50288
R1379 comparator_body_0.outx.n20 comparator_body_0.outx 1.50288
R1380 comparator_body_0.outx.n54 comparator_body_0.outx 1.50288
R1381 comparator_body_0.outx.n14 comparator_body_0.outx 1.50288
R1382 comparator_body_0.outx.n3 comparator_body_0.outx 1.50288
R1383 comparator_body_0.outx.n24 comparator_body_0.outx 1.50288
R1384 comparator_body_0.outx.n1 comparator_body_0.outx 1.50288
R1385 comparator_body_0.outx.n29 comparator_body_0.outx 1.50288
R1386 comparator_body_0.outx.n8 comparator_body_0.outx 1.50288
R1387 comparator_body_0.outx.n19 comparator_body_0.outx 1.50288
R1388 comparator_body_0.outx.n35 comparator_body_0.outx.n63 1.49914
R1389 comparator_body_0.outx.n16 comparator_body_0.outx.n61 1.49914
R1390 comparator_body_0.outx.n46 comparator_body_0.outx.n55 1.49914
R1391 comparator_body_0.outx.n36 comparator_body_0.outx.n58 1.49914
R1392 comparator_body_0.outx.n49 comparator_body_0.outx.n19 1.3997
R1393 comparator_body_0.outx.n50 comparator_body_0.outx.n23 0.302271
R1394 comparator_body_0.outx.n0 comparator_body_0.outx.n51 1.3557
R1395 comparator_body_0.outx.n25 comparator_body_0.outx.n29 1.3557
R1396 comparator_body_0.outx.n30 comparator_body_0.outx.n6 1.3557
R1397 comparator_body_0.outx.n12 comparator_body_0.outx.n27 0.516071
R1398 comparator_body_0.outx.n53 comparator_body_0.outx.n13 1.3557
R1399 comparator_body_0.outx.n57 comparator_body_0.outx.n54 1.34908
R1400 comparator_body_0.outx.n7 comparator_body_0.outx.n8 1.27782
R1401 comparator_body_0.outx.n1 comparator_body_0.outx.n8 1.26902
R1402 comparator_body_0.outx.n7 comparator_body_0.outx.n54 1.25714
R1403 comparator_body_0.outx.n65 comparator_body_0.outx.n34 1.17266
R1404 comparator_body_0.outx.n51 comparator_body_0.outx.n52 0.309284
R1405 comparator_body_0.outx.n17 comparator_body_0.outx.n60 1.04418
R1406 comparator_body_0.outx.n26 comparator_body_0.outx.n27 0.288971
R1407 comparator_body_0.outx.n9 comparator_body_0.outx.n23 0.516071
R1408 comparator_body_0.outx.n21 comparator_body_0.outx.n22 0.288971
R1409 comparator_body_0.outx.n26 comparator_body_0.outx.n10 0.455582
R1410 comparator_body_0.outx.n15 comparator_body_0.outx.n20 0.288387
R1411 comparator_body_0.outx.n32 comparator_body_0.outx.n53 0.855671
R1412 comparator_body_0.outx.n31 comparator_body_0.outx.n30 0.95002
R1413 comparator_body_0.outx.n29 comparator_body_0.outx.n28 0.95002
R1414 comparator_body_0.outx.n5 comparator_body_0.outx.n20 0.95002
R1415 comparator_body_0.outx.n52 comparator_body_0.outx.n60 0.867103
R1416 comparator_body_0.outx.n60 comparator_body_0.outx.n19 0.92362
R1417 comparator_body_0.outx.n10 comparator_body_0.outx.n9 0.362654
R1418 comparator_body_0.outx.n12 comparator_body_0.outx.n11 0.362654
R1419 comparator_body_0.outx.n52 comparator_body_0.outx.n24 1.23233
R1420 comparator_body_0.outx.n13 comparator_body_0.outx.n47 1.06596
R1421 comparator_body_0.outx.n34 comparator_body_0.outx.n48 0.92626
R1422 comparator_body_0.outx.n47 comparator_body_0.outx.n46 0.923681
R1423 comparator_body_0.outx.n33 comparator_body_0.outx.n14 0.88138
R1424 comparator_body_0.outx.n50 comparator_body_0.outx.n49 0.876585
R1425 comparator_body_0.outx.n37 comparator_body_0.outx.n35 0.360581
R1426 comparator_body_0.outx.n18 comparator_body_0.outx.n17 0.302254
R1427 comparator_body_0.outx.n2 comparator_body_0.outx.n4 2.09492
R1428 comparator_body_0.outx.n33 comparator_body_0.outx.n43 2.05435
R1429 comparator_body_0.outx.n43 comparator_body_0.outx.n56 2.0069
R1430 comparator_body_0.outx.n4 comparator_body_0.outx.n59 2.0069
R1431 comparator_body_0.outx.n42 comparator_body_0.outx.n62 2.0069
R1432 comparator_body_0.outx.n41 comparator_body_0.outx.n64 2.0069
R1433 comparator_body_0.outx.n1 comparator_body_0.outx.n0 1.44062
R1434 comparator_body_0.outx.n25 comparator_body_0.outx.n8 1.42654
R1435 comparator_body_0.outx.n7 comparator_body_0.outx.n6 1.4217
R1436 comparator_body_0.outx.n39 comparator_body_0.outx.n2 1.36966
R1437 comparator_body_0.outx.n11 comparator_body_0.outx.n21 0.455582
R1438 comparator_body_0.outx.n14 comparator_body_0.outx.n15 0.283535
R1439 comparator_body_0.outx.n0 comparator_body_0.outx.n24 1.33194
R1440 comparator_body_0.outx.n48 comparator_body_0.outx.n10 0.310753
R1441 comparator_body_0.outx.n11 comparator_body_0.outx.n3 0.310753
R1442 comparator_body_0.outx.n22 comparator_body_0.outx.n14 1.15084
R1443 comparator_body_0.outx.n18 comparator_body_0.outx.n16 0.31442
R1444 comparator_body_0.outx.n5 comparator_body_0.outx.n21 1.0829
R1445 comparator_body_0.outx.n28 comparator_body_0.outx.n24 1.0829
R1446 comparator_body_0.outx.n26 comparator_body_0.outx.n31 1.0829
R1447 comparator_body_0.outx.n32 comparator_body_0.outx.n57 0.998407
R1448 comparator_body_0.outx.n24 comparator_body_0.outx.n19 1.08202
R1449 comparator_body_0.outx.n19 comparator_body_0.outx.n18 1.04725
R1450 comparator_body_0.outx.n35 comparator_body_0.outx.n34 1.04587
R1451 comparator_body_0.outx.n2 comparator_body_0.outx.n3 1.02482
R1452 comparator_body_0.outx.n2 comparator_body_0.outx.n36 1.00722
R1453 comparator_body_0.outx.n40 comparator_body_0.outx.n39 0.97906
R1454 comparator_body_0.outx.n65 comparator_body_0.outx.n38 0.97906
R1455 comparator_body_0.outx.n47 comparator_body_0.outx.n33 0.899971
R1456 comparator_body_0.outx.n32 comparator_body_0.outx.n14 0.899838
R1457 comparator_body_0.outx.n45 comparator_body_0.outx.n44 0.854615
R1458 comparator_body_0.outx.n7 comparator_body_0.outx.n5 0.7595
R1459 comparator_body_0.outx.n14 comparator_body_0.outx.n13 0.75818
R1460 comparator_body_0.outx.n22 comparator_body_0.outx.n40 0.302271
R1461 comparator_body_0.outx.n24 comparator_body_0.outx.n23 0.288971
R1462 comparator_body_0.outx.n27 comparator_body_0.outx.n38 0.302271
R1463 comparator_body_0.outx.n21 comparator_body_0.outx.n6 0.75554
R1464 comparator_body_0.outx.n26 comparator_body_0.outx.n25 0.75554
R1465 comparator_body_0.outx.n28 comparator_body_0.outx.n1 0.7551
R1466 comparator_body_0.outx.n31 comparator_body_0.outx.n8 0.74542
R1467 comparator_body_0.outx.n15 comparator_body_0.outx.n54 1.27352
R1468 comparator_body_0.outx.n30 comparator_body_0.outx.n12 1.10574
R1469 comparator_body_0.outx.n29 comparator_body_0.outx.n9 1.10574
R1470 comparator_body_0.m3_m4_diff_0.n1.n48 comparator_body_0.m3_m4_diff_0.m3_m4_array_2/p1_2$1_13.D 10.3502
R1471 comparator_body_0.m3_m4_diff_0.m3_m4_array_2/p1_2$1_9.D comparator_body_0.m3_m4_diff_0.n1.n36 10.3502
R1472 comparator_body_0.m3_m4_diff_0.n1.n4 comparator_body_0.m3_m4_diff_0.n1.n50 10.3502
R1473 comparator_body_0.m3_m4_diff_0.n1.n59 comparator_body_0.m3_m4_diff_0.m3_m4_array_1/p1_2$1_13.D 10.3502
R1474 comparator_body_0.m3_m4_diff_0.n1.n0 comparator_body_0.m3_m4_diff_0.n1.n26 10.3502
R1475 comparator_body_0.m3_m4_diff_0.m3_m4_array_0/p1_2$1_13.D comparator_body_0.m3_m4_diff_0.n1.n56 10.3502
R1476 comparator_body_0.m3_m4_diff_0.n1.n37 comparator_body_0.m3_m4_diff_0.n1.n60 8.82038
R1477 comparator_body_0.m3_m4_diff_0.n1.t36 comparator_body_0.m3_m4_diff_0.n1.n2 2.16656
R1478 comparator_body_0.m3_m4_diff_0.n1.n0 comparator_body_0.m3_m4_diff_0.n1.t60 4.98207
R1479 comparator_body_0.m3_m4_diff_0.n1.n0 comparator_body_0.m3_m4_diff_0.n1.t70 4.98207
R1480 comparator_body_0.m3_m4_diff_0.n1.n34 comparator_body_0.m3_m4_diff_0.n1.n0 0.574529
R1481 comparator_body_0.m3_m4_diff_0.n1.t54 comparator_body_0.m3_m4_diff_0.n1.n1 2.39981
R1482 comparator_body_0.m3_m4_diff_0.n1.n0 comparator_body_0.m3_m4_diff_0.n1.t88 4.9771
R1483 comparator_body_0.m3_m4_diff_0.n1.n0 comparator_body_0.m3_m4_diff_0.n1.n3 0.284551
R1484 comparator_body_0.m3_m4_diff_0.n1.t82 comparator_body_0.m3_m4_diff_0.n1.n0 4.9771
R1485 comparator_body_0.m3_m4_diff_0.n1.n4 comparator_body_0.m3_m4_diff_0.n1.n7 0.61471
R1486 comparator_body_0.m3_m4_diff_0.n1.n4 comparator_body_0.m3_m4_diff_0.n1.t32 4.98207
R1487 comparator_body_0.m3_m4_diff_0.n1.n4 comparator_body_0.m3_m4_diff_0.n1.t86 4.98207
R1488 comparator_body_0.m3_m4_diff_0.n1.n32 comparator_body_0.m3_m4_diff_0.n1.n4 0.574529
R1489 comparator_body_0.m3_m4_diff_0.n1.n6 comparator_body_0.m3_m4_diff_0.n1.t72 2.39981
R1490 comparator_body_0.m3_m4_diff_0.n1.n4 comparator_body_0.m3_m4_diff_0.n1.t42 4.9771
R1491 comparator_body_0.m3_m4_diff_0.n1.n4 comparator_body_0.m3_m4_diff_0.n1.n5 0.28881
R1492 comparator_body_0.m3_m4_diff_0.n1.t38 comparator_body_0.m3_m4_diff_0.n1.n4 4.9771
R1493 comparator_body_0.m3_m4_diff_0.n1.n14 comparator_body_0.m3_m4_diff_0.n1.n30 0.61471
R1494 comparator_body_0.m3_m4_diff_0.n1.n30 comparator_body_0.m3_m4_diff_0.n1.t40 4.98207
R1495 comparator_body_0.m3_m4_diff_0.n1.n30 comparator_body_0.m3_m4_diff_0.n1.t44 4.98207
R1496 comparator_body_0.m3_m4_diff_0.n1.n28 comparator_body_0.m3_m4_diff_0.n1.n30 0.264696
R1497 comparator_body_0.m3_m4_diff_0.n1.n30 comparator_body_0.m3_m4_diff_0.n1.t58 4.9771
R1498 comparator_body_0.m3_m4_diff_0.n1.n27 comparator_body_0.m3_m4_diff_0.n1.t66 2.2396
R1499 comparator_body_0.m3_m4_diff_0.n1.n30 comparator_body_0.m3_m4_diff_0.n1.t52 4.9771
R1500 comparator_body_0.m3_m4_diff_0.n1.t40 comparator_body_0.m3_m4_diff_0.m3_m4_array_2/p1_2$1_14.D 4.93952
R1501 comparator_body_0.m3_m4_diff_0.n1.t32 comparator_body_0.m3_m4_diff_0.m3_m4_array_1/p1_2$1_14.D 4.93952
R1502 comparator_body_0.m3_m4_diff_0.n1.t60 comparator_body_0.m3_m4_diff_0.m3_m4_array_0/p1_2$1_14.D 4.93952
R1503 comparator_body_0.m3_m4_diff_0.m3_m4_array_3/p1_2$1_14.D comparator_body_0.m3_m4_diff_0.n1.t94 4.93952
R1504 comparator_body_0.m1_m2_diff_0.m1_m2_array_3/n1_2_10.D comparator_body_0.m3_m4_diff_0.n1.t0 5.77616
R1505 comparator_body_0.m3_m4_diff_0.n1.n52 comparator_body_0.m3_m4_diff_0.n1.n46 5.17146
R1506 comparator_body_0.m3_m4_diff_0.n1.n39 comparator_body_0.m3_m4_diff_0.n1.t80 4.96805
R1507 comparator_body_0.m3_m4_diff_0.n1.n39 comparator_body_0.m3_m4_diff_0.n1.t94 4.96805
R1508 comparator_body_0.m3_m4_diff_0.n1.n45 comparator_body_0.m3_m4_diff_0.n1.t92 4.96805
R1509 comparator_body_0.m3_m4_diff_0.n1.n46 comparator_body_0.m3_m4_diff_0.n1.t84 4.96805
R1510 comparator_body_0.m3_m4_diff_0.n1.n47 comparator_body_0.m3_m4_diff_0.n1.t46 2.21646
R1511 comparator_body_0.m3_m4_diff_0.n1.n18 comparator_body_0.m3_m4_diff_0.n1.t76 2.18191
R1512 comparator_body_0.m3_m4_diff_0.n1.t62 comparator_body_0.m3_m4_diff_0.n1.n38 4.96805
R1513 comparator_body_0.m3_m4_diff_0.n1.n51 comparator_body_0.m3_m4_diff_0.n1.t68 4.96805
R1514 comparator_body_0.m3_m4_diff_0.m3_m4_array_2/p1_2$1_13.D comparator_body_0.m3_m4_diff_0.n1.t34 2.30962
R1515 comparator_body_0.m3_m4_diff_0.n1.t78 comparator_body_0.m3_m4_diff_0.n1.n32 2.19666
R1516 comparator_body_0.m3_m4_diff_0.n1.t56 comparator_body_0.m3_m4_diff_0.n1.n34 2.19666
R1517 comparator_body_0.m3_m4_diff_0.m3_m4_array_3/p1_2$1_13.D comparator_body_0.m3_m4_diff_0.n1.t84 4.9444
R1518 comparator_body_0.m3_m4_diff_0.m3_m4_array_2/p1_2$1_4.D comparator_body_0.m3_m4_diff_0.n1.t62 4.94339
R1519 comparator_body_0.m3_m4_diff_0.n1.t74 comparator_body_0.m3_m4_diff_0.n1.n28 2.39981
R1520 comparator_body_0.m3_m4_diff_0.n1.t48 comparator_body_0.m3_m4_diff_0.n1.n5 2.39411
R1521 comparator_body_0.m3_m4_diff_0.n1.t90 comparator_body_0.m3_m4_diff_0.n1.n3 2.39541
R1522 comparator_body_0.m3_m4_diff_0.m3_m4_array_2/p1_2$1_4.D comparator_body_0.m3_m4_diff_0.n1.t68 4.89895
R1523 comparator_body_0.m3_m4_diff_0.n1.n35 comparator_body_0.m3_m4_diff_0.n1.t44 4.89895
R1524 comparator_body_0.m3_m4_diff_0.m3_m4_array_3/p1_2$1_14.D comparator_body_0.m3_m4_diff_0.n1.t80 4.89895
R1525 comparator_body_0.m3_m4_diff_0.n1.n2 comparator_body_0.m3_m4_diff_0.n1.n8 0.60447
R1526 comparator_body_0.m3_m4_diff_0.n1.n7 comparator_body_0.m3_m4_diff_0.n1.t50 2.16656
R1527 comparator_body_0.m3_m4_diff_0.n1.t64 comparator_body_0.m3_m4_diff_0.n1.n14 2.16656
R1528 comparator_body_0.m3_m4_diff_0.n1.n18 comparator_body_0.m3_m4_diff_0.n1.n17 0.567966
R1529 comparator_body_0.m3_m4_diff_0.m3_m4_array_1/p1_2$1_4.D comparator_body_0.m3_m4_diff_0.n1.t52 4.89895
R1530 comparator_body_0.m3_m4_diff_0.n1.t86 comparator_body_0.m3_m4_diff_0.n1.n19 4.89895
R1531 comparator_body_0.m3_m4_diff_0.n1.t38 comparator_body_0.m3_m4_diff_0.m3_m4_array_0/p1_2$1_4.D 4.89895
R1532 comparator_body_0.m3_m4_diff_0.n1.t70 comparator_body_0.m3_m4_diff_0.n1.n20 4.89895
R1533 comparator_body_0.m3_m4_diff_0.n1.t58 comparator_body_0.m3_m4_diff_0.n1.n21 4.89895
R1534 comparator_body_0.m3_m4_diff_0.n1.t42 comparator_body_0.m3_m4_diff_0.n1.n22 4.89895
R1535 comparator_body_0.m3_m4_diff_0.n1.t88 comparator_body_0.m3_m4_diff_0.n1.n23 4.89895
R1536 comparator_body_0.m3_m4_diff_0.n1.n25 comparator_body_0.m3_m4_diff_0.n1.t92 4.89895
R1537 comparator_body_0.m3_m4_diff_0.n1.t82 comparator_body_0.m3_m4_diff_0.m3_m4_array_3/p1_2$1_4.D 4.89895
R1538 comparator_body_0.m3_m4_diff_0.m3_m4_array_2/p1_2$1_9.D comparator_body_0.m3_m4_diff_0.n1.t69 2.4119
R1539 comparator_body_0.m3_m4_diff_0.m3_m4_array_2/p1_2$1_4.D comparator_body_0.m3_m4_diff_0.n1.t63 2.4119
R1540 comparator_body_0.m3_m4_diff_0.m3_m4_array_3/p1_2$1_1.D comparator_body_0.m3_m4_diff_0.n1.t55 2.4119
R1541 comparator_body_0.m3_m4_diff_0.m3_m4_array_0/p1_2$1_1.D comparator_body_0.m3_m4_diff_0.n1.t73 2.4119
R1542 comparator_body_0.m3_m4_diff_0.m3_m4_array_1/p1_2$1_1.D comparator_body_0.m3_m4_diff_0.n1.t75 2.4119
R1543 comparator_body_0.m3_m4_diff_0.m3_m4_array_2/p1_2$1_1.D comparator_body_0.m3_m4_diff_0.n1.t47 2.4119
R1544 comparator_body_0.m3_m4_diff_0.m3_m4_array_2/p1_2$1_10.D comparator_body_0.m3_m4_diff_0.n1.t77 2.4119
R1545 comparator_body_0.m3_m4_diff_0.m3_m4_array_1/p1_2$1_9.D comparator_body_0.m3_m4_diff_0.n1.t53 2.4119
R1546 comparator_body_0.m3_m4_diff_0.m3_m4_array_1/p1_2$1_4.D comparator_body_0.m3_m4_diff_0.n1.t67 2.4119
R1547 comparator_body_0.m3_m4_diff_0.m3_m4_array_0/p1_2$1_9.D comparator_body_0.m3_m4_diff_0.n1.t39 2.4119
R1548 comparator_body_0.m3_m4_diff_0.m3_m4_array_0/p1_2$1_4.D comparator_body_0.m3_m4_diff_0.n1.t49 2.4119
R1549 comparator_body_0.m3_m4_diff_0.m3_m4_array_1/p1_2$1_10.D comparator_body_0.m3_m4_diff_0.n1.t59 2.4119
R1550 comparator_body_0.m3_m4_diff_0.m3_m4_array_0/p1_2$1_10.D comparator_body_0.m3_m4_diff_0.n1.t43 2.4119
R1551 comparator_body_0.m3_m4_diff_0.m3_m4_array_3/p1_2$1_9.D comparator_body_0.m3_m4_diff_0.n1.t83 2.4119
R1552 comparator_body_0.m3_m4_diff_0.m3_m4_array_3/p1_2$1_4.D comparator_body_0.m3_m4_diff_0.n1.t91 2.4119
R1553 comparator_body_0.m3_m4_diff_0.m3_m4_array_3/p1_2$1_10.D comparator_body_0.m3_m4_diff_0.n1.t89 2.4119
R1554 comparator_body_0.m1_m2_diff_0.m1_m2_array_3/n1_2_10.D comparator_body_0.m3_m4_diff_0.n1.t0 4.31837
R1555 comparator_body_0.m3_m4_diff_0.n1.n52 comparator_body_0.m1_m2_diff_0.m1_m2_array_3/n1_2_11.D 3.74354
R1556 comparator_body_0.m3_m4_diff_0.n1.n40 comparator_body_0.m1_m2_diff_0.m1_m2_array_1/n1_2_14.D 3.40063
R1557 comparator_body_0.m3_m4_diff_0.n1.n41 comparator_body_0.m1_m2_diff_0.m1_m2_array_0/n1_2_14.D 3.40063
R1558 comparator_body_0.m3_m4_diff_0.n1.n42 comparator_body_0.m1_m2_diff_0.m1_m2_array_2/n1_2_14.D 3.40063
R1559 comparator_body_0.m3_m4_diff_0.n1.n43 comparator_body_0.m1_m2_diff_0.m1_m2_array_3/n1_2_14.D 3.40063
R1560 comparator_body_0.m3_m4_diff_0.n1.n57 comparator_body_0.m3_m4_diff_0.n1.n55 2.90186
R1561 comparator_body_0.m1_m2_diff_0.m1_m2_array_1/n1_2_10.D comparator_body_0.m3_m4_diff_0.n1.t18 2.46703
R1562 comparator_body_0.m1_m2_diff_0.m1_m2_array_1/n1_2_7.D comparator_body_0.m3_m4_diff_0.n1.t13 2.46703
R1563 comparator_body_0.m1_m2_diff_0.m1_m2_array_1/n1_2_4.D comparator_body_0.m3_m4_diff_0.n1.t15 2.46703
R1564 comparator_body_0.m1_m2_diff_0.m1_m2_array_0/n1_2_10.D comparator_body_0.m3_m4_diff_0.n1.t29 2.46703
R1565 comparator_body_0.m1_m2_diff_0.m1_m2_array_0/n1_2_11.D comparator_body_0.m3_m4_diff_0.n1.t25 2.46703
R1566 comparator_body_0.m1_m2_diff_0.m1_m2_array_0/n1_2_7.D comparator_body_0.m3_m4_diff_0.n1.t23 2.46703
R1567 comparator_body_0.m1_m2_diff_0.m1_m2_array_0/n1_2_4.D comparator_body_0.m3_m4_diff_0.n1.t17 2.46703
R1568 comparator_body_0.m1_m2_diff_0.m1_m2_array_2/n1_2_10.D comparator_body_0.m3_m4_diff_0.n1.t5 2.46703
R1569 comparator_body_0.m1_m2_diff_0.m1_m2_array_2/n1_2_11.D comparator_body_0.m3_m4_diff_0.n1.t31 2.46703
R1570 comparator_body_0.m1_m2_diff_0.m1_m2_array_2/n1_2_7.D comparator_body_0.m3_m4_diff_0.n1.t2 2.46703
R1571 comparator_body_0.m1_m2_diff_0.m1_m2_array_2/n1_2_4.D comparator_body_0.m3_m4_diff_0.n1.t24 2.46703
R1572 comparator_body_0.m1_m2_diff_0.m1_m2_array_1/n1_2_11.D comparator_body_0.m3_m4_diff_0.n1.t21 2.46703
R1573 comparator_body_0.m1_m2_diff_0.m1_m2_array_3/n1_2_7.D comparator_body_0.m3_m4_diff_0.n1.t1 2.46703
R1574 comparator_body_0.m1_m2_diff_0.m1_m2_array_3/n1_2_4.D comparator_body_0.m3_m4_diff_0.n1.t7 2.46703
R1575 comparator_body_0.m1_m2_diff_0.m1_m2_array_3/n1_2_11.D comparator_body_0.m3_m4_diff_0.n1.t4 2.46703
R1576 comparator_body_0.m1_m2_diff_0.m1_m2_array_1/n1_2_1.D comparator_body_0.m3_m4_diff_0.n1.t16 2.45485
R1577 comparator_body_0.m1_m2_diff_0.m1_m2_array_1/n1_2_2.D comparator_body_0.m3_m4_diff_0.n1.t12 2.45485
R1578 comparator_body_0.m1_m2_diff_0.m1_m2_array_1/n1_2_13.D comparator_body_0.m3_m4_diff_0.n1.t30 2.45485
R1579 comparator_body_0.m1_m2_diff_0.m1_m2_array_0/n1_2_13.D comparator_body_0.m3_m4_diff_0.n1.t26 2.45485
R1580 comparator_body_0.m1_m2_diff_0.m1_m2_array_0/n1_2_2.D comparator_body_0.m3_m4_diff_0.n1.t27 2.45485
R1581 comparator_body_0.m1_m2_diff_0.m1_m2_array_0/n1_2_1.D comparator_body_0.m3_m4_diff_0.n1.t20 2.45485
R1582 comparator_body_0.m1_m2_diff_0.m1_m2_array_2/n1_2_13.D comparator_body_0.m3_m4_diff_0.n1.t22 2.45485
R1583 comparator_body_0.m1_m2_diff_0.m1_m2_array_2/n1_2_2.D comparator_body_0.m3_m4_diff_0.n1.t6 2.45485
R1584 comparator_body_0.m1_m2_diff_0.m1_m2_array_2/n1_2_1.D comparator_body_0.m3_m4_diff_0.n1.t3 2.45485
R1585 comparator_body_0.m1_m2_diff_0.m1_m2_array_3/n1_2_13.D comparator_body_0.m3_m4_diff_0.n1.t8 2.45485
R1586 comparator_body_0.m1_m2_diff_0.m1_m2_array_3/n1_2_2.D comparator_body_0.m3_m4_diff_0.n1.t10 2.45485
R1587 comparator_body_0.m1_m2_diff_0.m1_m2_array_3/n1_2_1.D comparator_body_0.m3_m4_diff_0.n1.t11 2.45485
R1588 comparator_body_0.m1_m2_diff_0.m1_m2_array_3/n1_2_14.D comparator_body_0.m3_m4_diff_0.n1.t9 2.45485
R1589 comparator_body_0.m1_m2_diff_0.m1_m2_array_2/n1_2_14.D comparator_body_0.m3_m4_diff_0.n1.t28 2.45485
R1590 comparator_body_0.m1_m2_diff_0.m1_m2_array_0/n1_2_14.D comparator_body_0.m3_m4_diff_0.n1.t19 2.45485
R1591 comparator_body_0.m1_m2_diff_0.m1_m2_array_1/n1_2_14.D comparator_body_0.m3_m4_diff_0.n1.t14 2.45485
R1592 comparator_body_0.m3_m4_diff_0.m3_m4_array_2/p1_2$1_13.D comparator_body_0.m3_m4_diff_0.n1.t35 2.40997
R1593 comparator_body_0.m3_m4_diff_0.m3_m4_array_1/p1_2$1_13.D comparator_body_0.m3_m4_diff_0.n1.t79 2.40997
R1594 comparator_body_0.m3_m4_diff_0.m3_m4_array_0/p1_2$1_13.D comparator_body_0.m3_m4_diff_0.n1.t57 2.40997
R1595 comparator_body_0.m3_m4_diff_0.m3_m4_array_3/p1_2$1_13.D comparator_body_0.m3_m4_diff_0.n1.t85 2.40997
R1596 comparator_body_0.m3_m4_diff_0.m3_m4_array_2/p1_2$1_9.D comparator_body_0.m3_m4_diff_0.n1.t45 2.40957
R1597 comparator_body_0.m3_m4_diff_0.m3_m4_array_3/p1_2$1_0.D comparator_body_0.m3_m4_diff_0.n1.t81 2.40957
R1598 comparator_body_0.m3_m4_diff_0.m3_m4_array_0/p1_2$1_0.D comparator_body_0.m3_m4_diff_0.n1.t37 2.40957
R1599 comparator_body_0.m3_m4_diff_0.m3_m4_array_1/p1_2$1_0.D comparator_body_0.m3_m4_diff_0.n1.t51 2.40957
R1600 comparator_body_0.m3_m4_diff_0.m3_m4_array_2/p1_2$1_0.D comparator_body_0.m3_m4_diff_0.n1.t65 2.40957
R1601 comparator_body_0.m3_m4_diff_0.m3_m4_array_1/p1_2$1_10.D comparator_body_0.m3_m4_diff_0.n1.t87 2.40957
R1602 comparator_body_0.m3_m4_diff_0.m3_m4_array_0/p1_2$1_7.D comparator_body_0.m3_m4_diff_0.n1.t71 2.40957
R1603 comparator_body_0.m3_m4_diff_0.m3_m4_array_3/p1_2$1_7.D comparator_body_0.m3_m4_diff_0.n1.t93 2.40957
R1604 comparator_body_0.m3_m4_diff_0.m3_m4_array_2/p1_2$1_14.D comparator_body_0.m3_m4_diff_0.n1.t41 2.40519
R1605 comparator_body_0.m3_m4_diff_0.m3_m4_array_1/p1_2$1_14.D comparator_body_0.m3_m4_diff_0.n1.t33 2.40519
R1606 comparator_body_0.m3_m4_diff_0.m3_m4_array_0/p1_2$1_14.D comparator_body_0.m3_m4_diff_0.n1.t61 2.40519
R1607 comparator_body_0.m3_m4_diff_0.m3_m4_array_3/p1_2$1_14.D comparator_body_0.m3_m4_diff_0.n1.t95 2.40519
R1608 comparator_body_0.m3_m4_diff_0.n1.n60 comparator_body_0.m3_m4_diff_0.n1.n58 2.23218
R1609 comparator_body_0.m3_m4_diff_0.n1.n59 comparator_body_0.m1_m2_diff_0.m1_m2_array_0/n1_2_11.D 2.1525
R1610 comparator_body_0.m3_m4_diff_0.m3_m4_array_1/p1_2$1_10.D comparator_body_0.m3_m4_diff_0.m3_m4_array_1/p1_2$1_9.D 2.14993
R1611 comparator_body_0.m3_m4_diff_0.m3_m4_array_2/p1_2$1_10.D comparator_body_0.m3_m4_diff_0.m3_m4_array_2/p1_2$1_9.D 2.14993
R1612 comparator_body_0.m3_m4_diff_0.m3_m4_array_3/p1_2$1_4.D comparator_body_0.m3_m4_diff_0.n1.n3 0.722672
R1613 comparator_body_0.m3_m4_diff_0.m3_m4_array_0/p1_2$1_4.D comparator_body_0.m3_m4_diff_0.n1.n5 0.724532
R1614 comparator_body_0.m3_m4_diff_0.m3_m4_array_2/p1_2$1_13.D comparator_body_0.m3_m4_diff_0.m3_m4_array_1/p1_2$1_4.D 2.14163
R1615 comparator_body_0.m3_m4_diff_0.n1.n36 comparator_body_0.m1_m2_diff_0.m1_m2_array_1/n1_2_11.D 2.10674
R1616 comparator_body_0.m3_m4_diff_0.n1.n61 comparator_body_0.m3_m4_diff_0.n1.n44 2.0949
R1617 comparator_body_0.m3_m4_diff_0.n1.n17 comparator_body_0.m3_m4_diff_0.m3_m4_array_2/p1_2$1_4.D 2.05082
R1618 comparator_body_0.m3_m4_diff_0.n1.n25 comparator_body_0.m3_m4_diff_0.n1.n24 0.593316
R1619 comparator_body_0.m3_m4_diff_0.n1.n55 comparator_body_0.m3_m4_diff_0.n1.n43 2.04298
R1620 comparator_body_0.m3_m4_diff_0.n1.n54 comparator_body_0.m3_m4_diff_0.n1.n42 2.04298
R1621 comparator_body_0.m3_m4_diff_0.n1.n49 comparator_body_0.m3_m4_diff_0.n1.n41 2.04298
R1622 comparator_body_0.m3_m4_diff_0.n1.n53 comparator_body_0.m3_m4_diff_0.n1.n40 2.04298
R1623 comparator_body_0.m1_m2_diff_0.n1 comparator_body_0.m3_m4_diff_0.n1.n57 2.02362
R1624 comparator_body_0.m3_m4_diff_0.n1.n26 comparator_body_0.m3_m4_diff_0.n1.n56 2.0025
R1625 comparator_body_0.m3_m4_diff_0.n1.n29 comparator_body_0.m3_m4_diff_0.n1.n12 2.00061
R1626 comparator_body_0.m3_m4_diff_0.n1.n31 comparator_body_0.m3_m4_diff_0.n1.n10 2.00061
R1627 comparator_body_0.m3_m4_diff_0.n1.n33 comparator_body_0.m3_m4_diff_0.n1.n8 2.00061
R1628 comparator_body_0.m3_m4_diff_0.n1.n62 comparator_body_0.m1_m2_diff_0.n1 1.9761
R1629 comparator_body_0.m1_m2_diff_0.n1 comparator_body_0.m3_m4_diff_0.n1.n49 1.93914
R1630 comparator_body_0.m3_m4_diff_0.n1.n43 comparator_body_0.m1_m2_diff_0.m1_m2_array_3/n1_2_1.D 1.90199
R1631 comparator_body_0.m3_m4_diff_0.n1.n42 comparator_body_0.m1_m2_diff_0.m1_m2_array_2/n1_2_1.D 1.90199
R1632 comparator_body_0.m3_m4_diff_0.n1.n41 comparator_body_0.m1_m2_diff_0.m1_m2_array_0/n1_2_1.D 1.90199
R1633 comparator_body_0.m3_m4_diff_0.n1.n40 comparator_body_0.m1_m2_diff_0.m1_m2_array_1/n1_2_1.D 1.90199
R1634 comparator_body_0.m3_m4_diff_0.n1.n54 comparator_body_0.m1_m2_diff_0.n1 1.89866
R1635 comparator_body_0.m3_m4_diff_0.n1.n43 comparator_body_0.m1_m2_diff_0.m1_m2_array_3/n1_2_4.D 1.8885
R1636 comparator_body_0.m3_m4_diff_0.n1.n55 comparator_body_0.m1_m2_diff_0.m1_m2_array_3/n1_2_7.D 1.8885
R1637 comparator_body_0.m3_m4_diff_0.n1.n42 comparator_body_0.m1_m2_diff_0.m1_m2_array_2/n1_2_4.D 1.8885
R1638 comparator_body_0.m3_m4_diff_0.n1.n54 comparator_body_0.m1_m2_diff_0.m1_m2_array_2/n1_2_7.D 1.8885
R1639 comparator_body_0.m3_m4_diff_0.n1.n41 comparator_body_0.m1_m2_diff_0.m1_m2_array_0/n1_2_4.D 1.8885
R1640 comparator_body_0.m3_m4_diff_0.n1.n49 comparator_body_0.m1_m2_diff_0.m1_m2_array_0/n1_2_7.D 1.8885
R1641 comparator_body_0.m3_m4_diff_0.n1.n40 comparator_body_0.m1_m2_diff_0.m1_m2_array_1/n1_2_4.D 1.8885
R1642 comparator_body_0.m3_m4_diff_0.n1.n53 comparator_body_0.m1_m2_diff_0.m1_m2_array_1/n1_2_7.D 1.8885
R1643 comparator_body_0.m3_m4_diff_0.n1.n23 comparator_body_0.m3_m4_diff_0.m3_m4_array_3/p1_2$1_4.D 1.88003
R1644 comparator_body_0.m3_m4_diff_0.n1.n22 comparator_body_0.m3_m4_diff_0.m3_m4_array_0/p1_2$1_4.D 1.88003
R1645 comparator_body_0.m3_m4_diff_0.m3_m4_array_1/p1_2$1_4.D comparator_body_0.m3_m4_diff_0.n1.n21 1.88003
R1646 comparator_body_0.m3_m4_diff_0.n1.n44 comparator_body_0.m3_m4_diff_0.n1.n58 1.87314
R1647 comparator_body_0.m1_m2_diff_0.n1 comparator_body_0.m3_m4_diff_0.n1.n61 1.87314
R1648 comparator_body_0.m1_m2_diff_0.n1 comparator_body_0.m3_m4_diff_0.n1.n62 1.87314
R1649 comparator_body_0.m3_m4_diff_0.n1.n44 comparator_body_0.m3_m4_diff_0.n1.n53 1.81066
R1650 comparator_body_0.m3_m4_diff_0.n1.n56 comparator_body_0.m1_m2_diff_0.m1_m2_array_2/n1_2_11.D 1.74154
R1651 comparator_body_0.m3_m4_diff_0.m3_m4_array_3/p1_2$1_0.D comparator_body_0.m3_m4_diff_0.n1.n16 1.8871
R1652 comparator_body_0.m3_m4_diff_0.m3_m4_array_3/p1_2$1_10.D comparator_body_0.m3_m4_diff_0.m3_m4_array_3/p1_2$1_7.D 1.815
R1653 comparator_body_0.m3_m4_diff_0.m3_m4_array_2/p1_2$1_4.D comparator_body_0.m3_m4_diff_0.n1.n15 1.67969
R1654 comparator_body_0.m3_m4_diff_0.n1.n57 comparator_body_0.m1_m2_diff_0.m1_m2_array_3/n1_2_2.D 1.66263
R1655 comparator_body_0.m1_m2_diff_0.n1 comparator_body_0.m1_m2_diff_0.m1_m2_array_3/n1_2_13.D 1.66263
R1656 comparator_body_0.m3_m4_diff_0.n1.n62 comparator_body_0.m1_m2_diff_0.m1_m2_array_2/n1_2_2.D 1.66263
R1657 comparator_body_0.m1_m2_diff_0.n1 comparator_body_0.m1_m2_diff_0.m1_m2_array_2/n1_2_13.D 1.66263
R1658 comparator_body_0.m3_m4_diff_0.n1.n61 comparator_body_0.m1_m2_diff_0.m1_m2_array_0/n1_2_2.D 1.66263
R1659 comparator_body_0.m3_m4_diff_0.n1.n44 comparator_body_0.m1_m2_diff_0.m1_m2_array_0/n1_2_13.D 1.66263
R1660 comparator_body_0.m3_m4_diff_0.n1.n58 comparator_body_0.m1_m2_diff_0.m1_m2_array_1/n1_2_2.D 1.66263
R1661 comparator_body_0.m1_m2_diff_0.m1_m2_array_3/n1_2_10.D comparator_body_0.m3_m4_diff_0.n1.n52 1.65746
R1662 comparator_body_0.m3_m4_diff_0.n1.n26 comparator_body_0.m1_m2_diff_0.m1_m2_array_2/n1_2_10.D 1.64914
R1663 comparator_body_0.m3_m4_diff_0.n1.n50 comparator_body_0.m1_m2_diff_0.m1_m2_array_0/n1_2_10.D 1.64914
R1664 comparator_body_0.m3_m4_diff_0.n1.n48 comparator_body_0.m1_m2_diff_0.m1_m2_array_1/n1_2_10.D 1.64914
R1665 comparator_body_0.m3_m4_diff_0.n1.n48 comparator_body_0.m3_m4_diff_0.n1.n36 1.6373
R1666 comparator_body_0.m3_m4_diff_0.m3_m4_array_2/p1_2$1_9.D comparator_body_0.m3_m4_diff_0.m3_m4_array_2/p1_2$1_13.D 1.6293
R1667 comparator_body_0.m3_m4_diff_0.n1.n15 comparator_body_0.m3_m4_diff_0.n1.n51 1.6205
R1668 comparator_body_0.m3_m4_diff_0.n1.n39 comparator_body_0.m3_m4_diff_0.n1.n16 0.456668
R1669 comparator_body_0.m3_m4_diff_0.n1.n52 comparator_body_0.m3_m4_diff_0.n1.n55 1.59946
R1670 comparator_body_0.m3_m4_diff_0.m3_m4_array_3/p1_2$1_14.D comparator_body_0.m3_m4_diff_0.n1.n25 1.5946
R1671 comparator_body_0.m3_m4_diff_0.n1.n20 comparator_body_0.m3_m4_diff_0.m3_m4_array_0/p1_2$1_14.D 1.5946
R1672 comparator_body_0.m3_m4_diff_0.m3_m4_array_1/p1_2$1_14.D comparator_body_0.m3_m4_diff_0.n1.n19 1.5946
R1673 comparator_body_0.m3_m4_diff_0.m3_m4_array_2/p1_2$1_14.D comparator_body_0.m3_m4_diff_0.n1.n35 1.5946
R1674 comparator_body_0.m3_m4_diff_0.n1.n50 comparator_body_0.m3_m4_diff_0.n1.n59 1.59154
R1675 comparator_body_0.m3_m4_diff_0.m3_m4_array_1/p1_2$1_1.D comparator_body_0.m3_m4_diff_0.n1.n21 1.58748
R1676 comparator_body_0.m3_m4_diff_0.m3_m4_array_0/p1_2$1_1.D comparator_body_0.m3_m4_diff_0.n1.n22 1.58748
R1677 comparator_body_0.m3_m4_diff_0.m3_m4_array_3/p1_2$1_1.D comparator_body_0.m3_m4_diff_0.n1.n23 1.58748
R1678 comparator_body_0.m3_m4_diff_0.m3_m4_array_2/p1_2$1_1.D comparator_body_0.m3_m4_diff_0.n1.n17 1.58713
R1679 comparator_body_0.m3_m4_diff_0.n1.n35 comparator_body_0.m3_m4_diff_0.m3_m4_array_2/p1_2$1_13.D 1.5855
R1680 comparator_body_0.m3_m4_diff_0.n1.n13 comparator_body_0.m3_m4_diff_0.m3_m4_array_2/p1_2$1_0.D 0.490965
R1681 comparator_body_0.m3_m4_diff_0.n1.n11 comparator_body_0.m3_m4_diff_0.m3_m4_array_1/p1_2$1_0.D 0.490965
R1682 comparator_body_0.m3_m4_diff_0.n1.n9 comparator_body_0.m3_m4_diff_0.m3_m4_array_0/p1_2$1_0.D 0.490965
R1683 comparator_body_0.m3_m4_diff_0.m3_m4_array_3/p1_2$1_10.D comparator_body_0.m3_m4_diff_0.m3_m4_array_3/p1_2$1_0.D 1.57788
R1684 comparator_body_0.m3_m4_diff_0.m3_m4_array_3/p1_2$1_9.D comparator_body_0.m3_m4_diff_0.m3_m4_array_3/p1_2$1_7.D 1.57788
R1685 comparator_body_0.m3_m4_diff_0.m3_m4_array_1/p1_2$1_13.D comparator_body_0.m3_m4_diff_0.n1.n19 1.5592
R1686 comparator_body_0.m3_m4_diff_0.m3_m4_array_0/p1_2$1_13.D comparator_body_0.m3_m4_diff_0.n1.n20 1.5317
R1687 comparator_body_0.m3_m4_diff_0.n1.n60 comparator_body_0.m1_m2_diff_0.m1_m2_array_1/n1_2_13.D 1.52535
R1688 comparator_body_0.m3_m4_diff_0.n1.n4 comparator_body_0.m3_m4_diff_0.n1.n31 1.42404
R1689 comparator_body_0.m3_m4_diff_0.n1.n33 comparator_body_0.m3_m4_diff_0.n1.n0 1.42404
R1690 comparator_body_0.m3_m4_diff_0.n1.n20 comparator_body_0.m3_m4_diff_0.n1.n34 1.3993
R1691 comparator_body_0.m3_m4_diff_0.n1.n19 comparator_body_0.m3_m4_diff_0.n1.n32 1.3993
R1692 comparator_body_0.m3_m4_diff_0.n1.n9 comparator_body_0.m3_m4_diff_0.m3_m4_array_0/p1_2$1_10.D 1.39821
R1693 comparator_body_0.m3_m4_diff_0.m3_m4_array_1/p1_2$1_10.D comparator_body_0.m3_m4_diff_0.n1.n11 1.39821
R1694 comparator_body_0.m3_m4_diff_0.n1.n13 comparator_body_0.m3_m4_diff_0.m3_m4_array_2/p1_2$1_10.D 1.39821
R1695 comparator_body_0.m3_m4_diff_0.n1.n0 comparator_body_0.m3_m4_diff_0.n1.n2 0.61471
R1696 comparator_body_0.m3_m4_diff_0.n1.n7 comparator_body_0.m3_m4_diff_0.n1.n10 0.60447
R1697 comparator_body_0.m3_m4_diff_0.n1.n14 comparator_body_0.m3_m4_diff_0.n1.n12 0.60447
R1698 comparator_body_0.m3_m4_diff_0.n1.n16 comparator_body_0.m3_m4_diff_0.m3_m4_array_3/p1_2$1_14.D 1.32574
R1699 comparator_body_0.m3_m4_diff_0.m3_m4_array_1/p1_2$1_13.D comparator_body_0.m3_m4_diff_0.m3_m4_array_1/p1_2$1_9.D 1.318
R1700 comparator_body_0.m3_m4_diff_0.n1.n53 comparator_body_0.m3_m4_diff_0.n1.n48 1.31346
R1701 comparator_body_0.m3_m4_diff_0.n1.n50 comparator_body_0.m3_m4_diff_0.n1.n49 1.31346
R1702 comparator_body_0.m3_m4_diff_0.n1.n26 comparator_body_0.m3_m4_diff_0.n1.n54 1.31346
R1703 comparator_body_0.m3_m4_diff_0.n1.n27 comparator_body_0.m3_m4_diff_0.m3_m4_array_1/p1_2$1_4.D 1.3113
R1704 comparator_body_0.m3_m4_diff_0.m3_m4_array_3/p1_2$1_4.D comparator_body_0.m3_m4_diff_0.m3_m4_array_3/p1_2$1_9.D 1.3095
R1705 comparator_body_0.m3_m4_diff_0.m3_m4_array_3/p1_2$1_1.D comparator_body_0.m3_m4_diff_0.m3_m4_array_3/p1_2$1_10.D 1.3095
R1706 comparator_body_0.m3_m4_diff_0.m3_m4_array_3/p1_2$1_10.D comparator_body_0.m3_m4_diff_0.n1.n23 1.3095
R1707 comparator_body_0.m3_m4_diff_0.n1.n22 comparator_body_0.m3_m4_diff_0.m3_m4_array_0/p1_2$1_10.D 1.3095
R1708 comparator_body_0.m3_m4_diff_0.m3_m4_array_0/p1_2$1_10.D comparator_body_0.m3_m4_diff_0.m3_m4_array_0/p1_2$1_1.D 1.3095
R1709 comparator_body_0.m3_m4_diff_0.m3_m4_array_1/p1_2$1_1.D comparator_body_0.m3_m4_diff_0.m3_m4_array_1/p1_2$1_10.D 1.3095
R1710 comparator_body_0.m3_m4_diff_0.m3_m4_array_1/p1_2$1_10.D comparator_body_0.m3_m4_diff_0.n1.n21 1.3095
R1711 comparator_body_0.m3_m4_diff_0.n1.n17 comparator_body_0.m3_m4_diff_0.m3_m4_array_2/p1_2$1_10.D 1.3095
R1712 comparator_body_0.m3_m4_diff_0.n1.n15 comparator_body_0.m3_m4_diff_0.m3_m4_array_2/p1_2$1_9.D 1.3095
R1713 comparator_body_0.m3_m4_diff_0.m3_m4_array_2/p1_2$1_9.D comparator_body_0.m3_m4_diff_0.m3_m4_array_2/p1_2$1_4.D 1.3095
R1714 comparator_body_0.m3_m4_diff_0.m3_m4_array_3/p1_2$1_0.D comparator_body_0.m3_m4_diff_0.m3_m4_array_3/p1_2$1_1.D 1.3095
R1715 comparator_body_0.m3_m4_diff_0.m3_m4_array_0/p1_2$1_1.D comparator_body_0.m3_m4_diff_0.m3_m4_array_0/p1_2$1_0.D 1.3095
R1716 comparator_body_0.m3_m4_diff_0.m3_m4_array_1/p1_2$1_0.D comparator_body_0.m3_m4_diff_0.m3_m4_array_1/p1_2$1_1.D 1.3095
R1717 comparator_body_0.m3_m4_diff_0.m3_m4_array_2/p1_2$1_1.D comparator_body_0.m3_m4_diff_0.m3_m4_array_2/p1_2$1_0.D 1.3095
R1718 comparator_body_0.m3_m4_diff_0.m3_m4_array_2/p1_2$1_10.D comparator_body_0.m3_m4_diff_0.m3_m4_array_2/p1_2$1_1.D 1.3095
R1719 comparator_body_0.m3_m4_diff_0.m3_m4_array_1/p1_2$1_9.D comparator_body_0.m3_m4_diff_0.m3_m4_array_1/p1_2$1_4.D 1.3095
R1720 comparator_body_0.m3_m4_diff_0.m3_m4_array_1/p1_2$1_4.D comparator_body_0.m3_m4_diff_0.m3_m4_array_1/p1_2$1_10.D 1.3095
R1721 comparator_body_0.m3_m4_diff_0.m3_m4_array_0/p1_2$1_4.D comparator_body_0.m3_m4_diff_0.m3_m4_array_0/p1_2$1_9.D 1.3095
R1722 comparator_body_0.m3_m4_diff_0.m3_m4_array_0/p1_2$1_7.D comparator_body_0.m3_m4_diff_0.m3_m4_array_0/p1_2$1_4.D 1.3095
R1723 comparator_body_0.m3_m4_diff_0.m3_m4_array_3/p1_2$1_7.D comparator_body_0.m3_m4_diff_0.m3_m4_array_3/p1_2$1_4.D 1.3095
R1724 comparator_body_0.m3_m4_diff_0.m3_m4_array_3/p1_2$1_9.D comparator_body_0.m3_m4_diff_0.m3_m4_array_3/p1_2$1_13.D 1.2941
R1725 comparator_body_0.m3_m4_diff_0.m3_m4_array_3/p1_2$1_10.D comparator_body_0.m3_m4_diff_0.m3_m4_array_3/p1_2$1_14.D 1.2941
R1726 comparator_body_0.m3_m4_diff_0.m3_m4_array_3/p1_2$1_10.D comparator_body_0.m3_m4_diff_0.m3_m4_array_3/p1_2$1_14.D 1.2941
R1727 comparator_body_0.m3_m4_diff_0.m3_m4_array_0/p1_2$1_10.D comparator_body_0.m3_m4_diff_0.m3_m4_array_0/p1_2$1_14.D 1.2941
R1728 comparator_body_0.m3_m4_diff_0.m3_m4_array_1/p1_2$1_10.D comparator_body_0.m3_m4_diff_0.m3_m4_array_1/p1_2$1_14.D 1.2941
R1729 comparator_body_0.m3_m4_diff_0.m3_m4_array_2/p1_2$1_10.D comparator_body_0.m3_m4_diff_0.m3_m4_array_2/p1_2$1_14.D 1.2941
R1730 comparator_body_0.m3_m4_diff_0.m3_m4_array_2/p1_2$1_9.D comparator_body_0.m3_m4_diff_0.m3_m4_array_2/p1_2$1_13.D 1.2941
R1731 comparator_body_0.m3_m4_diff_0.n1.n9 comparator_body_0.m3_m4_diff_0.n1.n8 0.402818
R1732 comparator_body_0.m3_m4_diff_0.n1.n10 comparator_body_0.m3_m4_diff_0.n1.n11 0.402818
R1733 comparator_body_0.m3_m4_diff_0.n1.n13 comparator_body_0.m3_m4_diff_0.n1.n12 0.402818
R1734 comparator_body_0.m3_m4_diff_0.m3_m4_array_1/p1_2$1_10.D comparator_body_0.m3_m4_diff_0.n1.n19 1.2941
R1735 comparator_body_0.m3_m4_diff_0.m3_m4_array_0/p1_2$1_7.D comparator_body_0.m3_m4_diff_0.n1.n20 1.2941
R1736 comparator_body_0.m3_m4_diff_0.m3_m4_array_3/p1_2$1_7.D comparator_body_0.m3_m4_diff_0.n1.n25 1.2941
R1737 comparator_body_0.m3_m4_diff_0.n1.n1 comparator_body_0.m3_m4_diff_0.n1.n0 0.264696
R1738 comparator_body_0.m3_m4_diff_0.n1.n45 comparator_body_0.m3_m4_diff_0.m3_m4_array_3/p1_2$1_14.D 1.2919
R1739 comparator_body_0.m3_m4_diff_0.n1.n33 comparator_body_0.m3_m4_diff_0.m3_m4_array_0/p1_2$1_14.D 0.321424
R1740 comparator_body_0.m3_m4_diff_0.n1.n6 comparator_body_0.m3_m4_diff_0.n1.n4 0.264696
R1741 comparator_body_0.m3_m4_diff_0.m3_m4_array_1/p1_2$1_1.D comparator_body_0.m3_m4_diff_0.n1.n28 0.471778
R1742 comparator_body_0.m3_m4_diff_0.m3_m4_array_1/p1_2$1_14.D comparator_body_0.m3_m4_diff_0.n1.n31 0.321424
R1743 comparator_body_0.m3_m4_diff_0.n1.n29 comparator_body_0.m3_m4_diff_0.m3_m4_array_2/p1_2$1_14.D 0.321424
R1744 comparator_body_0.m3_m4_diff_0.n1.n38 comparator_body_0.m3_m4_diff_0.n1.n18 0.575963
R1745 comparator_body_0.m3_m4_diff_0.m3_m4_array_2/p1_2$1_4.D comparator_body_0.m3_m4_diff_0.n1.n51 1.2919
R1746 comparator_body_0.m3_m4_diff_0.n1.n29 comparator_body_0.m3_m4_diff_0.n1.n30 0.486488
R1747 comparator_body_0.m3_m4_diff_0.m3_m4_array_2/p1_2$1_1.D comparator_body_0.m3_m4_diff_0.n1.n38 1.2919
R1748 comparator_body_0.m3_m4_diff_0.n1.n46 comparator_body_0.m3_m4_diff_0.n1.n24 0.331716
R1749 comparator_body_0.m3_m4_diff_0.n1.n45 comparator_body_0.m3_m4_diff_0.n1.n39 1.28781
R1750 comparator_body_0.m3_m4_diff_0.n1.n51 comparator_body_0.m3_m4_diff_0.n1.n38 1.28781
R1751 comparator_body_0.m3_m4_diff_0.m3_m4_array_0/p1_2$1_7.D comparator_body_0.m3_m4_diff_0.m3_m4_array_0/p1_2$1_9.D 1.24295
R1752 comparator_body_0.m3_m4_diff_0.m3_m4_array_0/p1_2$1_10.D comparator_body_0.m3_m4_diff_0.m3_m4_array_0/p1_2$1_7.D 1.24268
R1753 comparator_body_0.m3_m4_diff_0.m3_m4_array_2/p1_2$1_13.D comparator_body_0.m3_m4_diff_0.n1.n30 1.23969
R1754 comparator_body_0.m3_m4_diff_0.n1.n37 comparator_body_0.m3_m4_diff_0.n1.n47 0.526573
R1755 comparator_body_0.m3_m4_diff_0.n1.n24 comparator_body_0.m3_m4_diff_0.m3_m4_array_3/p1_2$1_13.D 0.532773
R1756 comparator_body_0.m3_m4_diff_0.n1.n0 comparator_body_0.m3_m4_diff_0.m3_m4_array_0/p1_2$1_13.D 1.1115
R1757 comparator_body_0.m3_m4_diff_0.n1.n46 comparator_body_0.m3_m4_diff_0.n1.n45 1.10475
R1758 comparator_body_0.m3_m4_diff_0.m3_m4_array_3/p1_2$1_1.D comparator_body_0.m3_m4_diff_0.n1.n1 0.471778
R1759 comparator_body_0.m3_m4_diff_0.n1.n6 comparator_body_0.m3_m4_diff_0.m3_m4_array_0/p1_2$1_1.D 0.471778
R1760 comparator_body_0.m3_m4_diff_0.n1.n38 comparator_body_0.m3_m4_diff_0.n1.n37 1.09121
R1761 comparator_body_0.m3_m4_diff_0.n1.n4 comparator_body_0.m3_m4_diff_0.m3_m4_array_1/p1_2$1_13.D 1.084
R1762 comparator_body_0.m3_m4_diff_0.n1.n30 comparator_body_0.m3_m4_diff_0.n1.n27 0.485129
R1763 comparator_body_0.m3_m4_diff_0.m3_m4_array_0/p1_2$1_9.D comparator_body_0.m3_m4_diff_0.m3_m4_array_0/p1_2$1_13.D 1.0103
R1764 comparator_body_0.m3_m4_diff_0.n1.n47 comparator_body_0.m3_m4_diff_0.m3_m4_array_2/p1_2$1_1.D 1.00862
C0 a_n421_10196# ibias 0.83223f
C1 a_n6869_2934# AVDD 0.23311f
C2 a_n3314_n8459# a_n3001_n8459# 0.11313f
C3 inn a_n3001_3553# 0.24288f
C4 a_479_n986# ibias 0.72692f
C5 a_n5969_10204# comparator_body_0.outx 0.19529f
C6 comparator_body_0.outx a_n3898_n589# 0.18347f
C7 a_5747_3330# out 0.10865f
C8 a_n105_n3602# ibias 0.81675f
C9 a_n6285_7824# comparator_body_0.outx 0.09413f
C10 a_n6285_4124# comparator_body_0.outx 0.19516f
C11 inp a_n3314_3553# 0.24254f
C12 AVDD1V2 a_5747_3330# 0.33544f
C13 inn a_n2415_6033# 0.09261f
C14 inn a_n3314_n8459# 0.25363f
C15 comparator_body_0.outx AVDD 53.0098f
C16 inn a_n3898_n1829# 0.24476f
C17 a_n3001_6033# inp 0.05336f
C18 a_n5385_6504# AVDD 0.2306f
C19 ibias a_n105_6390# 0.81675f
C20 a_n3898_n8459# inp 0.25432f
C21 a_n2415_n589# inp 0.05339f
C22 a_n3898_10164# comparator_body_0.outx 0.18347f
C23 a_n6285_11394# comparator_body_0.outx 0.21057f
C24 a_n5969_n1956# AVDD 0.24138f
C25 a_n3001_n3069# inp 0.24252f
C26 a_n6285_n4466# AVDD 0.2495f
C27 comparator_body_0.outx a_n6869_6504# 0.07811f
C28 a_n5969_5314# comparator_body_0.outx 0.1953f
C29 a_n5969_n6846# AVDD 0.24138f
C30 inn a_n3314_n4739# 0.06065f
C31 comparator_body_0.outx a_n3898_3553# 0.25863f
C32 a_n5969_n3276# comparator_body_0.outx 0.09565f
C33 a_2989_2085# comparator_body_0.outx 2.17064f
C34 ibias AVDD 0.02207f
C35 a_479_9006# ibias 0.72692f
C36 a_n3314_n4739# a_n3001_n4739# 0.11313f
C37 a_n6285_n766# AVDD 0.2406f
C38 a_3257_1513# a_2989_2085# 0.18937f
C39 a_n3897_n4739# inp 0.06849f
C40 a_n5385_2934# AVDD 0.2401f
C41 a_n105_n7172# ibias 0.7281f
C42 inn a_n3898_n589# 0.05769f
C43 inn a_n3314_8924# 0.05182f
C44 a_n1005_n5982# ibias 0.81417f
C45 a_n2415_n7219# comparator_body_0.outx 0.1814f
C46 a_n3314_3553# a_n3001_3553# 0.11313f
C47 comparator_body_0.outx a_n5969_424# 0.1953f
C48 inp a_n2415_651# 0.24262f
C49 a_n421_204# ibias 0.83223f
C50 inn AVDD 0.04339f
C51 a_n3314_n3069# comparator_body_0.outx 0.08299f
C52 comparator_body_0.outx a_n6285_n1956# 0.09413f
C53 a_n3898_8924# inp 0.06821f
C54 a_n1005_n986# ibias 0.81417f
C55 out AVDD 0.03353f
C56 a_n6869_n5656# AVDD 0.22127f
C57 a_n5385_1614# comparator_body_0.outx 0.1941f
C58 AVDD1V2 AVDD 0.2206f
C59 comparator_body_0.outx a_n2415_7684# 0.25799f
C60 a_n3898_10164# inn 0.05498f
C61 a_n105_2820# ibias 0.7281f
C62 a_n1005_204# ibias 0.74374f
C63 a_n3314_8924# a_n3001_8924# 0.11313f
C64 a_n5385_10204# AVDD 0.22189f
C65 a_n2415_n3069# comparator_body_0.outx 0.25799f
C66 a_n2415_11404# inp 0.24262f
C67 comparator_body_0.outx a_n6869_n6846# 0.19262f
C68 inn a_n3001_10164# 0.05196f
C69 a_479_11386# ibias 0.72802f
C70 a_n5969_4124# AVDD 0.2488f
C71 inn a_n3898_3553# 0.24476f
C72 a_2989_2085# out 2.09031f
C73 comparator_body_0.outx a_n3001_651# 0.09117f
C74 a_n1005_n3602# ibias 0.81667f
C75 a_n5385_9014# comparator_body_0.outx 0.19148f
C76 a_n5385_5314# comparator_body_0.outx 0.104f
C77 inp a_n2415_4793# 0.05339f
C78 comparator_body_0.outx a_n2415_10164# 0.258f
C79 inn a_n3314_6033# 0.06065f
C80 AVDD1V2 a_2989_2085# 3.7654f
C81 inp a_n3001_2313# 0.24252f
C82 inn a_n2415_n7219# 0.18708f
C83 a_n5969_11394# AVDD 0.24966f
C84 inn a_n3314_n3069# 0.25354f
C85 a_n3897_6033# inp 0.06849f
C86 a_n6285_6504# AVDD 0.24138f
C87 ibias a_n1005_6390# 0.81667f
C88 a_n3001_n7219# inp 0.05336f
C89 ibias a_479_5200# 0.83215f
C90 a_n3001_11404# comparator_body_0.outx 0.09117f
C91 inn a_n2415_7684# 0.27988f
C92 a_n3898_n3069# inp 0.25848f
C93 a_n5385_n3276# AVDD 0.23146f
C94 comparator_body_0.outx a_n5969_7824# 0.20936f
C95 a_n3314_10164# a_n3001_10164# 0.11313f
C96 a_n6285_10204# comparator_body_0.outx 0.10672f
C97 comparator_body_0.outx a_n6285_5314# 0.10672f
C98 inn a_n2415_n3069# 0.27988f
C99 inn a_n3001_n5979# 0.0522f
C100 a_n6869_n3276# comparator_body_0.outx 0.07811f
C101 a_n421_9006# ibias 0.727f
C102 comparator_body_0.outx a_n3314_2313# 0.08299f
C103 a_n5385_424# AVDD 0.22442f
C104 a_n1005_n7172# ibias 0.72989f
C105 inn a_n3001_651# 0.25371f
C106 a_n3314_n5979# inp 0.05337f
C107 a_n6869_424# AVDD 0.21796f
C108 inn a_n2415_10164# 0.24749f
C109 a_n105_n4792# ibias 0.74383f
C110 inn a_n3001_7684# 0.06079f
C111 a_2989_2085# a_5163_3330# 0.26078f
C112 inp a_n3314_651# 0.24254f
C113 a_n6869_11394# comparator_body_0.outx 0.0777f
C114 a_n2415_n1829# comparator_body_0.outx 0.1814f
C115 comparator_body_0.outx a_n5385_n766# 0.19148f
C116 a_n5969_n4466# AVDD 0.24107f
C117 a_n6285_1614# comparator_body_0.outx 0.21109f
C118 a_n3314_7684# inp 0.05337f
C119 a_n6285_n6846# AVDD 0.24955f
C120 a_n3001_11404# inn 0.25344f
C121 a_n1005_2820# ibias 0.72802f
C122 a_n105_1394# ibias 0.81675f
C123 a_n3314_6033# a_n3001_6033# 0.11313f
C124 a_n3314_11404# inp 0.24243f
C125 comparator_body_0.outx a_n5969_n5656# 0.10658f
C126 a_n421_11386# ibias 0.7281f
C127 a_n6869_7824# AVDD 0.23421f
C128 a_n3898_n5979# comparator_body_0.outx 0.18262f
C129 a_n6869_4124# AVDD 0.22379f
C130 a_5133_1513# out 0.19008f
C131 inn a_n3314_2313# 0.25354f
C132 comparator_body_0.outx a_n3897_651# 0.26946f
C133 a_n105_n2176# ibias 0.7281f
C134 a_n6285_9014# comparator_body_0.outx 0.19516f
C135 a_n3314_n3069# a_n3001_n3069# 0.11313f
C136 comparator_body_0.outx a_n3898_7684# 0.18276f
C137 a_n6869_2934# comparator_body_0.outx 0.19162f
C138 inp a_n3898_2313# 0.25848f
C139 inn a_n3001_4793# 0.0522f
C140 inn a_n3314_n7219# 0.05182f
C141 inn a_n2415_n1829# 0.18752f
C142 a_n5385_7824# AVDD 0.24123f
C143 a_n3314_4793# inp 0.05337f
C144 a_n3898_n7219# inp 0.06821f
C145 ibias a_n421_5200# 0.83223f
C146 a_n3897_11404# comparator_body_0.outx 0.2698f
C147 a_n3001_n1829# inp 0.05336f
C148 a_3871_3330# AVDD 0.33544f
C149 a_n6285_n3276# AVDD 0.24138f
C150 a_3257_1513# comparator_body_0.outx 0.24897f
C151 comparator_body_0.outx a_n5385_6504# 0.19393f
C152 inn a_n3898_n5979# 0.05769f
C153 a_n5969_n1956# comparator_body_0.outx 0.20936f
C154 a_479_10196# ibias 0.83215f
C155 comparator_body_0.outx a_n2415_3553# 0.1814f
C156 a_n6285_n4466# comparator_body_0.outx 0.10672f
C157 a_n105_7816# ibias 0.7281f
C158 inn a_n3897_651# 0.25569f
C159 a_n6869_n1956# AVDD 0.23336f
C160 a_5717_1513# a_2989_2085# 0.3019f
C161 a_n2415_n4739# inp 0.24262f
C162 a_n5969_n6846# comparator_body_0.outx 0.20889f
C163 a_n5969_1614# AVDD 0.24966f
C164 a_n1005_n4792# ibias 0.74584f
C165 a_n2415_n8459# comparator_body_0.outx 0.25799f
C166 comparator_body_0.outx a_n3898_4793# 0.18347f
C167 a_n2415_n5979# comparator_body_0.outx 0.258f
C168 a_3871_3330# a_2989_2085# 0.10837f
C169 a_479_n5982# ibias 0.72692f
C170 inp a_n2415_2313# 0.05339f
C171 comparator_body_0.outx ibias 0.18907f
C172 comparator_body_0.outx a_n6285_n766# 0.19516f
C173 inp a_n3001_n589# 0.24249f
C174 a_n5385_2934# comparator_body_0.outx 0.07819f
C175 a_n2415_8924# inp 0.22664f
C176 a_n5385_n5656# AVDD 0.2148f
C177 a_n3897_11404# inn 0.25325f
C178 a_n105_4010# ibias 0.81425f
C179 a_n1005_1394# ibias 0.81806f
C180 inn comparator_body_0.outx 10.7314f
C181 comparator_body_0.outx a_n6869_n5656# 0.10522f
C182 comparator_body_0.outx out 0.01846f
C183 a_n5969_9014# AVDD 0.2488f
C184 a_n3001_n4739# comparator_body_0.outx 0.09117f
C185 AVDD1V2 comparator_body_0.outx 0.04409f
C186 a_n105_10196# ibias 0.74383f
C187 a_n6285_2934# AVDD 0.24955f
C188 inn a_n2415_3553# 0.19107f
C189 a_n1005_n2176# ibias 0.72802f
C190 a_n5385_10204# comparator_body_0.outx 0.104f
C191 comparator_body_0.outx a_n3314_n589# 0.08299f
C192 inn a_n2415_n8459# 0.2837f
C193 comparator_body_0.outx a_n3001_8924# 0.08298f
C194 a_n5969_4124# comparator_body_0.outx 0.10658f
C195 inp a_n3001_3553# 0.05336f
C196 inn a_n2415_n5979# 0.27049f
C197 inn a_n3898_4793# 0.05769f
C198 inn ibias 0.26473f
C199 inn a_n3001_n8459# 0.0609f
C200 inn a_n3314_n1829# 0.05182f
C201 a_n6869_10204# AVDD 0.21543f
C202 a_n2415_6033# inp 0.24262f
C203 a_n6869_5314# AVDD 0.21775f
C204 ibias a_479_6390# 0.72802f
C205 a_n3314_n8459# inp 0.05337f
C206 a_n3898_n1829# inp 0.06821f
C207 a_n3314_10164# comparator_body_0.outx 0.08299f
C208 a_n5969_11394# comparator_body_0.outx 0.09513f
C209 a_n5385_n1956# AVDD 0.24036f
C210 comparator_body_0.outx a_n6285_6504# 0.21109f
C211 a_n5385_n6846# AVDD 0.22338f
C212 inn a_n3001_n4739# 0.25371f
C213 AVDD1V2 out 0.79303f
C214 a_n5385_n3276# comparator_body_0.outx 0.1941f
C215 a_n1005_7816# ibias 0.72802f
C216 a_3841_1513# a_2989_2085# 0.10063f
C217 a_n3314_n4739# inp 0.24254f
C218 a_n5969_n766# AVDD 0.2488f
C219 a_479_n7172# ibias 0.81527f
C220 a_n6869_1614# AVDD 0.24012f
C221 a_n3314_n5979# a_n3001_n5979# 0.11313f
C222 inn a_n3314_n589# 0.24272f
C223 comparator_body_0.outx a_n3001_6033# 0.09117f
C224 inn a_n3001_8924# 0.24288f
C225 a_n421_n5982# ibias 0.727f
C226 a_n3898_n8459# comparator_body_0.outx 0.18188f
C227 a_n2415_n589# comparator_body_0.outx 0.258f
C228 comparator_body_0.outx a_n5385_424# 0.10386f
C229 a_n105_204# ibias 0.74383f
C230 inp a_n3898_n589# 0.25924f
C231 a_n3314_2313# a_n3001_2313# 0.11313f
C232 a_n421_n986# ibias 0.727f
C233 a_n3314_8924# inp 0.24254f
C234 a_n6285_n5656# AVDD 0.2406f
C235 a_n6869_424# comparator_body_0.outx 0.19162f
C236 a_n3314_651# a_n3001_651# 0.11313f
C237 inp AVDD 1.45061f
C238 a_n1005_4010# ibias 0.81417f
C239 a_n3314_10164# inn 0.24262f
C240 a_479_2820# ibias 0.81527f
C241 comparator_body_0.outx a_n5969_n4466# 0.1953f
C242 a_n3897_n4739# comparator_body_0.outx 0.2686f
C243 a_n6869_9014# AVDD 0.22401f
C244 a_n3898_10164# inp 0.25665f
C245 comparator_body_0.outx a_n6285_n6846# 0.09366f
C246 a_n3314_n7219# a_n3001_n7219# 0.11313f
C247 a_n3314_7684# a_n3001_7684# 0.11313f
C248 a_n1005_10196# ibias 0.74374f
C249 a_n5385_4124# AVDD 0.21733f
C250 inn a_n3314_3553# 0.05182f
C251 a_n105_n986# ibias 0.81425f
C252 a_n3001_10164# inp 0.24247f
C253 comparator_body_0.outx a_n2415_651# 0.18066f
C254 a_5163_3330# out 0.20312f
C255 a_n421_n3602# ibias 0.7281f
C256 a_n6869_7824# comparator_body_0.outx 0.19162f
C257 inp a_n3898_3553# 0.06821f
C258 a_n6869_4124# comparator_body_0.outx 0.10522f
C259 comparator_body_0.outx a_n3898_8924# 0.25863f
C260 AVDD1V2 a_5163_3330# 0.3297f
C261 inn a_n3001_6033# 0.25371f
C262 a_n5385_11394# AVDD 0.21562f
C263 inn a_n2415_n589# 0.27049f
C264 inn a_n3001_n3069# 0.06079f
C265 a_n3314_6033# inp 0.24254f
C266 a_n5969_6504# AVDD 0.24966f
C267 a_n3314_11404# a_n3001_11404# 0.11313f
C268 ibias a_n421_6390# 0.7281f
C269 a_n2415_n7219# inp 0.22554f
C270 a_n2415_11404# comparator_body_0.outx 0.18066f
C271 a_n3314_n3069# inp 0.05337f
C272 a_n6869_n4466# AVDD 0.21791f
C273 comparator_body_0.outx a_n5385_7824# 0.07809f
C274 a_3287_3330# AVDD 0.32967f
C275 a_n2415_7684# inp 0.05339f
C276 inn a_n3897_n4739# 0.25569f
C277 comparator_body_0.outx a_n2415_4793# 0.258f
C278 a_3871_3330# comparator_body_0.outx 0.3131f
C279 a_n6285_n3276# comparator_body_0.outx 0.21109f
C280 a_n105_9006# ibias 0.81425f
C281 a_n6869_n766# AVDD 0.22384f
C282 a_n2415_n3069# inp 0.05339f
C283 a_n421_n7172# ibias 0.81535f
C284 a_n5969_2934# AVDD 0.24138f
C285 inn a_n2415_651# 0.09261f
C286 a_n3001_n5979# inp 0.24249f
C287 comparator_body_0.outx a_n3897_6033# 0.26946f
C288 a_n6285_424# AVDD 0.2495f
C289 inn a_n3898_8924# 0.24476f
C290 a_479_n4792# ibias 0.83215f
C291 a_n3001_n7219# comparator_body_0.outx 0.08298f
C292 a_2989_2085# a_5747_3330# 0.31253f
C293 inp a_n3001_651# 0.05336f
C294 a_n3898_n3069# comparator_body_0.outx 0.18269f
C295 a_3287_3330# a_2989_2085# 0.20295f
C296 comparator_body_0.outx a_n6869_n1956# 0.19162f
C297 a_n2415_10164# inp 0.05339f
C298 a_n5385_n4466# AVDD 0.22437f
C299 a_n5969_1614# comparator_body_0.outx 0.09565f
C300 a_n3001_7684# inp 0.24252f
C301 a_n2415_11404# inn 0.06676f
C302 a_n421_2820# ibias 0.81535f
C303 a_479_1394# ibias 0.72802f
C304 a_n5969_10204# AVDD 0.24107f
C305 a_n3001_11404# inp 0.05326f
C306 comparator_body_0.outx a_n5385_n5656# 0.19099f
C307 a_n3314_4793# a_n3001_4793# 0.11313f
C308 a_n105_11386# ibias 0.81675f
C309 a_n6285_7824# AVDD 0.24955f
C310 a_n3314_n5979# comparator_body_0.outx 0.08299f
C311 a_n6285_4124# AVDD 0.2406f
C312 a_5717_1513# out 0.10091f
C313 inn a_n2415_4793# 0.27049f
C314 inn a_n3001_2313# 0.06079f
C315 a_479_n2176# ibias 0.81527f
C316 a_n5969_9014# comparator_body_0.outx 0.10658f
C317 inn a_n3897_6033# 0.25569f
C318 inp a_n3314_2313# 0.05337f
C319 comparator_body_0.outx a_n3314_7684# 0.08299f
C320 a_n6285_2934# comparator_body_0.outx 0.09413f
C321 inn a_n3001_n7219# 0.24288f
C322 a_n6285_11394# AVDD 0.24138f
C323 a_n6869_6504# AVDD 0.23898f
C324 ibias a_479_7816# 0.81527f
C325 a_n5969_5314# AVDD 0.24107f
C326 a_n3001_4793# inp 0.24249f
C327 a_n3314_n7219# inp 0.24254f
C328 ibias a_n105_5200# 0.74383f
C329 a_n2415_n1829# inp 0.2254f
C330 a_2989_2085# AVDD 0.83211f
C331 a_n5969_n3276# AVDD 0.24966f
C332 a_n6869_10204# comparator_body_0.outx 0.19162f
C333 a_3841_1513# comparator_body_0.outx 0.3017f
C334 comparator_body_0.outx a_n6869_5314# 0.19162f
C335 inn a_n3314_n5979# 0.24272f
C336 a_n5385_n1956# comparator_body_0.outx 0.07819f
C337 a_n1005_9006# ibias 0.81417f
C338 comparator_body_0.outx a_n3898_2313# 0.18271f
C339 a_n5969_424# AVDD 0.24107f
C340 inn a_n3314_651# 0.06065f
C341 a_n6285_n1956# AVDD 0.24955f
C342 a_n3898_n5979# inp 0.25924f
C343 a_n5385_1614# AVDD 0.23171f
C344 a_n5385_n6846# comparator_body_0.outx 0.07727f
C345 a_n421_n4792# ibias 0.83223f
C346 a_n3898_n7219# comparator_body_0.outx 0.25863f
C347 comparator_body_0.outx a_n3314_4793# 0.08299f
C348 inn a_n3314_7684# 0.25354f
C349 inp a_n3897_651# 0.06849f
C350 a_n3001_n1829# comparator_body_0.outx 0.08298f
C351 comparator_body_0.outx a_n5969_n766# 0.10658f
C352 a_n6869_1614# comparator_body_0.outx 0.07811f
C353 a_n3898_7684# inp 0.25848f
C354 a_n6869_n6846# AVDD 0.21688f
C355 a_n3314_11404# inn 0.06056f
C356 a_479_4010# ibias 0.72692f
C357 a_n421_1394# ibias 0.7281f
C358 comparator_body_0.outx a_n6285_n5656# 0.19515f
C359 a_n3897_11404# inp 0.05329f
C360 a_n1005_11386# ibias 0.81895f
C361 a_n2415_n4739# comparator_body_0.outx 0.18066f
C362 a_n5385_9014# AVDD 0.21755f
C363 a_n5385_5314# AVDD 0.22421f
C364 comparator_body_0.outx inp 7.93003f
C365 a_n3314_n1829# a_n3001_n1829# 0.11313f
C366 comparator_body_0.outx a_n2415_2313# 0.25799f
C367 a_n421_n2176# ibias 0.81535f
C368 a_n6869_9014# comparator_body_0.outx 0.10522f
C369 comparator_body_0.outx a_n2415_8924# 0.1814f
C370 a_n5385_4124# comparator_body_0.outx 0.19148f
C371 inp a_n2415_3553# 0.22474f
C372 inn a_n3314_4793# 0.24272f
C373 inn a_n3898_n7219# 0.24476f
C374 inn a_n3001_n1829# 0.24288f
C375 a_n5969_7824# AVDD 0.24138f
C376 a_n2415_n8459# inp 0.05339f
C377 a_n6285_10204# AVDD 0.2495f
C378 a_n3898_4793# inp 0.25924f
C379 a_n2415_n5979# inp 0.05339f
C380 a_n6285_5314# AVDD 0.2495f
C381 ibias a_n1005_5200# 0.74374f
C382 inp ibias 0.04438f
C383 a_n3001_n8459# inp 0.24252f
C384 a_n3314_n1829# inp 0.24254f
C385 a_n5385_11394# comparator_body_0.outx 0.20948f
C386 a_n6869_n3276# AVDD 0.23986f
C387 comparator_body_0.outx a_n5969_6504# 0.09565f
C388 inn a_n2415_n4739# 0.09261f
C389 inn inp 9.95187f
C390 comparator_body_0.outx a_n3001_3553# 0.08298f
C391 a_n6869_n4466# comparator_body_0.outx 0.19162f
C392 a_n421_7816# ibias 0.81535f
C393 a_n6869_11394# AVDD 0.22339f
C394 inn a_n2415_2313# 0.27988f
C395 a_3287_3330# comparator_body_0.outx 0.25632f
C396 a_n5385_n766# AVDD 0.21738f
C397 a_5133_1513# a_2989_2085# 0.24012f
C398 a_n3001_n4739# inp 0.05336f
C399 a_n6285_1614# AVDD 0.24138f
C400 inn a_n3001_n589# 0.0522f
C401 a_479_n3602# ibias 0.72802f
C402 comparator_body_0.outx a_n2415_6033# 0.18066f
C403 inn a_n2415_8924# 0.1797f
C404 a_n105_n5982# ibias 0.81425f
C405 a_n3314_n8459# comparator_body_0.outx 0.08299f
C406 a_n3898_n1829# comparator_body_0.outx 0.25863f
C407 comparator_body_0.outx a_n6869_n766# 0.10522f
C408 inp a_n3314_n589# 0.05337f
C409 a_479_204# ibias 0.83215f
C410 a_n5969_2934# comparator_body_0.outx 0.20936f
C411 a_n5969_n5656# AVDD 0.2488f
C412 a_n3001_8924# inp 0.05336f
C413 a_n6285_424# comparator_body_0.outx 0.10672f
C414 a_n3314_n589# a_n3001_n589# 0.11313f
C415 a_n421_4010# ibias 0.727f
C416 comparator_body_0.outx a_n5385_n4466# 0.1038f
C417 a_n6285_9014# AVDD 0.2406f
C418 a_n3314_10164# inp 0.05335f
C419 out AVSS 1.1156f
C420 ibias AVSS 0.13147p
C421 AVDD1V2 AVSS 1.01527f
C422 AVDD AVSS 23.93123f
C423 a_479_n7172# AVSS 0.84076f
C424 a_n105_n7172# AVSS 0.23828f
C425 a_n421_n7172# AVSS 0.86696f
C426 a_n1005_n7172# AVSS 0.22891f
C427 a_479_n5982# AVSS 0.21438f
C428 a_n105_n5982# AVSS 0.86355f
C429 a_n421_n5982# AVSS 0.24107f
C430 a_n1005_n5982# AVSS 0.84961f
C431 a_479_n4792# AVSS 0.83967f
C432 a_n105_n4792# AVSS 0.85534f
C433 a_n421_n4792# AVSS 0.86681f
C434 a_n1005_n4792# AVSS 0.84405f
C435 a_479_n3602# AVSS 0.23067f
C436 a_n105_n3602# AVSS 0.24707f
C437 a_n421_n3602# AVSS 0.24137f
C438 a_n1005_n3602# AVSS 0.24673f
C439 a_479_n2176# AVSS 0.23775f
C440 a_n105_n2176# AVSS 0.85615f
C441 a_n421_n2176# AVSS 0.24966f
C442 a_n1005_n2176# AVSS 0.23859f
C443 a_479_n986# AVSS 0.83394f
C444 a_n105_n986# AVSS 0.24625f
C445 a_n421_n986# AVSS 0.85837f
C446 a_n1005_n986# AVSS 0.85187f
C447 a_5717_1513# AVSS 0.34815f
C448 a_5133_1513# AVSS 3.2874f
C449 a_3841_1513# AVSS 1.04329f
C450 a_3257_1513# AVSS 1.04881f
C451 a_479_204# AVSS 0.22239f
C452 a_n105_204# AVSS 0.23735f
C453 a_n421_204# AVSS 0.24881f
C454 a_n1005_204# AVSS 0.22795f
C455 a_479_1394# AVSS 0.84806f
C456 a_n105_1394# AVSS 0.86507f
C457 a_n421_1394# AVSS 0.85867f
C458 a_n1005_1394# AVSS 0.86409f
C459 a_3871_3330# AVSS 0.69251f
C460 a_3287_3330# AVSS 0.69239f
C461 a_479_2820# AVSS 0.85496f
C462 a_n105_2820# AVSS 0.23884f
C463 a_n421_2820# AVSS 0.24966f
C464 a_n1005_2820# AVSS 0.23854f
C465 a_479_4010# AVSS 0.21663f
C466 a_n105_4010# AVSS 0.86355f
C467 a_n421_4010# AVSS 0.85907f
C468 a_n1005_4010# AVSS 0.85256f
C469 a_479_5200# AVSS 0.22237f
C470 a_n105_5200# AVSS 0.23735f
C471 a_n421_5200# AVSS 0.24881f
C472 a_n1005_5200# AVSS 0.22733f
C473 a_479_6390# AVSS 0.84797f
C474 a_n105_6390# AVSS 0.86506f
C475 a_n421_6390# AVSS 0.85867f
C476 a_n1005_6390# AVSS 0.86523f
C477 a_479_7816# AVSS 0.23775f
C478 a_n105_7816# AVSS 0.23885f
C479 a_n421_7816# AVSS 0.24966f
C480 a_n1005_7816# AVSS 0.23762f
C481 a_479_9006# AVSS 0.83394f
C482 a_n105_9006# AVSS 0.86355f
C483 a_n421_9006# AVSS 0.85907f
C484 a_n1005_9006# AVSS 0.85189f
C485 a_479_10196# AVSS 0.22014f
C486 a_n105_10196# AVSS 0.23735f
C487 a_n421_10196# AVSS 0.86611f
C488 a_n1005_10196# AVSS 0.22452f
C489 a_479_11386# AVSS 0.83318f
C490 a_n105_11386# AVSS 0.86381f
C491 a_n421_11386# AVSS 0.24137f
C492 a_n1005_11386# AVSS 0.85061f
C493 a_n2415_n8459# AVSS 0.11587f
C494 a_n3001_n8459# AVSS 0.11416f
C495 a_n3314_n8459# AVSS 0.11418f
C496 a_n3898_n8459# AVSS 0.13577f
C497 a_n2415_n7219# AVSS 17.14092f
C498 a_n3001_n7219# AVSS 0.1145f
C499 a_n3314_n7219# AVSS 0.11449f
C500 a_n3898_n7219# AVSS 0.11572f
C501 a_n2415_n5979# AVSS 0.11617f
C502 a_n3001_n5979# AVSS 0.1145f
C503 a_n3314_n5979# AVSS 0.11449f
C504 a_n3898_n5979# AVSS 0.11572f
C505 a_n2415_n4739# AVSS 0.11583f
C506 a_n3001_n4739# AVSS 0.1142f
C507 a_n3314_n4739# AVSS 0.11413f
C508 a_n3897_n4739# AVSS 0.11512f
C509 a_n2415_n3069# AVSS 0.11587f
C510 a_n3001_n3069# AVSS 0.11416f
C511 a_n3314_n3069# AVSS 0.11418f
C512 a_n3898_n3069# AVSS 0.12682f
C513 a_n2415_n1829# AVSS 0.11617f
C514 a_n3001_n1829# AVSS 0.1145f
C515 a_n3314_n1829# AVSS 0.11449f
C516 a_n3898_n1829# AVSS 20.06487f
C517 a_n2415_n589# AVSS 0.11617f
C518 a_n3001_n589# AVSS 0.1145f
C519 a_n3314_n589# AVSS 0.11449f
C520 a_n3898_n589# AVSS 0.11572f
C521 a_n2415_651# AVSS 0.11583f
C522 a_n3001_651# AVSS 0.1142f
C523 a_n3314_651# AVSS 0.11413f
C524 a_n3897_651# AVSS 0.11512f
C525 a_n2415_2313# AVSS 0.11587f
C526 a_n3001_2313# AVSS 0.11416f
C527 a_n3314_2313# AVSS 0.11418f
C528 a_n3898_2313# AVSS 0.12673f
C529 a_n2415_3553# AVSS 0.11617f
C530 a_n3001_3553# AVSS 0.1145f
C531 a_n3314_3553# AVSS 0.11449f
C532 a_n3898_3553# AVSS 0.11572f
C533 a_n2415_4793# AVSS 0.11617f
C534 a_n3001_4793# AVSS 0.1145f
C535 a_n3314_4793# AVSS 0.11449f
C536 a_n3898_4793# AVSS 0.11572f
C537 a_n2415_6033# AVSS 0.11583f
C538 a_n3001_6033# AVSS 0.1142f
C539 a_n3314_6033# AVSS 0.11413f
C540 a_n3897_6033# AVSS 0.11512f
C541 a_n2415_7684# AVSS 0.11587f
C542 a_n3001_7684# AVSS 0.11416f
C543 a_n3314_7684# AVSS 0.11418f
C544 a_n3898_7684# AVSS 0.12659f
C545 a_n2415_8924# AVSS 0.11617f
C546 a_n3001_8924# AVSS 0.1145f
C547 a_n3314_8924# AVSS 0.11449f
C548 a_n3898_8924# AVSS 0.11572f
C549 a_n2415_10164# AVSS 0.12898f
C550 a_n3001_10164# AVSS 0.11477f
C551 a_n3314_10164# AVSS 0.11464f
C552 a_n3898_10164# AVSS 0.12082f
C553 a_n2415_11404# AVSS 0.15727f
C554 a_n3001_11404# AVSS 0.12153f
C555 a_n3314_11404# AVSS 0.12013f
C556 a_n3897_11404# AVSS 0.15677f
C557 a_n5385_n6846# AVSS 1.51185f
C558 a_n6869_n6846# AVSS 1.51185f
C559 a_n5969_n5656# AVSS 1.51185f
C560 a_n6285_n5656# AVSS 1.51185f
C561 a_n5385_n4466# AVSS 1.51185f
C562 a_n5969_n4466# AVSS 1.51185f
C563 a_n6285_n4466# AVSS 1.51185f
C564 a_n6869_n4466# AVSS 1.51185f
C565 a_n5969_n1956# AVSS 1.51185f
C566 a_n6869_n1956# AVSS 1.51185f
C567 a_n5385_n766# AVSS 1.51185f
C568 a_n6285_n766# AVSS 1.51185f
C569 a_n5385_424# AVSS 1.51185f
C570 a_n5969_424# AVSS 1.51185f
C571 a_n6285_1614# AVSS 1.51185f
C572 a_n6869_1614# AVSS 1.51185f
C573 a_n5969_2934# AVSS 1.51185f
C574 a_n5385_4124# AVSS 1.51185f
C575 a_n6285_4124# AVSS 1.51185f
C576 a_n6869_4124# AVSS 1.51185f
C577 a_n5385_5314# AVSS 1.51185f
C578 a_n5969_6504# AVSS 1.51185f
C579 a_n6285_6504# AVSS 1.51185f
C580 a_n6869_6504# AVSS 1.51185f
C581 a_n5385_9014# AVSS 1.51185f
C582 a_n5969_9014# AVSS 1.51185f
C583 a_n6285_9014# AVSS 1.51185f
C584 a_n6869_9014# AVSS 1.51185f
C585 a_n6869_10204# AVSS 1.51185f
C586 comparator_body_0.outx AVSS 60.41927f
C587 a_n5385_11394# AVSS 1.51835f
C588 a_n5969_11394# AVSS 1.51185f
C589 a_n6285_11394# AVSS 1.51185f
C590 comparator_body_0.m3_m4_diff_0.m3_m4_array_2/p1_2$1_13.D AVSS 3.51009f
C591 comparator_body_0.m3_m4_diff_0.n1.n0 AVSS 6.77794f
C592 comparator_body_0.m3_m4_diff_0.n1.n4 AVSS 6.78588f
C593 comparator_body_0.m3_m4_diff_0.m3_m4_array_2/p1_2$1_9.D AVSS 3.17736f
C594 comparator_body_0.m3_m4_diff_0.m3_m4_array_2/p1_2$1_14.D AVSS 1.37963f
C595 comparator_body_0.m3_m4_diff_0.m3_m4_array_2/p1_2$1_10.D AVSS 2.21461f
C596 comparator_body_0.m3_m4_diff_0.m3_m4_array_1/p1_2$1_10.D AVSS 3.60075f
C597 comparator_body_0.m3_m4_diff_0.m3_m4_array_0/p1_2$1_14.D AVSS 1.37963f
C598 comparator_body_0.m3_m4_diff_0.m3_m4_array_0/p1_2$1_7.D AVSS 1.38615f
C599 comparator_body_0.m3_m4_diff_0.m3_m4_array_0/p1_2$1_10.D AVSS 2.21461f
C600 comparator_body_0.m3_m4_diff_0.m3_m4_array_3/p1_2$1_14.D AVSS 2.21568f
C601 comparator_body_0.m3_m4_diff_0.m3_m4_array_3/p1_2$1_7.D AVSS 1.38615f
C602 comparator_body_0.m3_m4_diff_0.m3_m4_array_3/p1_2$1_10.D AVSS 2.21461f
C603 comparator_body_0.m3_m4_diff_0.n1.n8 AVSS 1.63679f
C604 comparator_body_0.m3_m4_diff_0.n1.n10 AVSS 1.63679f
C605 comparator_body_0.m3_m4_diff_0.n1.n12 AVSS 1.63679f
C606 comparator_body_0.m3_m4_diff_0.m3_m4_array_1/p1_2$1_4.D AVSS 2.2202f
C607 comparator_body_0.m3_m4_diff_0.m3_m4_array_0/p1_2$1_4.D AVSS 2.2202f
C608 comparator_body_0.m3_m4_diff_0.m3_m4_array_3/p1_2$1_4.D AVSS 2.2202f
C609 comparator_body_0.m3_m4_diff_0.n1.n15 AVSS 0.87922f
C610 comparator_body_0.m3_m4_diff_0.m3_m4_array_2/p1_2$1_4.D AVSS 1.44296f
C611 comparator_body_0.m3_m4_diff_0.n1.n16 AVSS 0.59901f
C612 comparator_body_0.m3_m4_diff_0.n1.n17 AVSS 0.84713f
C613 comparator_body_0.m3_m4_diff_0.n1.n19 AVSS 0.91034f
C614 comparator_body_0.m3_m4_diff_0.n1.n20 AVSS 0.91034f
C615 comparator_body_0.m3_m4_diff_0.n1.n21 AVSS 0.84713f
C616 comparator_body_0.m3_m4_diff_0.n1.n22 AVSS 0.84713f
C617 comparator_body_0.m3_m4_diff_0.n1.n23 AVSS 0.84713f
C618 comparator_body_0.m3_m4_diff_0.n1.n25 AVSS 0.84263f
C619 comparator_body_0.m3_m4_diff_0.n1.n26 AVSS 2.25145f
C620 comparator_body_0.m3_m4_diff_0.m3_m4_array_3/p1_2$1_1.D AVSS 2.19931f
C621 comparator_body_0.m3_m4_diff_0.m3_m4_array_0/p1_2$1_1.D AVSS 2.19931f
C622 comparator_body_0.m3_m4_diff_0.n1.n30 AVSS 5.27497f
C623 comparator_body_0.m3_m4_diff_0.m3_m4_array_1/p1_2$1_1.D AVSS 2.19931f
C624 comparator_body_0.m3_m4_diff_0.m3_m4_array_2/p1_2$1_1.D AVSS 2.13706f
C625 comparator_body_0.m3_m4_diff_0.n1.n35 AVSS 0.04674f
C626 comparator_body_0.m3_m4_diff_0.m3_m4_array_1/p1_2$1_14.D AVSS 1.37963f
C627 comparator_body_0.m3_m4_diff_0.n1.n36 AVSS 1.42219f
C628 comparator_body_0.m3_m4_diff_0.n1.n37 AVSS 2.18506f
C629 comparator_body_0.m3_m4_diff_0.n1.n38 AVSS 1.48771f
C630 comparator_body_0.m3_m4_diff_0.n1.n39 AVSS 1.32619f
C631 comparator_body_0.m1_m2_diff_0.n1 AVSS 4.92583f
C632 comparator_body_0.m3_m4_diff_0.n1.n40 AVSS 2.69343f
C633 comparator_body_0.m3_m4_diff_0.n1.n41 AVSS 2.69343f
C634 comparator_body_0.m3_m4_diff_0.n1.n42 AVSS 2.69343f
C635 comparator_body_0.m3_m4_diff_0.n1.n43 AVSS 2.69343f
C636 comparator_body_0.m3_m4_diff_0.n1.n44 AVSS 2.41909f
C637 comparator_body_0.m3_m4_diff_0.m3_m4_array_3/p1_2$1_13.D AVSS 1.33954f
C638 comparator_body_0.m3_m4_diff_0.n1.n45 AVSS 0.74386f
C639 comparator_body_0.m3_m4_diff_0.n1.n46 AVSS 1.66735f
C640 comparator_body_0.m3_m4_diff_0.n1.n48 AVSS 1.98783f
C641 comparator_body_0.m3_m4_diff_0.n1.n49 AVSS 1.97454f
C642 comparator_body_0.m3_m4_diff_0.n1.n50 AVSS 1.95479f
C643 comparator_body_0.m3_m4_diff_0.m3_m4_array_3/p1_2$1_0.D AVSS 1.62745f
C644 comparator_body_0.m3_m4_diff_0.m3_m4_array_0/p1_2$1_0.D AVSS 1.35286f
C645 comparator_body_0.m3_m4_diff_0.m3_m4_array_1/p1_2$1_0.D AVSS 1.35286f
C646 comparator_body_0.m3_m4_diff_0.m3_m4_array_2/p1_2$1_0.D AVSS 1.35286f
C647 comparator_body_0.m3_m4_diff_0.m3_m4_array_1/p1_2$1_9.D AVSS 1.27093f
C648 comparator_body_0.m3_m4_diff_0.m3_m4_array_0/p1_2$1_9.D AVSS 1.27887f
C649 comparator_body_0.m3_m4_diff_0.m3_m4_array_3/p1_2$1_9.D AVSS 1.36082f
C650 comparator_body_0.m3_m4_diff_0.n1.n51 AVSS 1.14662f
C651 comparator_body_0.m3_m4_diff_0.m3_m4_array_1/p1_2$1_13.D AVSS 1.65587f
C652 comparator_body_0.m3_m4_diff_0.n1.n52 AVSS 3.32165f
C653 comparator_body_0.m3_m4_diff_0.n1.n53 AVSS 1.97454f
C654 comparator_body_0.m3_m4_diff_0.n1.n54 AVSS 1.97454f
C655 comparator_body_0.m3_m4_diff_0.n1.n55 AVSS 2.56078f
C656 comparator_body_0.m3_m4_diff_0.n1.n56 AVSS 1.22957f
C657 comparator_body_0.m3_m4_diff_0.m3_m4_array_0/p1_2$1_13.D AVSS 1.65587f
C658 comparator_body_0.m3_m4_diff_0.n1.t69 AVSS 0.21945f
C659 comparator_body_0.m3_m4_diff_0.n1.t63 AVSS 1.73129f
C660 comparator_body_0.m3_m4_diff_0.n1.t55 AVSS 0.21945f
C661 comparator_body_0.m3_m4_diff_0.n1.t73 AVSS 0.21945f
C662 comparator_body_0.m3_m4_diff_0.n1.t75 AVSS 1.73129f
C663 comparator_body_0.m3_m4_diff_0.n1.t47 AVSS 0.21945f
C664 comparator_body_0.m3_m4_diff_0.n1.t77 AVSS 0.21945f
C665 comparator_body_0.m3_m4_diff_0.n1.t53 AVSS 0.21945f
C666 comparator_body_0.m3_m4_diff_0.n1.t67 AVSS 1.73129f
C667 comparator_body_0.m3_m4_diff_0.n1.t39 AVSS 0.21945f
C668 comparator_body_0.m3_m4_diff_0.n1.t49 AVSS 0.21945f
C669 comparator_body_0.m3_m4_diff_0.n1.t59 AVSS 0.21945f
C670 comparator_body_0.m3_m4_diff_0.n1.t43 AVSS 0.21945f
C671 comparator_body_0.m3_m4_diff_0.n1.t91 AVSS 0.21945f
C672 comparator_body_0.m3_m4_diff_0.n1.t83 AVSS 1.73129f
C673 comparator_body_0.m3_m4_diff_0.n1.t89 AVSS 1.73129f
C674 comparator_body_0.m1_m2_diff_0.m1_m2_array_1/n1_2_1.D AVSS 0.35894f
C675 comparator_body_0.m1_m2_diff_0.m1_m2_array_1/n1_2_14.D AVSS 0.75777f
C676 comparator_body_0.m1_m2_diff_0.m1_m2_array_1/n1_2_2.D AVSS 0.32354f
C677 comparator_body_0.m1_m2_diff_0.m1_m2_array_1/n1_2_13.D AVSS 0.31047f
C678 comparator_body_0.m1_m2_diff_0.m1_m2_array_0/n1_2_13.D AVSS 0.32354f
C679 comparator_body_0.m1_m2_diff_0.m1_m2_array_0/n1_2_2.D AVSS 0.32354f
C680 comparator_body_0.m1_m2_diff_0.m1_m2_array_0/n1_2_1.D AVSS 0.35894f
C681 comparator_body_0.m1_m2_diff_0.m1_m2_array_0/n1_2_14.D AVSS 0.75777f
C682 comparator_body_0.m1_m2_diff_0.m1_m2_array_2/n1_2_13.D AVSS 0.32354f
C683 comparator_body_0.m1_m2_diff_0.m1_m2_array_2/n1_2_2.D AVSS 0.32354f
C684 comparator_body_0.m1_m2_diff_0.m1_m2_array_2/n1_2_1.D AVSS 0.35894f
C685 comparator_body_0.m1_m2_diff_0.m1_m2_array_2/n1_2_14.D AVSS 0.75777f
C686 comparator_body_0.m1_m2_diff_0.m1_m2_array_3/n1_2_13.D AVSS 0.32354f
C687 comparator_body_0.m1_m2_diff_0.m1_m2_array_3/n1_2_2.D AVSS 0.32354f
C688 comparator_body_0.m1_m2_diff_0.m1_m2_array_3/n1_2_1.D AVSS 0.35894f
C689 comparator_body_0.m1_m2_diff_0.m1_m2_array_3/n1_2_14.D AVSS 0.75777f
C690 comparator_body_0.m3_m4_diff_0.n1.t0 AVSS 0.22125f
C691 comparator_body_0.m1_m2_diff_0.m1_m2_array_3/n1_2_10.D AVSS 0.3253f
C692 comparator_body_0.m1_m2_diff_0.m1_m2_array_3/n1_2_11.D AVSS 0.87277f
C693 comparator_body_0.m1_m2_diff_0.m1_m2_array_1/n1_2_10.D AVSS 0.32407f
C694 comparator_body_0.m1_m2_diff_0.m1_m2_array_1/n1_2_7.D AVSS 0.35948f
C695 comparator_body_0.m1_m2_diff_0.m1_m2_array_1/n1_2_4.D AVSS 0.35948f
C696 comparator_body_0.m1_m2_diff_0.m1_m2_array_0/n1_2_10.D AVSS 0.32407f
C697 comparator_body_0.m1_m2_diff_0.m1_m2_array_0/n1_2_11.D AVSS 0.41912f
C698 comparator_body_0.m1_m2_diff_0.m1_m2_array_0/n1_2_7.D AVSS 0.35948f
C699 comparator_body_0.m1_m2_diff_0.m1_m2_array_0/n1_2_4.D AVSS 0.35948f
C700 comparator_body_0.m1_m2_diff_0.m1_m2_array_2/n1_2_10.D AVSS 0.32407f
C701 comparator_body_0.m1_m2_diff_0.m1_m2_array_2/n1_2_11.D AVSS 0.33776f
C702 comparator_body_0.m1_m2_diff_0.m1_m2_array_2/n1_2_7.D AVSS 0.35948f
C703 comparator_body_0.m1_m2_diff_0.m1_m2_array_2/n1_2_4.D AVSS 0.35948f
C704 comparator_body_0.m1_m2_diff_0.m1_m2_array_1/n1_2_11.D AVSS 0.40877f
C705 comparator_body_0.m1_m2_diff_0.m1_m2_array_3/n1_2_7.D AVSS 0.35948f
C706 comparator_body_0.m1_m2_diff_0.m1_m2_array_3/n1_2_4.D AVSS 0.35948f
C707 comparator_body_0.m3_m4_diff_0.n1.t4 AVSS 0.22126f
C708 comparator_body_0.m3_m4_diff_0.n1.t9 AVSS 0.22053f
C709 comparator_body_0.m3_m4_diff_0.n1.t7 AVSS 0.22126f
C710 comparator_body_0.m3_m4_diff_0.n1.t11 AVSS 0.22053f
C711 comparator_body_0.m3_m4_diff_0.n1.t1 AVSS 0.22126f
C712 comparator_body_0.m3_m4_diff_0.n1.t85 AVSS 1.73036f
C713 comparator_body_0.m3_m4_diff_0.n1.t95 AVSS 0.21851f
C714 comparator_body_0.m3_m4_diff_0.n1.t81 AVSS 0.21851f
C715 comparator_body_0.m3_m4_diff_0.n1.t93 AVSS 1.73036f
C716 comparator_body_0.m3_m4_diff_0.n1.t37 AVSS 0.21851f
C717 comparator_body_0.m3_m4_diff_0.n1.t51 AVSS 1.73036f
C718 comparator_body_0.m3_m4_diff_0.n1.t87 AVSS 0.21851f
C719 comparator_body_0.m3_m4_diff_0.n1.t33 AVSS 0.21851f
C720 comparator_body_0.m3_m4_diff_0.n1.t71 AVSS 0.21851f
C721 comparator_body_0.m3_m4_diff_0.n1.t57 AVSS 0.21851f
C722 comparator_body_0.m3_m4_diff_0.n1.t31 AVSS 0.22126f
C723 comparator_body_0.m3_m4_diff_0.n1.t5 AVSS 0.22126f
C724 comparator_body_0.m3_m4_diff_0.n1.t28 AVSS 0.22053f
C725 comparator_body_0.m3_m4_diff_0.n1.t24 AVSS 0.22126f
C726 comparator_body_0.m3_m4_diff_0.n1.t3 AVSS 0.22053f
C727 comparator_body_0.m3_m4_diff_0.n1.t2 AVSS 0.22126f
C728 comparator_body_0.m3_m4_diff_0.n1.t10 AVSS 0.22053f
C729 comparator_body_0.m3_m4_diff_0.n1.n57 AVSS 2.01523f
C730 comparator_body_0.m3_m4_diff_0.n1.t8 AVSS 0.22053f
C731 comparator_body_0.m3_m4_diff_0.n1.t6 AVSS 0.22053f
C732 comparator_body_0.m3_m4_diff_0.n1.t22 AVSS 0.22053f
C733 comparator_body_0.m3_m4_diff_0.n1.t19 AVSS 0.22053f
C734 comparator_body_0.m3_m4_diff_0.n1.t17 AVSS 0.22126f
C735 comparator_body_0.m3_m4_diff_0.n1.t20 AVSS 0.22053f
C736 comparator_body_0.m3_m4_diff_0.n1.t23 AVSS 0.22126f
C737 comparator_body_0.m3_m4_diff_0.n1.t27 AVSS 0.22053f
C738 comparator_body_0.m3_m4_diff_0.n1.t26 AVSS 0.22053f
C739 comparator_body_0.m3_m4_diff_0.n1.t12 AVSS 0.22053f
C740 comparator_body_0.m3_m4_diff_0.n1.n58 AVSS 1.7099f
C741 comparator_body_0.m3_m4_diff_0.n1.t14 AVSS 0.22053f
C742 comparator_body_0.m3_m4_diff_0.n1.t15 AVSS 0.22126f
C743 comparator_body_0.m3_m4_diff_0.n1.t16 AVSS 0.22053f
C744 comparator_body_0.m3_m4_diff_0.n1.t13 AVSS 0.22126f
C745 comparator_body_0.m3_m4_diff_0.n1.t18 AVSS 0.22126f
C746 comparator_body_0.m3_m4_diff_0.n1.t21 AVSS 0.22126f
C747 comparator_body_0.m3_m4_diff_0.n1.t79 AVSS 0.21851f
C748 comparator_body_0.m3_m4_diff_0.n1.t25 AVSS 0.22126f
C749 comparator_body_0.m3_m4_diff_0.n1.n59 AVSS 1.44487f
C750 comparator_body_0.m3_m4_diff_0.n1.t29 AVSS 0.22126f
C751 comparator_body_0.m3_m4_diff_0.n1.t35 AVSS 0.21851f
C752 comparator_body_0.m3_m4_diff_0.n1.t65 AVSS 1.73036f
C753 comparator_body_0.m3_m4_diff_0.n1.t45 AVSS 1.73036f
C754 comparator_body_0.m3_m4_diff_0.n1.t30 AVSS 0.22053f
C755 comparator_body_0.m3_m4_diff_0.n1.n60 AVSS 3.48606f
C756 comparator_body_0.m3_m4_diff_0.n1.t41 AVSS 0.21851f
C757 comparator_body_0.m3_m4_diff_0.n1.n61 AVSS 1.6584f
C758 comparator_body_0.m3_m4_diff_0.n1.n62 AVSS 1.61552f
C759 comparator_body_0.m3_m4_diff_0.n1.t61 AVSS 0.21851f
C760 comparator_body_0.outx.n0 AVSS 0.65433f
C761 comparator_body_0.outx.n1 AVSS 10.5106f
C762 comparator_body_0.outx.n2 AVSS 3.37421f
C763 comparator_body_0.outx.n3 AVSS 0.98024f
C764 comparator_body_0.outx.n4 AVSS 1.78402f
C765 comparator_body_0.outx.n5 AVSS 0.58143f
C766 comparator_body_0.outx.n6 AVSS 0.64968f
C767 comparator_body_0.outx.n7 AVSS 6.42628f
C768 comparator_body_0.outx.n8 AVSS 6.43478f
C769 comparator_body_0.outx.n9 AVSS 3.36086f
C770 comparator_body_0.outx.n12 AVSS 3.36086f
C771 comparator_body_0.outx.n13 AVSS 1.11594f
C772 comparator_body_0.outx.n14 AVSS 6.7344f
C773 comparator_body_0.outx.n15 AVSS 0.3845f
C774 comparator_body_0.outx.n16 AVSS 1.23616f
C775 comparator_body_0.outx.n17 AVSS 1.55535f
C776 comparator_body_0.outx.n19 AVSS 2.13723f
C777 comparator_body_0.outx.n20 AVSS 1.72418f
C778 comparator_body_0.outx.n21 AVSS 2.64364f
C779 comparator_body_0.outx.n24 AVSS 2.59716f
C780 comparator_body_0.outx.n25 AVSS 0.6523f
C781 comparator_body_0.outx.n26 AVSS 2.64364f
C782 comparator_body_0.outx.n28 AVSS 0.58001f
C783 comparator_body_0.outx.n29 AVSS 1.5035f
C784 comparator_body_0.outx.n30 AVSS 1.5035f
C785 comparator_body_0.outx.n31 AVSS 0.57688f
C786 comparator_body_0.outx.n32 AVSS 0.98904f
C787 comparator_body_0.outx.n33 AVSS 2.4217f
C788 comparator_body_0.outx.n34 AVSS 1.15023f
C789 comparator_body_0.outx.n35 AVSS 1.23616f
C790 comparator_body_0.outx.n36 AVSS 0.73528f
C791 comparator_body_0.outx.n37 AVSS 1.9734f
C792 comparator_body_0.outx.n38 AVSS 1.07709f
C793 comparator_body_0.outx.n39 AVSS 1.19218f
C794 comparator_body_0.outx.n40 AVSS 1.07709f
C795 comparator_body_0.outx.n41 AVSS 1.67829f
C796 comparator_body_0.outx.n42 AVSS 1.67829f
C797 comparator_body_0.outx.n43 AVSS 1.76897f
C798 comparator_body_0.outx.n44 AVSS 0.80272f
C799 comparator_body_0.outx.n45 AVSS 9.23218f
C800 comparator_body_0.outx.n46 AVSS 0.73528f
C801 comparator_body_0.outx.n47 AVSS 1.25074f
C802 comparator_body_0.outx.n48 AVSS 0.99043f
C803 comparator_body_0.outx.n49 AVSS 1.27814f
C804 comparator_body_0.outx.n50 AVSS 1.06484f
C805 comparator_body_0.outx.n51 AVSS 1.06673f
C806 comparator_body_0.outx.n52 AVSS 0.97185f
C807 comparator_body_0.outx.n53 AVSS 1.93897f
C808 comparator_body_0.outx.n54 AVSS 4.15113f
C809 comparator_body_0.outx.t0 AVSS 0.17168f
C810 comparator_body_0.outx.t56 AVSS 1.68284f
C811 comparator_body_0.outx.t57 AVSS 0.17099f
C812 comparator_body_0.outx.t45 AVSS 0.17171f
C813 comparator_body_0.outx.t61 AVSS 0.17099f
C814 comparator_body_0.outx.t16 AVSS 0.17065f
C815 comparator_body_0.outx.t14 AVSS 0.17121f
C816 comparator_body_0.outx.n55 AVSS 1.36508f
C817 comparator_body_0.outx.t15 AVSS 0.17065f
C818 comparator_body_0.outx.t17 AVSS 0.17065f
C819 comparator_body_0.outx.t22 AVSS 0.17121f
C820 comparator_body_0.outx.n56 AVSS 1.37692f
C821 comparator_body_0.outx.t20 AVSS 0.17065f
C822 comparator_body_0.outx.t21 AVSS 0.17121f
C823 comparator_body_0.outx.t19 AVSS 0.17121f
C824 comparator_body_0.outx.t10 AVSS 1.68356f
C825 comparator_body_0.outx.t47 AVSS 0.17171f
C826 comparator_body_0.outx.t5 AVSS 0.17099f
C827 comparator_body_0.outx.t60 AVSS 0.17099f
C828 comparator_body_0.outx.n57 AVSS 1.67284f
C829 comparator_body_0.outx.t46 AVSS 0.17099f
C830 comparator_body_0.outx.t58 AVSS 1.68356f
C831 comparator_body_0.outx.t18 AVSS 0.17065f
C832 comparator_body_0.outx.t43 AVSS 0.17121f
C833 comparator_body_0.outx.n58 AVSS 1.36508f
C834 comparator_body_0.outx.t31 AVSS 0.17065f
C835 comparator_body_0.outx.t44 AVSS 0.17065f
C836 comparator_body_0.outx.t13 AVSS 0.17121f
C837 comparator_body_0.outx.n59 AVSS 1.37692f
C838 comparator_body_0.outx.t33 AVSS 0.17065f
C839 comparator_body_0.outx.t34 AVSS 0.17121f
C840 comparator_body_0.outx.t7 AVSS 0.17171f
C841 comparator_body_0.outx.t2 AVSS 1.68284f
C842 comparator_body_0.outx.t52 AVSS 0.17171f
C843 comparator_body_0.outx.t9 AVSS 0.17171f
C844 comparator_body_0.outx.t49 AVSS 0.17171f
C845 comparator_body_0.outx.t55 AVSS 1.68284f
C846 comparator_body_0.outx.t6 AVSS 0.17099f
C847 comparator_body_0.outx.t54 AVSS 1.68284f
C848 comparator_body_0.outx.n60 AVSS 0.98323f
C849 comparator_body_0.outx.t27 AVSS 0.17065f
C850 comparator_body_0.outx.t26 AVSS 0.17121f
C851 comparator_body_0.outx.n61 AVSS 1.36508f
C852 comparator_body_0.outx.t30 AVSS 0.17065f
C853 comparator_body_0.outx.t25 AVSS 0.17065f
C854 comparator_body_0.outx.t36 AVSS 0.17121f
C855 comparator_body_0.outx.n62 AVSS 1.37692f
C856 comparator_body_0.outx.t29 AVSS 0.17065f
C857 comparator_body_0.outx.t23 AVSS 0.17121f
C858 comparator_body_0.outx.t35 AVSS 0.17121f
C859 comparator_body_0.outx.t3 AVSS 0.17171f
C860 comparator_body_0.outx.t41 AVSS 0.17065f
C861 comparator_body_0.outx.t39 AVSS 0.17121f
C862 comparator_body_0.outx.n63 AVSS 1.36508f
C863 comparator_body_0.outx.t28 AVSS 0.17065f
C864 comparator_body_0.outx.t37 AVSS 0.17121f
C865 comparator_body_0.outx.t32 AVSS 0.17065f
C866 comparator_body_0.outx.t42 AVSS 0.17121f
C867 comparator_body_0.outx.n64 AVSS 1.37692f
C868 comparator_body_0.outx.t24 AVSS 0.17065f
C869 comparator_body_0.outx.t38 AVSS 0.17121f
C870 comparator_body_0.outx.t51 AVSS 0.17171f
C871 comparator_body_0.outx.t12 AVSS 0.17171f
C872 comparator_body_0.outx.t11 AVSS 0.17099f
C873 comparator_body_0.outx.t59 AVSS 0.17171f
C874 comparator_body_0.outx.t50 AVSS 1.68284f
C875 comparator_body_0.outx.t48 AVSS 1.68356f
C876 comparator_body_0.outx.t63 AVSS 0.17099f
C877 comparator_body_0.outx.t8 AVSS 1.68284f
C878 comparator_body_0.outx.t1 AVSS 0.17171f
C879 comparator_body_0.outx.n65 AVSS 1.21583f
C880 comparator_body_0.outx.t40 AVSS 0.17121f
C881 comparator_body_0.outx.t4 AVSS 0.17099f
C882 comparator_body_0.outx.t62 AVSS 0.17171f
C883 comparator_body_0.outx.t53 AVSS 0.17099f
C884 comparator_body_0.mref_m5_diff_0.tail.n0 AVSS 0.78183f
C885 comparator_body_0.mref_m5_diff_0.tail.n1 AVSS 0.86164f
C886 comparator_body_0.mref_m5_diff_0.tail.n2 AVSS 0.29402f
C887 comparator_body_0.mref_m5_diff_0.tail.n3 AVSS 0.65444f
C888 comparator_body_0.mref_m5_diff_0.tail.n4 AVSS 0.33593f
C889 comparator_body_0.mref_m5_diff_0.tail.n5 AVSS 0.33593f
C890 comparator_body_0.mref_m5_diff_0.tail.n6 AVSS 54.8423f
C891 comparator_body_0.mref_m5_diff_0.tail.n7 AVSS 0.65084f
C892 comparator_body_0.mref_m5_diff_0.tail.n8 AVSS 0.60214f
C893 comparator_body_0.mref_m5_diff_0.tail.n9 AVSS 0.57549f
C894 comparator_body_0.m1_m2_diff_0.m1_m2_array_0/n1_2_11.S AVSS 0.24468f
C895 comparator_body_0.mref_m5_diff_0.tail.n10 AVSS 0.57549f
C896 comparator_body_0.mref_m5_diff_0.tail.n11 AVSS 0.58637f
C897 comparator_body_0.mref_m5_diff_0.tail.n12 AVSS 0.18256f
C898 comparator_body_0.mref_m5_diff_0.tail.n13 AVSS 0.45597f
C899 comparator_body_0.m1_m2_diff_0.m1_m2_array_2/n1_2_15.S AVSS 0.26038f
C900 comparator_body_0.mref_m5_diff_0.tail.n14 AVSS 0.57549f
C901 comparator_body_0.mref_m5_diff_0.tail.n15 AVSS 0.60233f
C902 comparator_body_0.mref_m5_diff_0.tail.n16 AVSS 0.35171f
C903 comparator_body_0.m1_m2_diff_0.m1_m2_array_0/n1_2_7.S AVSS 0.23354f
C904 comparator_body_0.mref_m5_diff_0.tail.n17 AVSS 0.40798f
C905 comparator_body_0.m1_m2_diff_0.m1_m2_array_0/n1_2_15.S AVSS 0.26013f
C906 comparator_body_0.mref_m5_diff_0.tail.n18 AVSS 0.23033f
C907 comparator_body_0.m1_m2_diff_0.m1_m2_array_1/n1_2_3.S AVSS 0.23043f
C908 comparator_body_0.m1_m2_diff_0.m1_m2_array_0/n1_2_4.S AVSS 0.22982f
C909 comparator_body_0.m1_m2_diff_0.m1_m2_array_2/n1_2_3.S AVSS 0.23043f
C910 comparator_body_0.m1_m2_diff_0.m1_m2_array_1/n1_2_7.S AVSS 0.23354f
C911 comparator_body_0.mref_m5_diff_0.tail.n19 AVSS 0.36518f
C912 comparator_body_0.mref_m5_diff_0.tail.n20 AVSS 0.57825f
C913 comparator_body_0.mref_m5_diff_0.tail.n21 AVSS 1.35465f
C914 comparator_body_0.mref_m5_diff_0.tail.n22 AVSS 0.35843f
C915 comparator_body_0.mref_m5_diff_0.tail.n23 AVSS 0.46433f
C916 comparator_body_0.mref_m5_diff_0.tail.n24 AVSS 0.61124f
C917 comparator_body_0.mref_m5_diff_0.tail.n25 AVSS 0.19862f
C918 comparator_body_0.mref_m5_diff_0.tail.n26 AVSS 0.54043f
C919 comparator_body_0.mref_m5_diff_0.tail.n27 AVSS 0.19941f
C920 comparator_body_0.mref_m5_diff_0.tail.n28 AVSS 0.70431f
C921 comparator_body_0.mref_m5_diff_0.tail.n29 AVSS 0.54437f
C922 comparator_body_0.mref_m5_diff_0.tail.n30 AVSS 0.54043f
C923 comparator_body_0.mref_m5_diff_0.tail.n31 AVSS 0.19941f
C924 comparator_body_0.mref_m5_diff_0.tail.n32 AVSS 0.70431f
C925 comparator_body_0.mref_m5_diff_0.tail.n33 AVSS 0.19862f
C926 comparator_body_0.mref_m5_diff_0.tail.n34 AVSS 0.54043f
C927 comparator_body_0.mref_m5_diff_0.tail.n35 AVSS 0.19941f
C928 comparator_body_0.mref_m5_diff_0.tail.n36 AVSS 0.70431f
C929 comparator_body_0.mref_m5_diff_0.tail.n37 AVSS 0.19941f
C930 comparator_body_0.mref_m5_diff_0.tail.n38 AVSS 0.70431f
C931 comparator_body_0.mref_m5_diff_0.mref_m5_array_0/n1_2$1_11.D AVSS 0.23835f
C932 comparator_body_0.mref_m5_diff_0.mref_m5_array_0/n1_2$1_2.D AVSS 0.18392f
C933 comparator_body_0.mref_m5_diff_0.mref_m5_array_1/n1_2$1_11.D AVSS 0.23835f
C934 comparator_body_0.mref_m5_diff_0.mref_m5_array_1/n1_2$1_2.D AVSS 0.18392f
C935 comparator_body_0.mref_m5_diff_0.mref_m5_array_1/n1_2$1_8.D AVSS 0.18392f
C936 comparator_body_0.mref_m5_diff_0.mref_m5_array_0/n1_2$1_8.D AVSS 0.18392f
C937 comparator_body_0.mref_m5_diff_0.mref_m5_array_0/n1_2$1_3.D AVSS 0.18393f
C938 comparator_body_0.mref_m5_diff_0.mref_m5_array_3/n1_2$1_11.D AVSS 0.23835f
C939 comparator_body_0.mref_m5_diff_0.mref_m5_array_3/n1_2$1_2.D AVSS 0.18392f
C940 comparator_body_0.mref_m5_diff_0.mref_m5_array_2/n1_2$1_11.D AVSS 0.23835f
C941 comparator_body_0.mref_m5_diff_0.mref_m5_array_2/n1_2$1_2.D AVSS 0.18392f
C942 comparator_body_0.mref_m5_diff_0.mref_m5_array_2/n1_2$1_8.D AVSS 0.18392f
C943 comparator_body_0.mref_m5_diff_0.mref_m5_array_2/n1_2$1_3.D AVSS 0.18393f
C944 comparator_body_0.mref_m5_diff_0.mref_m5_array_3/n1_2$1_8.D AVSS 0.18392f
C945 comparator_body_0.mref_m5_diff_0.mref_m5_array_3/n1_2$1_3.D AVSS 0.18393f
C946 comparator_body_0.mref_m5_diff_0.mref_m5_array_1/n1_2$1_3.D AVSS 0.18393f
C947 comparator_body_0.mref_m5_diff_0.tail.t0 AVSS 0.74837f
C948 comparator_body_0.mref_m5_diff_0.mref_m5_array_3/n1_2$1_12.D AVSS 0.18503f
C949 comparator_body_0.m1_m2_diff_0.m1_m2_array_1/n1_2_15.S AVSS 0.21971f
C950 comparator_body_0.m1_m2_diff_0.m1_m2_array_1/n1_2_10.S AVSS 0.21969f
C951 comparator_body_0.m1_m2_diff_0.m1_m2_array_1/n1_2_0.S AVSS 0.21969f
C952 comparator_body_0.m1_m2_diff_0.m1_m2_array_1/n1_2_11.S AVSS 0.21969f
C953 comparator_body_0.m1_m2_diff_0.m1_m2_array_1/n1_2_4.S AVSS 0.22982f
C954 comparator_body_0.m1_m2_diff_0.m1_m2_array_1/n1_2_12.S AVSS 0.21969f
C955 comparator_body_0.m1_m2_diff_0.m1_m2_array_0/n1_2_10.S AVSS 0.21969f
C956 comparator_body_0.m1_m2_diff_0.m1_m2_array_0/n1_2_0.S AVSS 0.24647f
C957 comparator_body_0.m1_m2_diff_0.m1_m2_array_0/n1_2_3.S AVSS 0.23043f
C958 comparator_body_0.m1_m2_diff_0.m1_m2_array_0/n1_2_12.S AVSS 0.29613f
C959 comparator_body_0.m1_m2_diff_0.m1_m2_array_2/n1_2_10.S AVSS 0.21969f
C960 comparator_body_0.m1_m2_diff_0.m1_m2_array_2/n1_2_0.S AVSS 0.21969f
C961 comparator_body_0.m1_m2_diff_0.m1_m2_array_2/n1_2_11.S AVSS 0.21969f
C962 comparator_body_0.m1_m2_diff_0.m1_m2_array_2/n1_2_4.S AVSS 0.26515f
C963 comparator_body_0.m1_m2_diff_0.m1_m2_array_2/n1_2_7.S AVSS 0.23354f
C964 comparator_body_0.m1_m2_diff_0.m1_m2_array_3/n1_2_12.S AVSS 0.21969f
C965 comparator_body_0.m1_m2_diff_0.m1_m2_array_3/n1_2_4.S AVSS 0.23136f
C966 comparator_body_0.m1_m2_diff_0.m1_m2_array_3/n1_2_3.S AVSS 0.23043f
C967 comparator_body_0.m1_m2_diff_0.m1_m2_array_3/n1_2_7.S AVSS 0.23173f
C968 comparator_body_0.m1_m2_diff_0.m1_m2_array_2/n1_2_12.S AVSS 0.21969f
C969 comparator_body_0.m1_m2_diff_0.m1_m2_array_3/n1_2_10.S AVSS 0.24577f
C970 comparator_body_0.m1_m2_diff_0.m1_m2_array_3/n1_2_0.S AVSS 0.21969f
C971 comparator_body_0.m1_m2_diff_0.m1_m2_array_3/n1_2_11.S AVSS 0.21969f
C972 comparator_body_0.m1_m2_diff_0.m1_m2_array_3/n1_2_15.S AVSS 0.26042f
C973 comparator_body_0.mref_m5_diff_0.mref_m5_array_0/n1_2$1_15.D AVSS 0.23886f
C974 comparator_body_0.mref_m5_diff_0.mref_m5_array_0/n1_2$1_6.D AVSS 0.18431f
C975 comparator_body_0.mref_m5_diff_0.mref_m5_array_0/n1_2$1_12.D AVSS 0.1843f
C976 comparator_body_0.mref_m5_diff_0.mref_m5_array_1/n1_2$1_6.D AVSS 0.18431f
C977 comparator_body_0.mref_m5_diff_0.mref_m5_array_1/n1_2$1_15.D AVSS 0.23886f
C978 comparator_body_0.mref_m5_diff_0.mref_m5_array_1/n1_2$1_5.D AVSS 0.1843f
C979 comparator_body_0.mref_m5_diff_0.mref_m5_array_1/n1_2$1_12.D AVSS 0.1843f
C980 comparator_body_0.mref_m5_diff_0.mref_m5_array_0/n1_2$1_5.D AVSS 0.1843f
C981 comparator_body_0.mref_m5_diff_0.mref_m5_array_3/n1_2$1_15.D AVSS 0.23886f
C982 comparator_body_0.mref_m5_diff_0.mref_m5_array_2/n1_2$1_15.D AVSS 0.23886f
C983 comparator_body_0.mref_m5_diff_0.mref_m5_array_2/n1_2$1_5.D AVSS 0.1843f
C984 comparator_body_0.mref_m5_diff_0.mref_m5_array_2/n1_2$1_6.D AVSS 0.18431f
C985 comparator_body_0.mref_m5_diff_0.mref_m5_array_2/n1_2$1_12.D AVSS 0.1843f
C986 comparator_body_0.mref_m5_diff_0.mref_m5_array_3/n1_2$1_5.D AVSS 0.1843f
C987 comparator_body_0.mref_m5_diff_0.mref_m5_array_3/n1_2$1_6.D AVSS 0.18431f
C988 comparator_body_0.m1_m2_diff_0.m1_m2_array_1/n1_2_6.S AVSS 0.21977f
C989 comparator_body_0.m1_m2_diff_0.m1_m2_array_1/n1_2_1.S AVSS 0.21977f
C990 comparator_body_0.m1_m2_diff_0.m1_m2_array_1/n1_2_9.S AVSS 0.21977f
C991 comparator_body_0.m1_m2_diff_0.m1_m2_array_1/n1_2_14.S AVSS 0.22789f
C992 comparator_body_0.m1_m2_diff_0.m1_m2_array_1/n1_2_8.S AVSS 0.21977f
C993 comparator_body_0.m1_m2_diff_0.m1_m2_array_1/n1_2_2.S AVSS 0.21977f
C994 comparator_body_0.m1_m2_diff_0.m1_m2_array_1/n1_2_5.S AVSS 0.21977f
C995 comparator_body_0.m1_m2_diff_0.m1_m2_array_1/n1_2_13.S AVSS 0.21977f
C996 comparator_body_0.m1_m2_diff_0.m1_m2_array_0/n1_2_6.S AVSS 0.21977f
C997 comparator_body_0.m1_m2_diff_0.m1_m2_array_0/n1_2_1.S AVSS 0.21977f
C998 comparator_body_0.m1_m2_diff_0.m1_m2_array_0/n1_2_9.S AVSS 0.21977f
C999 comparator_body_0.m1_m2_diff_0.m1_m2_array_0/n1_2_14.S AVSS 0.21977f
C1000 comparator_body_0.m1_m2_diff_0.m1_m2_array_2/n1_2_6.S AVSS 0.21977f
C1001 comparator_body_0.m1_m2_diff_0.m1_m2_array_2/n1_2_1.S AVSS 0.21977f
C1002 comparator_body_0.m1_m2_diff_0.m1_m2_array_2/n1_2_9.S AVSS 0.21977f
C1003 comparator_body_0.m1_m2_diff_0.m1_m2_array_2/n1_2_14.S AVSS 0.21977f
C1004 comparator_body_0.m1_m2_diff_0.m1_m2_array_3/n1_2_8.S AVSS 0.25623f
C1005 comparator_body_0.m1_m2_diff_0.m1_m2_array_3/n1_2_2.S AVSS 0.24494f
C1006 comparator_body_0.m1_m2_diff_0.m1_m2_array_3/n1_2_5.S AVSS 0.21977f
C1007 comparator_body_0.m1_m2_diff_0.m1_m2_array_3/n1_2_13.S AVSS 0.21977f
C1008 comparator_body_0.m1_m2_diff_0.m1_m2_array_2/n1_2_8.S AVSS 0.25337f
C1009 comparator_body_0.m1_m2_diff_0.m1_m2_array_2/n1_2_2.S AVSS 0.21977f
C1010 comparator_body_0.m1_m2_diff_0.m1_m2_array_2/n1_2_5.S AVSS 0.21977f
C1011 comparator_body_0.m1_m2_diff_0.m1_m2_array_2/n1_2_13.S AVSS 0.24072f
C1012 comparator_body_0.m1_m2_diff_0.m1_m2_array_3/n1_2_6.S AVSS 0.21977f
C1013 comparator_body_0.m1_m2_diff_0.m1_m2_array_3/n1_2_1.S AVSS 0.21977f
C1014 comparator_body_0.m1_m2_diff_0.m1_m2_array_3/n1_2_9.S AVSS 0.21977f
C1015 comparator_body_0.m1_m2_diff_0.m1_m2_array_3/n1_2_14.S AVSS 0.21977f
C1016 comparator_body_0.m1_m2_diff_0.m1_m2_array_0/n1_2_8.S AVSS 0.25099f
C1017 comparator_body_0.m1_m2_diff_0.m1_m2_array_0/n1_2_2.S AVSS 0.21977f
C1018 comparator_body_0.m1_m2_diff_0.m1_m2_array_0/n1_2_5.S AVSS 0.21977f
C1019 comparator_body_0.m1_m2_diff_0.m1_m2_array_0/n1_2_13.S AVSS 0.23479f
C1020 comparator_body_0.mref_m5_diff_0.tail.n39 AVSS 0.50295f
C1021 comparator_body_0.mref_m5_diff_0.tail.n40 AVSS 0.84443f
C1022 comparator_body_0.mref_m5_diff_0.tail.t9 AVSS 0.13107f
C1023 comparator_body_0.mref_m5_diff_0.tail.n41 AVSS 0.51667f
C1024 comparator_body_0.mref_m5_diff_0.tail.n42 AVSS 0.57424f
C1025 comparator_body_0.mref_m5_diff_0.tail.t29 AVSS 0.13064f
C1026 comparator_body_0.mref_m5_diff_0.tail.t34 AVSS 0.13092f
C1027 comparator_body_0.mref_m5_diff_0.tail.t41 AVSS 0.13148f
C1028 comparator_body_0.mref_m5_diff_0.tail.t72 AVSS 0.13092f
C1029 comparator_body_0.mref_m5_diff_0.tail.t66 AVSS 0.13148f
C1030 comparator_body_0.mref_m5_diff_0.tail.t39 AVSS 0.13092f
C1031 comparator_body_0.mref_m5_diff_0.tail.t43 AVSS 0.13148f
C1032 comparator_body_0.mref_m5_diff_0.tail.t73 AVSS 0.13092f
C1033 comparator_body_0.mref_m5_diff_0.tail.t67 AVSS 0.13148f
C1034 comparator_body_0.mref_m5_diff_0.tail.t70 AVSS 0.13092f
C1035 comparator_body_0.mref_m5_diff_0.tail.t36 AVSS 0.13092f
C1036 comparator_body_0.mref_m5_diff_0.tail.n43 AVSS 0.38635f
C1037 comparator_body_0.mref_m5_diff_0.tail.n44 AVSS 0.33593f
C1038 comparator_body_0.mref_m5_diff_0.tail.t65 AVSS 0.13092f
C1039 comparator_body_0.mref_m5_diff_0.tail.n45 AVSS 0.30118f
C1040 comparator_body_0.mref_m5_diff_0.tail.t32 AVSS 0.13092f
C1041 comparator_body_0.mref_m5_diff_0.tail.t33 AVSS 0.13092f
C1042 comparator_body_0.mref_m5_diff_0.tail.t31 AVSS 0.13064f
C1043 comparator_body_0.mref_m5_diff_0.tail.n46 AVSS 0.41656f
C1044 comparator_body_0.m1_m2_diff_0.tail AVSS 0.54538f
C1045 comparator_body_0.mref_m5_diff_0.tail.t40 AVSS 0.13148f
C1046 comparator_body_0.mref_m5_diff_0.tail.t3 AVSS 0.13107f
C1047 comparator_body_0.mref_m5_diff_0.tail.n47 AVSS 0.31466f
C1048 comparator_body_0.mref_m5_diff_0.tail.t30 AVSS 0.13107f
C1049 comparator_body_0.mref_m5_diff_0.tail.n48 AVSS 0.55798f
C1050 comparator_body_0.mref_m5_diff_0.tail.n49 AVSS 0.75574f
C1051 comparator_body_0.mref_m5_diff_0.tail.t16 AVSS 0.13064f
C1052 comparator_body_0.mref_m5_diff_0.tail.n50 AVSS 0.54043f
C1053 comparator_body_0.mref_m5_diff_0.tail.t4 AVSS 0.13064f
C1054 comparator_body_0.mref_m5_diff_0.tail.n51 AVSS 0.19943f
C1055 comparator_body_0.mref_m5_diff_0.tail.n52 AVSS 0.61876f
C1056 comparator_body_0.mref_m5_diff_0.tail.t10 AVSS 0.13064f
C1057 comparator_body_0.mref_m5_diff_0.tail.n53 AVSS 0.68128f
C1058 comparator_body_0.mref_m5_diff_0.tail.t15 AVSS 0.13107f
C1059 comparator_body_0.mref_m5_diff_0.tail.n54 AVSS 0.19862f
C1060 comparator_body_0.mref_m5_diff_0.tail.n55 AVSS 0.31101f
C1061 comparator_body_0.mref_m5_diff_0.tail.n56 AVSS 0.61844f
C1062 comparator_body_0.mref_m5_diff_0.tail.t14 AVSS 0.74794f
C1063 comparator_body_0.mref_m5_diff_0.tail.n57 AVSS 0.19943f
C1064 comparator_body_0.mref_m5_diff_0.tail.t21 AVSS 0.13064f
C1065 comparator_body_0.mref_m5_diff_0.tail.t2 AVSS 0.13064f
C1066 comparator_body_0.mref_m5_diff_0.tail.n58 AVSS 0.19943f
C1067 comparator_body_0.mref_m5_diff_0.tail.t13 AVSS 0.13064f
C1068 comparator_body_0.mref_m5_diff_0.tail.t8 AVSS 0.13107f
C1069 comparator_body_0.mref_m5_diff_0.tail.n59 AVSS 0.61844f
C1070 comparator_body_0.mref_m5_diff_0.tail.n60 AVSS 0.57424f
C1071 comparator_body_0.mref_m5_diff_0.tail.n61 AVSS 0.44049f
C1072 comparator_body_0.mref_m5_diff_0.tail.t22 AVSS 0.13107f
C1073 comparator_body_0.mref_m5_diff_0.tail.n62 AVSS 0.84443f
C1074 comparator_body_0.mref_m5_diff_0.tail.n63 AVSS 0.31466f
C1075 comparator_body_0.mref_m5_diff_0.tail.t25 AVSS 0.13064f
C1076 comparator_body_0.mref_m5_diff_0.tail.t45 AVSS 0.13092f
C1077 comparator_body_0.mref_m5_diff_0.tail.t78 AVSS 0.13148f
C1078 comparator_body_0.mref_m5_diff_0.tail.t87 AVSS 0.13092f
C1079 comparator_body_0.mref_m5_diff_0.tail.t48 AVSS 0.13148f
C1080 comparator_body_0.mref_m5_diff_0.tail.t47 AVSS 0.13092f
C1081 comparator_body_0.mref_m5_diff_0.tail.t81 AVSS 0.13148f
C1082 comparator_body_0.mref_m5_diff_0.tail.t46 AVSS 0.13148f
C1083 comparator_body_0.mref_m5_diff_0.tail.t50 AVSS 0.13092f
C1084 comparator_body_0.mref_m5_diff_0.tail.n64 AVSS 0.37971f
C1085 comparator_body_0.mref_m5_diff_0.tail.n65 AVSS 0.33593f
C1086 comparator_body_0.mref_m5_diff_0.tail.t77 AVSS 0.13092f
C1087 comparator_body_0.mref_m5_diff_0.tail.n66 AVSS 0.26245f
C1088 comparator_body_0.mref_m5_diff_0.tail.n67 AVSS 0.33593f
C1089 comparator_body_0.mref_m5_diff_0.tail.t53 AVSS 0.13092f
C1090 comparator_body_0.mref_m5_diff_0.tail.n68 AVSS 0.2615f
C1091 comparator_body_0.mref_m5_diff_0.tail.n69 AVSS 0.33593f
C1092 comparator_body_0.mref_m5_diff_0.tail.t86 AVSS 0.13092f
C1093 comparator_body_0.mref_m5_diff_0.tail.t74 AVSS 0.13092f
C1094 comparator_body_0.mref_m5_diff_0.tail.t12 AVSS 0.13107f
C1095 comparator_body_0.mref_m5_diff_0.tail.n70 AVSS 0.76957f
C1096 comparator_body_0.mref_m5_diff_0.tail.t20 AVSS 0.13107f
C1097 comparator_body_0.mref_m5_diff_0.tail.n71 AVSS 0.57763f
C1098 comparator_body_0.mref_m5_diff_0.tail.t26 AVSS 0.74794f
C1099 comparator_body_0.mref_m5_diff_0.tail.t23 AVSS 0.13107f
C1100 comparator_body_0.mref_m5_diff_0.tail.n72 AVSS 0.73491f
C1101 comparator_body_0.mref_m5_diff_0.tail.n73 AVSS 0.31101f
C1102 comparator_body_0.mref_m5_diff_0.tail.n74 AVSS 0.68128f
C1103 comparator_body_0.mref_m5_diff_0.tail.n75 AVSS 0.49972f
C1104 comparator_body_0.mref_m5_diff_0.tail.t17 AVSS 0.13064f
C1105 comparator_body_0.mref_m5_diff_0.tail.n76 AVSS 0.19943f
C1106 comparator_body_0.mref_m5_diff_0.tail.t11 AVSS 0.74864f
C1107 comparator_body_0.mref_m5_diff_0.tail.n77 AVSS 0.54437f
C1108 comparator_body_0.mref_m5_diff_0.tail.t24 AVSS 0.13107f
C1109 comparator_body_0.mref_m5_diff_0.tail.n78 AVSS 0.1986f
C1110 comparator_body_0.mref_m5_diff_0.tail.n79 AVSS 0.62185f
C1111 comparator_body_0.mref_m5_diff_0.tail.n80 AVSS 0.51902f
C1112 comparator_body_0.mref_m5_diff_0.tail.n81 AVSS 0.40414f
C1113 comparator_body_0.mref_m5_diff_0.tail.t44 AVSS 0.13148f
C1114 comparator_body_0.mref_m5_diff_0.tail.t80 AVSS 0.13148f
C1115 comparator_body_0.mref_m5_diff_0.tail.n82 AVSS 0.3232f
C1116 comparator_body_0.mref_m5_diff_0.tail.t62 AVSS 0.13148f
C1117 comparator_body_0.mref_m5_diff_0.tail.n83 AVSS 0.35956f
C1118 comparator_body_0.mref_m5_diff_0.tail.t89 AVSS 0.13092f
C1119 comparator_body_0.mref_m5_diff_0.tail.t51 AVSS 0.13148f
C1120 comparator_body_0.mref_m5_diff_0.tail.t49 AVSS 0.13092f
C1121 comparator_body_0.mref_m5_diff_0.tail.t79 AVSS 0.13148f
C1122 comparator_body_0.mref_m5_diff_0.tail.t52 AVSS 0.13148f
C1123 comparator_body_0.mref_m5_diff_0.tail.t92 AVSS 0.13148f
C1124 comparator_body_0.mref_m5_diff_0.tail.t88 AVSS 0.13092f
C1125 comparator_body_0.mref_m5_diff_0.tail.t57 AVSS 0.13092f
C1126 comparator_body_0.mref_m5_diff_0.tail.t90 AVSS 0.13092f
C1127 comparator_body_0.mref_m5_diff_0.tail.t61 AVSS 0.13092f
C1128 comparator_body_0.mref_m5_diff_0.tail.n84 AVSS 0.49075f
C1129 comparator_body_0.mref_m5_diff_0.tail.t54 AVSS 0.13148f
C1130 comparator_body_0.mref_m5_diff_0.tail.t7 AVSS 0.13107f
C1131 comparator_body_0.mref_m5_diff_0.tail.n85 AVSS 0.40649f
C1132 comparator_body_0.mref_m5_diff_0.tail.t84 AVSS 0.13148f
C1133 comparator_body_0.mref_m5_diff_0.tail.t85 AVSS 0.13092f
C1134 comparator_body_0.mref_m5_diff_0.tail.t60 AVSS 0.13148f
C1135 comparator_body_0.mref_m5_diff_0.tail.t56 AVSS 0.13092f
C1136 comparator_body_0.mref_m5_diff_0.tail.t64 AVSS 0.13092f
C1137 comparator_body_0.mref_m5_diff_0.tail.t82 AVSS 0.13148f
C1138 comparator_body_0.mref_m5_diff_0.tail.t91 AVSS 0.13092f
C1139 comparator_body_0.mref_m5_diff_0.tail.t63 AVSS 0.13092f
C1140 comparator_body_0.mref_m5_diff_0.tail.n86 AVSS 0.38637f
C1141 comparator_body_0.mref_m5_diff_0.tail.t94 AVSS 20.08007f
C1142 comparator_body_0.mref_m5_diff_0.tail.n87 AVSS 0.26245f
C1143 comparator_body_0.mref_m5_diff_0.tail.t37 AVSS 0.13092f
C1144 comparator_body_0.mref_m5_diff_0.tail.n88 AVSS 0.37971f
C1145 comparator_body_0.mref_m5_diff_0.tail.t69 AVSS 0.13148f
C1146 comparator_body_0.mref_m5_diff_0.tail.t35 AVSS 0.13148f
C1147 comparator_body_0.mref_m5_diff_0.tail.t93 AVSS 0.13092f
C1148 comparator_body_0.mref_m5_diff_0.tail.t58 AVSS 0.13148f
C1149 comparator_body_0.mref_m5_diff_0.tail.t75 AVSS 0.13148f
C1150 comparator_body_0.mref_m5_diff_0.tail.t59 AVSS 0.13148f
C1151 comparator_body_0.mref_m5_diff_0.tail.t18 AVSS 0.13064f
C1152 comparator_body_0.mref_m5_diff_0.tail.n89 AVSS 0.41743f
C1153 comparator_body_0.mref_m5_diff_0.tail.t83 AVSS 0.13148f
C1154 comparator_body_0.mref_m5_diff_0.tail.t55 AVSS 0.13092f
C1155 comparator_body_0.mref_m5_diff_0.tail.t76 AVSS 0.13148f
C1156 comparator_body_0.mref_m5_diff_0.tail.n90 AVSS 0.32829f
C1157 comparator_body_0.mref_m5_diff_0.tail.n91 AVSS 0.38286f
C1158 comparator_body_0.mref_m5_diff_0.tail.n92 AVSS 0.41896f
C1159 comparator_body_0.mref_m5_diff_0.tail.n93 AVSS 0.43896f
C1160 comparator_body_0.mref_m5_diff_0.tail.n94 AVSS 0.57424f
C1161 comparator_body_0.mref_m5_diff_0.tail.t6 AVSS 0.13107f
C1162 comparator_body_0.mref_m5_diff_0.tail.n95 AVSS 0.1986f
C1163 comparator_body_0.mref_m5_diff_0.tail.n96 AVSS 0.50295f
C1164 comparator_body_0.mref_m5_diff_0.tail.n97 AVSS 0.51518f
C1165 comparator_body_0.mref_m5_diff_0.tail.n98 AVSS 0.31466f
C1166 comparator_body_0.mref_m5_diff_0.tail.t1 AVSS 0.74864f
C1167 comparator_body_0.mref_m5_diff_0.tail.t27 AVSS 0.13107f
C1168 comparator_body_0.mref_m5_diff_0.tail.n99 AVSS 0.19862f
C1169 comparator_body_0.mref_m5_diff_0.tail.n100 AVSS 0.31101f
C1170 comparator_body_0.mref_m5_diff_0.tail.n101 AVSS 0.68128f
C1171 comparator_body_0.mref_m5_diff_0.tail.n102 AVSS 0.49972f
C1172 comparator_body_0.mref_m5_diff_0.tail.n103 AVSS 0.57763f
C1173 comparator_body_0.mref_m5_diff_0.tail.t28 AVSS 0.74837f
C1174 comparator_body_0.mref_m5_diff_0.tail.n104 AVSS 0.61844f
C1175 comparator_body_0.mref_m5_diff_0.tail.n105 AVSS 0.31101f
C1176 comparator_body_0.mref_m5_diff_0.tail.n106 AVSS 0.68128f
C1177 comparator_body_0.mref_m5_diff_0.tail.n107 AVSS 0.49972f
C1178 comparator_body_0.mref_m5_diff_0.tail.n108 AVSS 0.57763f
C1179 comparator_body_0.mref_m5_diff_0.tail.n109 AVSS 0.84443f
C1180 comparator_body_0.mref_m5_diff_0.tail.n110 AVSS 0.54437f
C1181 comparator_body_0.mref_m5_diff_0.tail.t19 AVSS 0.13107f
C1182 comparator_body_0.mref_m5_diff_0.tail.n111 AVSS 0.1986f
C1183 comparator_body_0.mref_m5_diff_0.tail.n112 AVSS 0.50295f
C1184 comparator_body_0.mref_m5_diff_0.tail.n113 AVSS 0.52029f
C1185 comparator_body_0.mref_m5_diff_0.tail.n114 AVSS 0.40287f
C1186 comparator_body_0.mref_m5_diff_0.tail.t71 AVSS 0.13148f
C1187 comparator_body_0.mref_m5_diff_0.tail.t42 AVSS 17.15623f
C1188 comparator_body_0.mref_m5_diff_0.tail.t68 AVSS 0.13148f
C1189 comparator_body_0.mref_m5_diff_0.tail.t95 AVSS 0.13148f
C1190 comparator_body_0.mref_m5_diff_0.tail.t38 AVSS 0.13148f
C1191 comparator_body_0.mref_m5_diff_0.tail.n115 AVSS 0.37374f
C1192 comparator_body_0.mref_m5_diff_0.tail.n116 AVSS 0.42514f
C1193 comparator_body_0.mref_m5_diff_0.tail.n117 AVSS 0.43278f
C1194 comparator_body_0.mref_m5_diff_0.tail.n118 AVSS 0.31466f
C1195 comparator_body_0.mref_m5_diff_0.tail.t5 AVSS 0.13064f
C1196 comparator_body_0.mref_m5_diff_0.tail.n119 AVSS 0.54437f
C1197 comparator_body_0.mref_m5_diff_0.tail.n120 AVSS 0.19787f
C1198 AVSS.t45 AVSS 0.6173f
C1199 AVSS.t21 AVSS 0.6173f
C1200 AVSS.t22 AVSS 0.6173f
C1201 AVSS.t44 AVSS 0.6173f
C1202 AVSS.t23 AVSS 0.6173f
C1203 AVSS.t3 AVSS 0.6173f
C1204 AVSS.t92 AVSS 2.92872f
C1205 AVSS.t89 AVSS 0.69104f
C1206 AVSS.t77 AVSS 0.68925f
C1207 AVSS.t74 AVSS 0.6173f
C1208 AVSS.t68 AVSS 0.6173f
C1209 AVSS.t65 AVSS 0.61799f
C1210 AVSS.t66 AVSS 0.61799f
C1211 AVSS.t70 AVSS 0.6173f
C1212 AVSS.t52 AVSS 0.6173f
C1213 AVSS.t46 AVSS 0.61799f
C1214 AVSS.t55 AVSS 0.6173f
C1215 AVSS.t53 AVSS 0.6173f
C1216 AVSS.t64 AVSS 0.6173f
C1217 AVSS.t7 AVSS 0.6173f
C1218 AVSS.t9 AVSS 0.6173f
C1219 ibias.n0 AVSS 0.93245f
C1220 ibias.n3 AVSS 0.93245f
C1221 ibias.n4 AVSS 0.12254f
C1222 ibias.n6 AVSS 0.93245f
C1223 ibias.n7 AVSS 0.12254f
C1224 ibias.t47 AVSS 1.0255f
C1225 ibias.n9 AVSS 0.12254f
C1226 ibias.n11 AVSS 0.16307f
C1227 ibias.t35 AVSS 1.23757f
C1228 ibias.n12 AVSS 0.23109f
C1229 ibias.t63 AVSS 0.68517f
C1230 ibias.n13 AVSS 0.67521f
C1231 ibias.n15 AVSS 0.23026f
C1232 ibias.n16 AVSS 0.70577f
C1233 ibias.n17 AVSS 0.34903f
C1234 ibias.n18 AVSS 0.3507f
C1235 ibias.n20 AVSS 0.58997f
C1236 ibias.n22 AVSS 0.58997f
C1237 ibias.n24 AVSS 0.34903f
C1238 ibias.n25 AVSS 0.32451f
C1239 ibias.n27 AVSS 0.3507f
C1240 ibias.n28 AVSS 0.58997f
C1241 ibias.n29 AVSS 0.34903f
C1242 ibias.n30 AVSS 2.61003f
C1243 ibias.n32 AVSS 0.59512f
C1244 ibias.n33 AVSS 0.3507f
C1245 ibias.n34 AVSS 0.41059f
C1246 ibias.n37 AVSS 0.79409f
C1247 ibias.n38 AVSS 0.19596f
C1248 ibias.n41 AVSS 0.7607f
C1249 ibias.n42 AVSS 0.64911f
C1250 ibias.n47 AVSS 0.46544f
C1251 ibias.n48 AVSS 0.76738f
C1252 ibias.n49 AVSS 0.22869f
C1253 ibias.n50 AVSS 0.45397f
C1254 ibias.n51 AVSS 0.95124f
C1255 ibias.n52 AVSS 1.52418f
C1256 ibias.n53 AVSS 1.52418f
C1257 ibias.t37 AVSS 1.30762f
C1258 ibias.n56 AVSS 0.59512f
C1259 ibias.n59 AVSS 0.59512f
C1260 ibias.n62 AVSS 0.98564f
C1261 ibias.n63 AVSS 0.32435f
C1262 ibias.t7 AVSS 0.65695f
C1263 ibias.t3 AVSS 0.55014f
C1264 ibias.n64 AVSS 0.55977f
C1265 ibias.n65 AVSS 0.54343f
C1266 ibias.n66 AVSS 0.48347f
C1267 ibias.n67 AVSS 0.54626f
C1268 ibias.n68 AVSS 0.54343f
C1269 ibias.n69 AVSS 0.36789f
C1270 ibias.n70 AVSS 0.54626f
C1271 ibias.n71 AVSS 0.54343f
C1272 ibias.n72 AVSS 0.55695f
C1273 ibias.n73 AVSS 0.33306f
C1274 ibias.n74 AVSS 0.55695f
C1275 ibias.n75 AVSS 0.55977f
C1276 ibias.n76 AVSS 0.33306f
C1277 ibias.n77 AVSS 0.55695f
C1278 ibias.n78 AVSS 0.55977f
C1279 ibias.n79 AVSS 0.5697f
C1280 ibias.n80 AVSS 0.3831f
C1281 ibias.n81 AVSS 0.32268f
C1282 ibias.n82 AVSS 0.62836f
C1283 ibias.n83 AVSS 0.37403f
C1284 ibias.t1 AVSS 0.65911f
C1285 ibias.t9 AVSS 1.18652f
C1286 ibias.t21 AVSS 0.0952f
C1287 ibias.t5 AVSS 0.0952f
C1288 ibias.t45 AVSS 0.09442f
C1289 ibias.t43 AVSS 0.0952f
C1290 ibias.t23 AVSS 0.09764f
C1291 ibias.t11 AVSS 0.0952f
C1292 ibias.t39 AVSS 0.7125f
C1293 ibias.t13 AVSS 0.7125f
C1294 ibias.t41 AVSS 0.71172f
C1295 ibias.t57 AVSS 0.7125f
C1296 ibias.t55 AVSS 0.09764f
C1297 ibias.t49 AVSS 0.09442f
C1298 ibias.t51 AVSS 0.0952f
C1299 ibias.t25 AVSS 0.09426f
C1300 ibias.n84 AVSS 0.67736f
C1301 ibias.t27 AVSS 0.7125f
C1302 ibias.t29 AVSS 0.0952f
C1303 ibias.n85 AVSS 0.16307f
C1304 ibias.n86 AVSS 0.53495f
C1305 ibias.n87 AVSS 0.33306f
C1306 ibias.n88 AVSS 0.32451f
C1307 ibias.t15 AVSS 0.71563f
C1308 ibias.t59 AVSS 0.09442f
C1309 ibias.t31 AVSS 0.0952f
C1310 ibias.t61 AVSS 0.09442f
C1311 ibias.t53 AVSS 0.09426f
C1312 ibias.n89 AVSS 0.32451f
C1313 ibias.t17 AVSS 0.09442f
C1314 ibias.t19 AVSS 0.0952f
C1315 ibias.t33 AVSS 0.09426f
C1316 ibias.n90 AVSS 0.65924f
C1317 ibias.n91 AVSS 0.34266f
C1318 ibias.n92 AVSS 0.42028f
C1319 ibias.n93 AVSS 0.57834f
C1320 ibias.n94 AVSS 1.38445f
.ends
