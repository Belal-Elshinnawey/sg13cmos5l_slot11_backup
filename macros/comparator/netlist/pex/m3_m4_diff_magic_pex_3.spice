* PEX produced on Sun Nov  8 06:17:30 PM CET 2026 using /foss/tools/sak/sak-pex.sh with m=3 and s=1 (extresist threshold=10000 mOhm, minres=1000 mOhm, mindelay=1 ps)
* NGSPICE file created from m3_m4_diff_pex.ext - technology: ihp-sg13cmos5l

.subckt m3_m4_diff_pex avdd n1 outx
X0 a_852_n2726# n1 n1 avdd sg13_hv_pmos ad=0.85p pd=5.68u as=0.85p ps=5.68u w=2.5u l=1u
X1 a_268_n1536# n1 avdd avdd sg13_hv_pmos ad=0.85p pd=5.68u as=0.85p ps=5.68u w=2.5u l=1u
X2 a_852_3354# n1 outx avdd sg13_hv_pmos ad=0.85p pd=5.68u as=0.85p ps=5.68u w=2.5u l=1u
X3 avdd n1 a_1752_7054# avdd sg13_hv_pmos ad=0.85p pd=5.68u as=0.85p ps=5.68u w=2.5u l=1u
X4 avdd n1 a_1752_11944# avdd sg13_hv_pmos ad=0.85p pd=5.68u as=0.85p ps=5.68u w=2.5u l=1u
X5 a_268_3354# n1 avdd avdd sg13_hv_pmos ad=0.85p pd=5.68u as=0.85p ps=5.68u w=2.5u l=1u
X6 n1 n1 a_1752_n2726# avdd sg13_hv_pmos ad=0.85p pd=5.68u as=0.85p ps=5.68u w=2.5u l=1u
X7 a_268_11944# n1 outx avdd sg13_hv_pmos ad=0.85p pd=5.68u as=0.85p ps=5.68u w=2.5u l=1u
X8 a_268_7054# n1 outx avdd sg13_hv_pmos ad=0.85p pd=5.68u as=0.85p ps=5.68u w=2.5u l=1u
X9 avdd n1 a_1168_10754# avdd sg13_hv_pmos ad=0.85p pd=5.68u as=0.85p ps=5.68u w=2.5u l=1u
X10 a_852_5864# n1 avdd avdd sg13_hv_pmos ad=0.85p pd=5.68u as=0.85p ps=5.68u w=2.5u l=1u
X11 a_852_n216# n1 avdd avdd sg13_hv_pmos ad=0.85p pd=5.68u as=0.85p ps=5.68u w=2.5u l=1u
X12 n1 n1 a_1168_3354# avdd sg13_hv_pmos ad=0.85p pd=5.68u as=0.85p ps=5.68u w=2.5u l=1u
X13 a_852_2164# n1 avdd avdd sg13_hv_pmos ad=0.85p pd=5.68u as=0.85p ps=5.68u w=2.5u l=1u
X14 outx n1 a_1168_n5106# avdd sg13_hv_pmos ad=0.85p pd=5.68u as=0.85p ps=5.68u w=2.5u l=1u
X15 a_268_n2726# n1 avdd avdd sg13_hv_pmos ad=0.85p pd=5.68u as=0.85p ps=5.68u w=2.5u l=1u
X16 a_268_9564# n1 avdd avdd sg13_hv_pmos ad=0.85p pd=5.68u as=0.85p ps=5.68u w=2.5u l=1u
X17 avdd n1 a_1168_974# avdd sg13_hv_pmos ad=0.85p pd=5.68u as=0.85p ps=5.68u w=2.5u l=1u
X18 a_268_5864# n1 n1 avdd sg13_hv_pmos ad=0.85p pd=5.68u as=0.85p ps=5.68u w=2.5u l=1u
X19 avdd n1 a_1168_5864# avdd sg13_hv_pmos ad=0.85p pd=5.68u as=0.85p ps=5.68u w=2.5u l=1u
X20 a_852_11944# n1 n1 avdd sg13_hv_pmos ad=0.85p pd=5.68u as=0.85p ps=5.68u w=2.5u l=1u
X21 avdd n1 a_1752_n1536# avdd sg13_hv_pmos ad=0.85p pd=5.68u as=0.85p ps=5.68u w=2.5u l=1u
X22 avdd n1 a_1168_n216# avdd sg13_hv_pmos ad=0.85p pd=5.68u as=0.85p ps=5.68u w=2.5u l=1u
X23 avdd n1 a_1168_2164# avdd sg13_hv_pmos ad=0.85p pd=5.68u as=0.85p ps=5.68u w=2.5u l=1u
X24 avdd n1 a_1168_13134# avdd sg13_hv_pmos ad=0.85p pd=5.68u as=0.85p ps=5.68u w=2.5u l=1u
X25 a_852_8244# n1 avdd avdd sg13_hv_pmos ad=0.85p pd=5.68u as=0.85p ps=5.68u w=2.5u l=1u
X26 a_268_10754# n1 n1 avdd sg13_hv_pmos ad=0.85p pd=5.68u as=0.85p ps=5.68u w=2.5u l=1u
X27 avdd n1 a_1168_n3916# avdd sg13_hv_pmos ad=0.85p pd=5.68u as=0.85p ps=5.68u w=2.5u l=1u
X28 avdd n1 a_1752_3354# avdd sg13_hv_pmos ad=0.85p pd=5.68u as=0.85p ps=5.68u w=2.5u l=1u
X29 a_268_n1536# n1 n1 avdd sg13_hv_pmos ad=0.85p pd=5.68u as=0.85p ps=5.68u w=2.5u l=1u
X30 n1 n1 a_1752_11944# avdd sg13_hv_pmos ad=0.85p pd=5.68u as=0.85p ps=5.68u w=2.5u l=1u
X31 outx n1 a_1168_9564# avdd sg13_hv_pmos ad=0.85p pd=5.68u as=0.85p ps=5.68u w=2.5u l=1u
X32 a_852_4674# n1 n1 avdd sg13_hv_pmos ad=0.85p pd=5.68u as=0.85p ps=5.68u w=2.5u l=1u
X33 a_268_n5106# n1 avdd avdd sg13_hv_pmos ad=0.85p pd=5.68u as=0.85p ps=5.68u w=2.5u l=1u
X34 a_852_n2726# n1 avdd avdd sg13_hv_pmos ad=0.85p pd=5.68u as=0.85p ps=5.68u w=2.5u l=1u
X35 n1 n1 a_1752_7054# avdd sg13_hv_pmos ad=0.85p pd=5.68u as=0.85p ps=5.68u w=2.5u l=1u
X36 avdd n1 a_1168_8244# avdd sg13_hv_pmos ad=0.85p pd=5.68u as=0.85p ps=5.68u w=2.5u l=1u
X37 a_268_3354# n1 n1 avdd sg13_hv_pmos ad=0.85p pd=5.68u as=0.85p ps=5.68u w=2.5u l=1u
X38 avdd n1 a_1752_n2726# avdd sg13_hv_pmos ad=0.85p pd=5.68u as=0.85p ps=5.68u w=2.5u l=1u
X39 outx n1 a_1168_n216# avdd sg13_hv_pmos ad=0.85p pd=5.68u as=0.85p ps=5.68u w=2.5u l=1u
X40 outx n1 a_1168_4674# avdd sg13_hv_pmos ad=0.85p pd=5.68u as=0.85p ps=5.68u w=2.5u l=1u
X41 a_852_10754# n1 outx avdd sg13_hv_pmos ad=0.85p pd=5.68u as=0.85p ps=5.68u w=2.5u l=1u
X42 avdd n1 a_1752_9564# avdd sg13_hv_pmos ad=0.85p pd=5.68u as=0.85p ps=5.68u w=2.5u l=1u
X43 a_852_n1536# n1 outx avdd sg13_hv_pmos ad=0.85p pd=5.68u as=0.85p ps=5.68u w=2.5u l=1u
X44 a_852_2164# n1 n1 avdd sg13_hv_pmos ad=0.85p pd=5.68u as=0.85p ps=5.68u w=2.5u l=1u
X45 outx n1 a_1752_5864# avdd sg13_hv_pmos ad=0.85p pd=5.68u as=0.85p ps=5.68u w=2.5u l=1u
X46 a_852_n5106# n1 avdd avdd sg13_hv_pmos ad=0.85p pd=5.68u as=0.85p ps=5.68u w=2.5u l=1u
X47 outx n1 a_1752_10754# avdd sg13_hv_pmos ad=0.85p pd=5.68u as=0.85p ps=5.68u w=2.5u l=1u
X48 a_268_5864# n1 avdd avdd sg13_hv_pmos ad=0.85p pd=5.68u as=0.85p ps=5.68u w=2.5u l=1u
X49 a_268_n216# n1 avdd avdd sg13_hv_pmos ad=0.85p pd=5.68u as=0.85p ps=5.68u w=2.5u l=1u
X50 a_268_2164# n1 avdd avdd sg13_hv_pmos ad=0.85p pd=5.68u as=0.85p ps=5.68u w=2.5u l=1u
X51 outx n1 a_1752_n1536# avdd sg13_hv_pmos ad=0.85p pd=5.68u as=0.85p ps=5.68u w=2.5u l=1u
X52 a_268_10754# n1 avdd avdd sg13_hv_pmos ad=0.85p pd=5.68u as=0.85p ps=5.68u w=2.5u l=1u
X53 avdd n1 a_1752_n5106# avdd sg13_hv_pmos ad=0.85p pd=5.68u as=0.85p ps=5.68u w=2.5u l=1u
X54 a_852_4674# n1 avdd avdd sg13_hv_pmos ad=0.85p pd=5.68u as=0.85p ps=5.68u w=2.5u l=1u
X55 n1 n1 a_1168_13134# avdd sg13_hv_pmos ad=0.85p pd=5.68u as=0.85p ps=5.68u w=2.5u l=1u
X56 a_268_n5106# n1 outx avdd sg13_hv_pmos ad=0.85p pd=5.68u as=0.85p ps=5.68u w=2.5u l=1u
X57 a_852_974# n1 outx avdd sg13_hv_pmos ad=0.85p pd=5.68u as=0.85p ps=5.68u w=2.5u l=1u
X58 outx n1 a_1168_2164# avdd sg13_hv_pmos ad=0.85p pd=5.68u as=0.85p ps=5.68u w=2.5u l=1u
X59 a_852_8244# n1 outx avdd sg13_hv_pmos ad=0.85p pd=5.68u as=0.85p ps=5.68u w=2.5u l=1u
X60 n1 n1 a_1168_n3916# avdd sg13_hv_pmos ad=0.85p pd=5.68u as=0.85p ps=5.68u w=2.5u l=1u
X61 outx n1 a_1752_3354# avdd sg13_hv_pmos ad=0.85p pd=5.68u as=0.85p ps=5.68u w=2.5u l=1u
X62 a_268_8244# n1 avdd avdd sg13_hv_pmos ad=0.85p pd=5.68u as=0.85p ps=5.68u w=2.5u l=1u
X63 a_268_13134# n1 avdd avdd sg13_hv_pmos ad=0.85p pd=5.68u as=0.85p ps=5.68u w=2.5u l=1u
X64 a_268_4674# n1 outx avdd sg13_hv_pmos ad=0.85p pd=5.68u as=0.85p ps=5.68u w=2.5u l=1u
X65 avdd n1 a_1168_4674# avdd sg13_hv_pmos ad=0.85p pd=5.68u as=0.85p ps=5.68u w=2.5u l=1u
X66 a_852_10754# n1 avdd avdd sg13_hv_pmos ad=0.85p pd=5.68u as=0.85p ps=5.68u w=2.5u l=1u
X67 n1 n1 a_1168_8244# avdd sg13_hv_pmos ad=0.85p pd=5.68u as=0.85p ps=5.68u w=2.5u l=1u
X68 avdd n1 a_1168_11944# avdd sg13_hv_pmos ad=0.85p pd=5.68u as=0.85p ps=5.68u w=2.5u l=1u
X69 a_268_n3916# n1 avdd avdd sg13_hv_pmos ad=0.85p pd=5.68u as=0.85p ps=5.68u w=2.5u l=1u
X70 n1 n1 a_1168_974# avdd sg13_hv_pmos ad=0.85p pd=5.68u as=0.85p ps=5.68u w=2.5u l=1u
X71 a_852_7054# n1 avdd avdd sg13_hv_pmos ad=0.85p pd=5.68u as=0.85p ps=5.68u w=2.5u l=1u
X72 a_268_9564# n1 outx avdd sg13_hv_pmos ad=0.85p pd=5.68u as=0.85p ps=5.68u w=2.5u l=1u
X73 avdd n1 a_1752_5864# avdd sg13_hv_pmos ad=0.85p pd=5.68u as=0.85p ps=5.68u w=2.5u l=1u
X74 outx n1 a_1168_n2726# avdd sg13_hv_pmos ad=0.85p pd=5.68u as=0.85p ps=5.68u w=2.5u l=1u
X75 avdd n1 a_1752_n216# avdd sg13_hv_pmos ad=0.85p pd=5.68u as=0.85p ps=5.68u w=2.5u l=1u
X76 avdd n1 a_1752_974# avdd sg13_hv_pmos ad=0.85p pd=5.68u as=0.85p ps=5.68u w=2.5u l=1u
X77 a_852_n5106# n1 n1 avdd sg13_hv_pmos ad=0.85p pd=5.68u as=0.85p ps=5.68u w=2.5u l=1u
X78 avdd n1 a_1752_2164# avdd sg13_hv_pmos ad=0.85p pd=5.68u as=0.85p ps=5.68u w=2.5u l=1u
X79 avdd n1 a_1752_10754# avdd sg13_hv_pmos ad=0.85p pd=5.68u as=0.85p ps=5.68u w=2.5u l=1u
X80 n1 n1 a_1752_n5106# avdd sg13_hv_pmos ad=0.85p pd=5.68u as=0.85p ps=5.68u w=2.5u l=1u
X81 a_268_974# n1 avdd avdd sg13_hv_pmos ad=0.85p pd=5.68u as=0.85p ps=5.68u w=2.5u l=1u
X82 avdd n1 a_1168_7054# avdd sg13_hv_pmos ad=0.85p pd=5.68u as=0.85p ps=5.68u w=2.5u l=1u
X83 a_852_13134# n1 avdd avdd sg13_hv_pmos ad=0.85p pd=5.68u as=0.85p ps=5.68u w=2.5u l=1u
X84 a_268_2164# n1 outx avdd sg13_hv_pmos ad=0.85p pd=5.68u as=0.85p ps=5.68u w=2.5u l=1u
X85 a_852_974# n1 avdd avdd sg13_hv_pmos ad=0.85p pd=5.68u as=0.85p ps=5.68u w=2.5u l=1u
X86 avdd n1 a_1752_8244# avdd sg13_hv_pmos ad=0.85p pd=5.68u as=0.85p ps=5.68u w=2.5u l=1u
X87 a_852_n3916# n1 avdd avdd sg13_hv_pmos ad=0.85p pd=5.68u as=0.85p ps=5.68u w=2.5u l=1u
X88 a_852_9564# n1 n1 avdd sg13_hv_pmos ad=0.85p pd=5.68u as=0.85p ps=5.68u w=2.5u l=1u
X89 avdd n1 a_1752_13134# avdd sg13_hv_pmos ad=0.85p pd=5.68u as=0.85p ps=5.68u w=2.5u l=1u
X90 n1 n1 a_1752_4674# avdd sg13_hv_pmos ad=0.85p pd=5.68u as=0.85p ps=5.68u w=2.5u l=1u
X91 n1 n1 a_1752_n216# avdd sg13_hv_pmos ad=0.85p pd=5.68u as=0.85p ps=5.68u w=2.5u l=1u
X92 avdd n1 a_1752_n3916# avdd sg13_hv_pmos ad=0.85p pd=5.68u as=0.85p ps=5.68u w=2.5u l=1u
X93 a_268_4674# n1 avdd avdd sg13_hv_pmos ad=0.85p pd=5.68u as=0.85p ps=5.68u w=2.5u l=1u
X94 n1 n1 a_1752_9564# avdd sg13_hv_pmos ad=0.85p pd=5.68u as=0.85p ps=5.68u w=2.5u l=1u
X95 a_852_n1536# n1 avdd avdd sg13_hv_pmos ad=0.85p pd=5.68u as=0.85p ps=5.68u w=2.5u l=1u
X96 a_268_974# n1 n1 avdd sg13_hv_pmos ad=0.85p pd=5.68u as=0.85p ps=5.68u w=2.5u l=1u
X97 a_268_8244# n1 n1 avdd sg13_hv_pmos ad=0.85p pd=5.68u as=0.85p ps=5.68u w=2.5u l=1u
X98 outx n1 a_1168_11944# avdd sg13_hv_pmos ad=0.85p pd=5.68u as=0.85p ps=5.68u w=2.5u l=1u
X99 a_852_3354# n1 avdd avdd sg13_hv_pmos ad=0.85p pd=5.68u as=0.85p ps=5.68u w=2.5u l=1u
X100 a_268_13134# n1 n1 avdd sg13_hv_pmos ad=0.85p pd=5.68u as=0.85p ps=5.68u w=2.5u l=1u
X101 a_268_n216# n1 outx avdd sg13_hv_pmos ad=0.85p pd=5.68u as=0.85p ps=5.68u w=2.5u l=1u
X102 a_268_n3916# n1 n1 avdd sg13_hv_pmos ad=0.85p pd=5.68u as=0.85p ps=5.68u w=2.5u l=1u
X103 a_852_7054# n1 n1 avdd sg13_hv_pmos ad=0.85p pd=5.68u as=0.85p ps=5.68u w=2.5u l=1u
X104 a_852_n216# n1 n1 avdd sg13_hv_pmos ad=0.85p pd=5.68u as=0.85p ps=5.68u w=2.5u l=1u
X105 avdd n1 a_1168_n2726# avdd sg13_hv_pmos ad=0.85p pd=5.68u as=0.85p ps=5.68u w=2.5u l=1u
X106 avdd n1 a_1168_n1536# avdd sg13_hv_pmos ad=0.85p pd=5.68u as=0.85p ps=5.68u w=2.5u l=1u
X107 n1 n1 a_1752_2164# avdd sg13_hv_pmos ad=0.85p pd=5.68u as=0.85p ps=5.68u w=2.5u l=1u
X108 a_268_7054# n1 avdd avdd sg13_hv_pmos ad=0.85p pd=5.68u as=0.85p ps=5.68u w=2.5u l=1u
X109 avdd n1 a_1168_3354# avdd sg13_hv_pmos ad=0.85p pd=5.68u as=0.85p ps=5.68u w=2.5u l=1u
X110 a_268_11944# n1 avdd avdd sg13_hv_pmos ad=0.85p pd=5.68u as=0.85p ps=5.68u w=2.5u l=1u
X111 a_852_9564# n1 avdd avdd sg13_hv_pmos ad=0.85p pd=5.68u as=0.85p ps=5.68u w=2.5u l=1u
X112 n1 n1 a_1168_10754# avdd sg13_hv_pmos ad=0.85p pd=5.68u as=0.85p ps=5.68u w=2.5u l=1u
X113 a_268_n2726# n1 outx avdd sg13_hv_pmos ad=0.85p pd=5.68u as=0.85p ps=5.68u w=2.5u l=1u
X114 a_852_5864# n1 outx avdd sg13_hv_pmos ad=0.85p pd=5.68u as=0.85p ps=5.68u w=2.5u l=1u
X115 outx n1 a_1168_7054# avdd sg13_hv_pmos ad=0.85p pd=5.68u as=0.85p ps=5.68u w=2.5u l=1u
X116 a_852_13134# n1 outx avdd sg13_hv_pmos ad=0.85p pd=5.68u as=0.85p ps=5.68u w=2.5u l=1u
X117 avdd n1 a_1752_4674# avdd sg13_hv_pmos ad=0.85p pd=5.68u as=0.85p ps=5.68u w=2.5u l=1u
X118 n1 n1 a_1168_n1536# avdd sg13_hv_pmos ad=0.85p pd=5.68u as=0.85p ps=5.68u w=2.5u l=1u
X119 a_852_n3916# n1 outx avdd sg13_hv_pmos ad=0.85p pd=5.68u as=0.85p ps=5.68u w=2.5u l=1u
X120 outx n1 a_1752_974# avdd sg13_hv_pmos ad=0.85p pd=5.68u as=0.85p ps=5.68u w=2.5u l=1u
X121 outx n1 a_1752_8244# avdd sg13_hv_pmos ad=0.85p pd=5.68u as=0.85p ps=5.68u w=2.5u l=1u
X122 avdd n1 a_1168_n5106# avdd sg13_hv_pmos ad=0.85p pd=5.68u as=0.85p ps=5.68u w=2.5u l=1u
X123 outx n1 a_1752_13134# avdd sg13_hv_pmos ad=0.85p pd=5.68u as=0.85p ps=5.68u w=2.5u l=1u
X124 avdd n1 a_1168_9564# avdd sg13_hv_pmos ad=0.85p pd=5.68u as=0.85p ps=5.68u w=2.5u l=1u
X125 outx n1 a_1752_n3916# avdd sg13_hv_pmos ad=0.85p pd=5.68u as=0.85p ps=5.68u w=2.5u l=1u
X126 n1 n1 a_1168_5864# avdd sg13_hv_pmos ad=0.85p pd=5.68u as=0.85p ps=5.68u w=2.5u l=1u
X127 a_852_11944# n1 avdd avdd sg13_hv_pmos ad=0.85p pd=5.68u as=0.85p ps=5.68u w=2.5u l=1u
C0 a_852_3354# n1 0.72719f
C1 a_268_4674# avdd 0.23311f
C2 n1 a_852_n1536# 0.72719f
C3 a_1168_n1536# outx 0.09565f
C4 n1 a_1168_n5106# 0.72719f
C5 a_852_974# outx 0.19516f
C6 avdd a_268_n3916# 0.22127f
C7 a_1752_13134# avdd 0.21562f
C8 a_1752_n5106# avdd 0.22338f
C9 a_268_4674# n1 0.7271f
C10 a_1752_n216# outx 0.07771f
C11 outx a_1752_8244# 0.19367f
C12 a_1168_n2726# avdd 0.24107f
C13 a_1752_5864# outx 0.19099f
C14 a_1752_11944# outx 0.10351f
C15 n1 a_268_n3916# 0.83215f
C16 a_1752_13134# n1 0.7271f
C17 n1 a_1752_n5106# 0.81575f
C18 a_1752_9564# avdd 0.24123f
C19 a_1168_n2726# n1 0.727f
C20 outx a_1168_n216# 0.20936f
C21 a_268_10754# outx 0.10479f
C22 a_852_8244# outx 0.21109f
C23 avdd a_1752_10754# 0.21755f
C24 a_1752_9564# n1 0.81575f
C25 a_268_9564# avdd 0.23421f
C26 a_268_8244# avdd 0.23898f
C27 avdd a_1168_8244# 0.24966f
C28 a_268_7054# avdd 0.21775f
C29 n1 a_1752_10754# 0.74374f
C30 a_1168_10754# outx 0.10658f
C31 a_852_n5106# avdd 0.24955f
C32 a_268_9564# n1 0.7271f
C33 a_268_8244# n1 0.81435f
C34 n1 a_1168_8244# 0.81444f
C35 a_268_7054# n1 0.72692f
C36 avdd a_1752_n1536# 0.23146f
C37 a_268_n1536# avdd 0.23986f
C38 a_852_7054# avdd 0.2495f
C39 avdd a_1752_2164# 0.22442f
C40 a_1752_7054# outx 0.10351f
C41 a_852_n5106# n1 0.81584f
C42 a_1168_5864# outx 0.10658f
C43 a_852_4674# avdd 0.24955f
C44 a_268_n1536# n1 0.81435f
C45 n1 a_1752_n1536# 0.7271f
C46 avdd a_1168_4674# 0.24138f
C47 a_852_7054# n1 0.81425f
C48 outx a_268_3354# 0.07768f
C49 a_1168_974# avdd 0.2488f
C50 n1 a_1752_2164# 0.81417f
C51 a_268_2164# avdd 0.21796f
C52 outx a_1168_7054# 0.1953f
C53 a_852_4674# n1 0.81584f
C54 n1 a_1168_4674# 0.72719f
C55 a_1168_974# n1 0.83223f
C56 a_268_2164# n1 0.72692f
C57 a_268_n216# avdd 0.23336f
C58 a_1752_n3916# outx 0.19099f
C59 a_1168_n3916# outx 0.10658f
C60 avdd a_1752_4674# 0.24019f
C61 a_268_974# outx 0.10479f
C62 a_852_n2726# avdd 0.2495f
C63 n1 a_268_n216# 0.7271f
C64 n1 a_1752_4674# 0.81575f
C65 avdd a_1752_974# 0.21738f
C66 outx a_852_5864# 0.19516f
C67 a_852_n3916# avdd 0.2406f
C68 a_852_13134# outx 0.21057f
C69 a_852_n2726# n1 0.81425f
C70 a_852_11944# outx 0.10672f
C71 a_1168_13134# avdd 0.24966f
C72 a_852_9564# avdd 0.24955f
C73 n1 a_852_n3916# 0.74383f
C74 n1 a_1752_974# 0.74374f
C75 a_1168_13134# n1 0.81444f
C76 a_1168_3354# outx 0.09565f
C77 a_1168_11944# outx 0.19529f
C78 a_268_5864# outx 0.10479f
C79 a_852_9564# n1 0.81584f
C80 a_1168_9564# avdd 0.24138f
C81 a_268_n5106# avdd 0.21688f
C82 n1 avdd 0.11138p
C83 a_1168_9564# n1 0.72719f
C84 a_268_n5106# n1 0.7271f
C85 avdd a_268_n2726# 0.21791f
C86 a_852_n216# outx 0.09413f
C87 a_1168_2164# outx 0.1953f
C88 a_1752_3354# outx 0.19367f
C89 n1 a_268_n2726# 0.72692f
C90 a_1752_n2726# avdd 0.22437f
C91 a_268_11944# outx 0.19118f
C92 a_852_3354# outx 0.21109f
C93 a_852_n1536# outx 0.21109f
C94 a_852_2164# avdd 0.2495f
C95 outx a_1168_n5106# 0.20889f
C96 avdd a_852_10754# 0.2406f
C97 a_268_13134# avdd 0.22339f
C98 a_1752_n2726# n1 0.81417f
C99 a_268_4674# outx 0.19118f
C100 a_1168_n1536# avdd 0.24966f
C101 a_852_2164# n1 0.81425f
C102 a_852_974# avdd 0.2406f
C103 n1 a_852_10754# 0.74383f
C104 a_268_13134# n1 0.81435f
C105 outx a_268_n3916# 0.10479f
C106 a_1752_13134# outx 0.19367f
C107 a_1752_n216# avdd 0.24036f
C108 outx a_1752_n5106# 0.07727f
C109 avdd a_1752_8244# 0.2306f
C110 a_1168_n1536# n1 0.81444f
C111 a_1168_n2726# outx 0.1953f
C112 a_1752_5864# avdd 0.21733f
C113 a_852_974# n1 0.74383f
C114 a_1752_11944# avdd 0.22189f
C115 n1 a_1752_n216# 0.81575f
C116 n1 a_1752_8244# 0.7271f
C117 a_1752_9564# outx 0.07771f
C118 a_1752_5864# n1 0.74374f
C119 avdd a_1168_n216# 0.24138f
C120 a_1752_11944# n1 0.81417f
C121 a_268_10754# avdd 0.22401f
C122 a_852_8244# avdd 0.24138f
C123 outx a_1752_10754# 0.19099f
C124 a_268_9564# outx 0.19118f
C125 a_268_8244# outx 0.07768f
C126 outx a_1168_8244# 0.09565f
C127 a_268_7054# outx 0.19118f
C128 n1 a_1168_n216# 0.72719f
C129 a_268_10754# n1 0.83215f
C130 a_852_8244# n1 0.72719f
C131 a_1168_10754# avdd 0.2488f
C132 a_852_n5106# outx 0.09366f
C133 outx a_1752_n1536# 0.19367f
C134 a_268_n1536# outx 0.07768f
C135 a_852_7054# outx 0.10672f
C136 a_1752_7054# avdd 0.22421f
C137 a_1168_10754# n1 0.83223f
C138 outx a_1752_2164# 0.10351f
C139 a_1168_5864# avdd 0.2488f
C140 a_852_4674# outx 0.09413f
C141 outx a_1168_4674# 0.20936f
C142 avdd a_268_3354# 0.24012f
C143 a_1168_974# outx 0.10658f
C144 a_1752_7054# n1 0.81417f
C145 a_268_2164# outx 0.19118f
C146 avdd a_1168_7054# 0.24107f
C147 a_1168_5864# n1 0.83223f
C148 n1 a_268_3354# 0.81435f
C149 n1 a_1168_7054# 0.727f
C150 a_268_n216# outx 0.19118f
C151 a_1752_n3916# avdd 0.2148f
C152 a_1168_n3916# avdd 0.2488f
C153 outx a_1752_4674# 0.07771f
C154 a_268_974# avdd 0.22384f
C155 a_852_n2726# outx 0.10672f
C156 a_1752_n3916# n1 0.74374f
C157 a_1168_n3916# n1 0.83223f
C158 avdd a_852_5864# 0.2406f
C159 outx a_1752_974# 0.19099f
C160 a_852_13134# avdd 0.24138f
C161 a_852_n3916# outx 0.19515f
C162 a_268_974# n1 0.83215f
C163 a_852_11944# avdd 0.2495f
C164 a_1168_13134# outx 0.09513f
C165 a_852_9564# outx 0.09413f
C166 n1 a_852_5864# 0.74383f
C167 a_852_13134# n1 0.72719f
C168 a_852_11944# n1 0.81425f
C169 a_1168_3354# avdd 0.24966f
C170 a_1168_11944# avdd 0.24107f
C171 a_268_5864# avdd 0.22379f
C172 outx avdd 37.9319f
C173 a_1168_9564# outx 0.20936f
C174 a_268_n5106# outx 0.19118f
C175 a_1168_3354# n1 0.81444f
C176 a_1168_11944# n1 0.727f
C177 a_268_5864# n1 0.83215f
C178 n1 outx 34.8681f
C179 outx a_268_n2726# 0.19118f
C180 a_852_n216# avdd 0.24955f
C181 a_1168_2164# avdd 0.24107f
C182 a_1752_3354# avdd 0.23171f
C183 a_268_11944# avdd 0.21543f
C184 a_1752_n2726# outx 0.10351f
C185 a_852_3354# avdd 0.24138f
C186 a_852_n216# n1 0.81584f
C187 a_852_n1536# avdd 0.24138f
C188 a_1168_2164# n1 0.727f
C189 a_1168_n5106# avdd 0.24138f
C190 a_852_2164# outx 0.10672f
C191 a_1752_3354# n1 0.7271f
C192 outx a_852_10754# 0.19516f
C193 a_268_13134# outx 0.07727f
C194 a_268_11944# n1 0.72692f
C195 outx sub 2.23942f
C196 avdd sub 0.84928f
C197 a_852_n2726# sub 0.42544f
.ends
