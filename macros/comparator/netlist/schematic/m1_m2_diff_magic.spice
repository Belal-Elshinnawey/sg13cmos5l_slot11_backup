** sch_path: /foss/designs/sg13cmos5l_slot3_backup/macros/comparator/schematic/xschem/m1_m2_diff.sch
.subckt m1_m2_diff n1 outx inp inn tail avss
*.PININFO n1:B outx:B inp:B inn:B tail:B avss:B
xM1[15] n1 inp tail avss n1_4
xM1[14] n1 inp tail avss n1_4
xM1[13] n1 inp tail avss n1_4
xM1[12] n1 inp tail avss n1_4
xM1[11] n1 inp tail avss n1_4
xM1[10] n1 inp tail avss n1_4
xM1[9] n1 inp tail avss n1_4
xM1[8] n1 inp tail avss n1_4
xM1[7] n1 inp tail avss n1_4
xM1[6] n1 inp tail avss n1_4
xM1[5] n1 inp tail avss n1_4
xM1[4] n1 inp tail avss n1_4
xM1[3] n1 inp tail avss n1_4
xM1[2] n1 inp tail avss n1_4
xM1[1] n1 inp tail avss n1_4
xM1[0] n1 inp tail avss n1_4
xM2[15] outx inn tail avss n1_4
xM2[14] outx inn tail avss n1_4
xM2[13] outx inn tail avss n1_4
xM2[12] outx inn tail avss n1_4
xM2[11] outx inn tail avss n1_4
xM2[10] outx inn tail avss n1_4
xM2[9] outx inn tail avss n1_4
xM2[8] outx inn tail avss n1_4
xM2[7] outx inn tail avss n1_4
xM2[6] outx inn tail avss n1_4
xM2[5] outx inn tail avss n1_4
xM2[4] outx inn tail avss n1_4
xM2[3] outx inn tail avss n1_4
xM2[2] outx inn tail avss n1_4
xM2[1] outx inn tail avss n1_4
xM2[0] outx inn tail avss n1_4
.ends

* expanding   symbol:  n1_4.sym # of pins=4
** sym_path: /foss/designs/sg13cmos5l_slot3_backup/macros/comparator/schematic/xschem/n1_4.sym
** sch_path: /foss/designs/sg13cmos5l_slot3_backup/macros/comparator/schematic/xschem/n1_4.sch
.subckt n1_4 D G S B
*.PININFO D:B G:B S:B B:B
xp1 D G S B n1_2
xp2 D G S B n1_2
.ends

* expanding   symbol:  n1_2.sym # of pins=4
** sym_path: /foss/designs/sg13cmos5l_slot3_backup/macros/comparator/schematic/xschem/n1_2.sym
** sch_path: /foss/designs/sg13cmos5l_slot3_backup/macros/comparator/schematic/xschem/n1_2.sch
.subckt n1_2 D G S B
*.PININFO G:B D:B S:B B:B
XMbot D G X B sg13_hv_nmos w=2.5e-6 l=1e-6 ng=1 m=1 mm_ok=1
XMtop X G S B sg13_hv_nmos w=2.5e-6 l=1e-6 ng=1 m=1 mm_ok=1
.ends
