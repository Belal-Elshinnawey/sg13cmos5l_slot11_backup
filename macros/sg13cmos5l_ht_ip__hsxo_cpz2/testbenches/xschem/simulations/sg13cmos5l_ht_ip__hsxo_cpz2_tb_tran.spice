** sch_path: /foss/designs/sg13cmos5l_slot3_backup/macros/sg13cmos5l_ht_ip__hsxo_cpz2/testbenches/xschem/sg13cmos5l_ht_ip__hsxo_cpz2_tb_tran.sch
**.subckt sg13cmos5l_ht_ip__hsxo_cpz2_tb_tran
C1 XOUT GND 11p
C2 XIN GND 11p
I1 AVDD net1 1u
V1 AVDD GND 3.3
V2 DVDD GND 1.2
X2 XIN XOUT crystal_model_p_res f=12Meg Cm=20f Rm=15 C0=4p icLm=0m
V3 ENA GND PWL(0 1.2)
V4 STDBY GND PWL(0 0)
x3 XIN XIN_Padres GND AVDD pad_model_simp
x4 XOUT XOUT_Padres GND AVDD pad_model_simp
X5 XOUT_Padres XIN_Padres ENA STDBY DOUT AVDD DVDD GND net1 sg13cmos5l_ht_ip__hsxo_cpz2
**** begin user architecture code

.param temp=27
.control
*save all
save xout dout x1.x1.aout x1.x1.ain xin
+ x1.xinpad x1.xoutpad
tran 1n 20000u uic
remzerovec
write sg13cmos5l_ht_ip__hsxo_cpz2_tb_tran.raw
.endc

.lib cornerMOSlv.lib mos_tt
.lib cornerMOShv.lib mos_tt
.lib cornerRES.lib res_typ
.lib cornerCAP.lib cap_typ
.lib cornerDIO.lib dio_tt

**** end user architecture code
**.ends

* expanding   symbol:  crystal_model_p_res.sym # of pins=2
** sym_path: /foss/designs/sg13cmos5l_slot3_backup/macros/sg13cmos5l_ht_ip__hsxo_cpz2/testbenches/xschem/crystal_model_p_res.sym
** sch_path: /foss/designs/sg13cmos5l_slot3_backup/macros/sg13cmos5l_ht_ip__hsxo_cpz2/testbenches/xschem/crystal_model_p_res.sch
.subckt crystal_model_p_res XIN XOUT  f=12Meg Cm=20f Rm=15 C0=4p icLm=0m
*.iopin XIN
*.iopin XOUT
X1 XIN XOUT crystal_model Lm=(1/Cm+1/C0)/(4*pi^2*f^2) Cm=Cm Rm=Rm C0=C0 icLm=icLm
**** begin user architecture code
.param pi=4*atan(1)
**** end user architecture code
.ends

* expanding   symbol:  pad_model_simp.sym # of pins=4
** sym_path: /foss/designs/sg13cmos5l_slot3_backup/macros/sg13cmos5l_ht_ip__hsxo_cpz2/testbenches/xschem/pad_model_simp.sym
** sch_path: /foss/designs/sg13cmos5l_slot3_backup/macros/sg13cmos5l_ht_ip__hsxo_cpz2/testbenches/xschem/pad_model_simp.sch
.subckt pad_model_simp pad padres iovss iovdd
*.iopin pad
*.iopin padres
*.iopin iovdd
*.iopin iovss
XM2 pad net2 iovdd iovdd sg13_hv_pmos w=133.2u l=0.6u ng=20 m=2 mm_ok=1
XM1 pad net1 iovss iovss sg13_hv_nmos w=88u l=0.6u ng=20 m=1 mm_ok=1
R1 iovdd net2 6768
R2 net1 iovss 1959
R3 pad padres 5869
XD1 iovdd pad iovss diodevdd_2kv
XD2 iovdd pad iovss diodevss_2kv
XD3 iovdd padres iovss diodevdd_2kv
XD4 iovdd padres iovss diodevss_2kv
.ends

* expanding   symbol:  sg13cmos5l_ht_ip__hsxo_cpz2.sym # of pins=9
** sym_path: /foss/designs/sg13cmos5l_slot3_backup/macros/sg13cmos5l_ht_ip__hsxo_cpz2/schematic/xschem/sg13cmos5l_ht_ip__hsxo_cpz2.sym
** sch_path: /foss/designs/sg13cmos5l_slot3_backup/macros/sg13cmos5l_ht_ip__hsxo_cpz2/schematic/xschem/sg13cmos5l_ht_ip__hsxo_cpz2.sch
.subckt sg13cmos5l_ht_ip__hsxo_cpz2 XOUT XIN ENA STDBY DOUT AVDD DVDD VSS IBIAS
*.iopin DVDD
*.iopin VSS
*.iopin AVDD
*.ipin ENA
*.ipin STDBY
*.ipin XIN
*.opin XOUT
*.opin DOUT
*.ipin IBIAS
x1 XOUT SG_AVDD EG_AVDD XIN EG_IBIAS AOUT VSS vittoz_pierce_osc
x2 SG_DVDD AIN DOUT VSS schmitt_trigger_pullmid
x3 DOUT SG_AVDD DVDD EG_IBIAS SG_DVDD AVDD IBIAS EG_AVDD ENA STDBY VSS power_gating
XC3 AOUT AIN cap_cmomf w=30.0e-6 l=75.0e-6 mmin=1 mmax=4 subblock=0 m=1 mm_ok=1
.ends

* expanding   symbol:  crystal_model.sym # of pins=2
** sym_path: /foss/designs/sg13cmos5l_slot3_backup/macros/sg13cmos5l_ht_ip__hsxo_cpz2/testbenches/xschem/crystal_model.sym
** sch_path: /foss/designs/sg13cmos5l_slot3_backup/macros/sg13cmos5l_ht_ip__hsxo_cpz2/testbenches/xschem/crystal_model.sch
.subckt crystal_model XIN XOUT  Lm=8.8m Cm=20f Rm=15 C0=4p icLm=0m
*.iopin XIN
*.iopin XOUT
Cm net1 net2 C=Cm
Lm XIN net1 L=Lm ic=icLm
Rm net2 XOUT R=Rm
C0 XIN XOUT C=C0
.ends

* expanding   symbol:  vittoz_pierce_osc.sym # of pins=7
** sym_path: /foss/designs/sg13cmos5l_slot3_backup/macros/vittoz_pierce_osc/schematic/xschem/vittoz_pierce_osc.sym
** sch_path: /foss/designs/sg13cmos5l_slot3_backup/macros/vittoz_pierce_osc/schematic/xschem/vittoz_pierce_osc.sch
.subckt vittoz_pierce_osc XOUT SG_AVDD EG_AVDD XIN EG_IBIAS AOUT VSS
*.iopin EG_AVDD
*.iopin VSS
*.iopin SG_AVDD
*.ipin XIN
*.ipin EG_IBIAS
*.opin XOUT
*.opin AOUT
Vmeas3 net6 XOUT 0
.save i(vmeas3)
Vmeas4 net7 net1 0
.save i(vmeas4)
Vmeas2 PBIAS net3 0
.save i(vmeas2)
Vmeas5 net8 AOUT 0
.save i(vmeas5)
Vmeas1 EG_IBIAS net4 0
.save i(vmeas1)
XC3 VSS EG_AVDD cap_cmomf w=30.0e-6 l=75.0e-6 mmin=1 mmax=4 subblock=0 m=1 mm_ok=1
XC4 VSS SG_AVDD cap_cmomf w=30.0e-6 l=75.0e-6 mmin=1 mmax=4 subblock=0 m=1 mm_ok=1
XR1 net1 net2 VSS rhigh w=0.5e-6 l=1.342e-5 m=1 b=0 mm_ok=1
XR2 XOUT XIN VSS rhigh w=0.5e-6 l=5.305e-6 m=1 b=0 mm_ok=1
XC2 XIN net2 cap_cmomf w=30.0e-6 l=75.0e-6 mmin=1 mmax=4 subblock=0 m=1 mm_ok=1
XC7 net2 VSS cap_cmomf w=30.0e-6 l=75.0e-6 mmin=1 mmax=4 subblock=0 m=1 mm_ok=1
XC1 VSS net1 cap_cmomf w=4.0e-6 l=4.0e-6 mmin=1 mmax=1 subblock=0 m=1 mm_ok=1
XC8 VSS AOUT cap_cmomf w=4.0e-6 l=4.0e-6 mmin=1 mmax=1 subblock=0 m=1 mm_ok=1
XM11 PBIAS PBIAS EG_AVDD EG_AVDD sg13_hv_pmos w=102.4u l=0.4u ng=16 m=1 mm_ok=1
XM10 net7 PBIAS EG_AVDD EG_AVDD sg13_hv_pmos w=102.4u l=0.4u ng=16 m=1 mm_ok=1
XM9 net6 PBIAS EG_AVDD EG_AVDD sg13_hv_pmos w=819.2u l=0.4u ng=128 m=1 mm_ok=1
XM14 net3 net2 net5 VSS sg13_hv_nmos w=921.6u l=0.45u ng=128 m=1 mm_ok=1
XM12 net1 net2 VSS VSS sg13_hv_nmos w=115.2u l=0.45u ng=16 m=1 mm_ok=1
XM13 XOUT XIN VSS VSS sg13_hv_nmos w=28.8u l=0.45u ng=32 m=1 mm_ok=1
XM15 net5 net4 VSS VSS sg13_hv_nmos w=115.2u l=0.45u ng=16 m=1 mm_ok=1
XM16 net4 net4 VSS VSS sg13_hv_nmos w=7.2u l=0.45u ng=4 m=1 mm_ok=1
XM18 net8 PBIAS SG_AVDD SG_AVDD sg13_hv_pmos w=102.4u l=0.4u ng=16 m=1 mm_ok=1
XM17 AOUT XIN VSS VSS sg13_hv_nmos w=3.6u l=0.45u ng=4 m=1 mm_ok=1
.ends

* expanding   symbol:  schmitt_trigger_pullmid.sym # of pins=4
** sym_path: /foss/designs/sg13cmos5l_slot3_backup/macros/schmitt_trigger_pullmid/schematic/xschem/schmitt_trigger_pullmid.sym
** sch_path: /foss/designs/sg13cmos5l_slot3_backup/macros/schmitt_trigger_pullmid/schematic/xschem/schmitt_trigger_pullmid.sch
.subckt schmitt_trigger_pullmid SG_DVDD AIN DOUT VSS
*.iopin SG_DVDD
*.iopin VSS
*.ipin AIN
*.opin DOUT
Vmeas6 AIN net1 0
.save i(vmeas6)
XR1 SG_DVDD MID VSS rhigh w=0.5e-6 l=3.412e-05 m=1 b=0 mm_ok=1
XR2 MID VSS VSS rhigh w=0.5e-6 l=3.412e-05 m=1 b=0 mm_ok=1
XR3 net1 MID VSS rhigh w=0.5e-6 l=2.7172e-04 m=1 b=0 mm_ok=1
XC4 VSS SG_DVDD cap_cmomf w=30.0e-6 l=75.0e-6 mmin=1 mmax=4 subblock=0 m=1 mm_ok=1
XM4 DOUT net1 DLT VSS sg13_lv_nmos w=1u l=0.3u ng=1 m=1 mm_ok=1
XM5 DHT net1 SG_DVDD SG_DVDD sg13_lv_pmos w=1u l=0.3u ng=1 m=1 mm_ok=1
XM3 DOUT net1 DHT SG_DVDD sg13_lv_pmos w=1u l=0.3u ng=1 m=1 mm_ok=1
XM7 VSS DOUT DHT SG_DVDD sg13_lv_pmos w=1u l=0.3u ng=1 m=1 mm_ok=1
XM6 DLT net1 VSS VSS sg13_lv_nmos w=1u l=0.3u ng=1 m=1 mm_ok=1
XM8 SG_DVDD DOUT DLT VSS sg13_lv_nmos w=1u l=0.3u ng=1 m=1 mm_ok=1
.ends

* expanding   symbol:  power_gating.sym # of pins=11
** sym_path: /foss/designs/sg13cmos5l_slot3_backup/macros/power_gating/schematic/xschem/power_gating.sym
** sch_path: /foss/designs/sg13cmos5l_slot3_backup/macros/power_gating/schematic/xschem/power_gating.sch
.subckt power_gating DOUT SG_AVDD DVDD EG_IBIAS SG_DVDD AVDD IBIAS EG_AVDD ENA STDBY VSS
*.iopin DVDD
*.iopin VSS
*.iopin AVDD
*.ipin ENA
*.ipin STDBY
*.opin DOUT
*.ipin IBIAS
*.iopin EG_AVDD
*.iopin SG_AVDD
*.iopin SG_DVDD
*.opin EG_IBIAS
x3 AVDD ENA_B DVDD ENA ENA_H VSS ENA_BH level_shifter
x4 AVDD STDBY_B DVDD STDBY STDBY_H VSS STDBY_BH level_shifter
XC3 VSS AVDD cap_cmomf w=30.0e-6 l=75.0e-6 mmin=1 mmax=4 subblock=0 m=1 mm_ok=1
XC4 VSS DVDD cap_cmomf w=30.0e-6 l=75.0e-6 mmin=1 mmax=4 subblock=0 m=1 mm_ok=1
XM2 EG_IBIAS ENA_BH net1 AVDD sg13_hv_pmos w=25.6u l=0.4u ng=8 m=1 mm_ok=1
XM1 SG_AVDD STDBY_H AVDD AVDD sg13_hv_pmos w=25.6u l=0.4u ng=8 m=1 mm_ok=1
XM25 EG_AVDD ENA_BH AVDD AVDD sg13_hv_pmos w=25.6u l=0.4u ng=8 m=1 mm_ok=1
XM9 SG_AVDD STDBY_H VSS VSS sg13_hv_nmos w=28.8u l=0.45u ng=8 m=1 mm_ok=1
XM21 EG_AVDD ENA_BH VSS VSS sg13_hv_nmos w=28.8u l=0.45u ng=8 m=1 mm_ok=1
XM27 SG_DVDD STDBY DVDD DVDD sg13_lv_pmos w=27.76u l=0.13u ng=8 m=1 mm_ok=1
XM18 SG_DVDD STDBY VSS VSS sg13_lv_nmos w=27.76u l=0.13u ng=8 m=1 mm_ok=1
XM4 DOUT STDBY VSS VSS sg13_lv_nmos w=27.76u l=0.13u ng=8 m=1 mm_ok=1
Vmeas1 IBIAS net1 0
.save i(vmeas1)
Vmeas2 IBIAS net2 0
.save i(vmeas2)
XM3 VSS ENA_H net2 AVDD sg13_hv_pmos w=25.6u l=0.4u ng=8 m=1 mm_ok=1
.ends

* expanding   symbol:  level_shifter.sym # of pins=7
** sym_path: /foss/designs/sg13cmos5l_slot3_backup/macros/level_shifter/schematic/xschem/level_shifter.sym
** sch_path: /foss/designs/sg13cmos5l_slot3_backup/macros/level_shifter/schematic/xschem/level_shifter.sch
.subckt level_shifter AVDD LO_B DVDD LO HI VSS HI_B
*.iopin DVDD
*.iopin VSS
*.iopin AVDD
*.ipin LO
*.opin LO_B
*.opin HI
*.opin HI_B
XM1 IM_B IM AVDD AVDD sg13_hv_pmos w=0.8u l=0.4u ng=1 m=1 mm_ok=1
XM2 IM_B LO_BB VSS VSS sg13_hv_nmos w=0.9u l=0.45u ng=1 m=1 mm_ok=1
XM3 IM IM_B AVDD AVDD sg13_hv_pmos w=0.8u l=0.4u ng=1 m=1 mm_ok=1
XM4 IM LO_B VSS VSS sg13_hv_nmos w=0.9u l=0.45u ng=1 m=1 mm_ok=1
XM5 LO_B LO DVDD DVDD sg13_lv_pmos w=0.87u l=0.13u ng=1 m=1 mm_ok=1
XM6 LO_B LO VSS VSS sg13_lv_nmos w=0.87u l=0.13u ng=1 m=1 mm_ok=1
XM7 LO_BB LO_B DVDD DVDD sg13_lv_pmos w=0.87u l=0.13u ng=1 m=1 mm_ok=1
XM8 LO_BB LO_B VSS VSS sg13_lv_nmos w=0.87u l=0.13u ng=1 m=1 mm_ok=1
XM9 HI IM_B AVDD AVDD sg13_hv_pmos w=0.8u l=0.4u ng=1 m=1 mm_ok=1
XM10 HI IM_B VSS VSS sg13_hv_nmos w=0.9u l=0.45u ng=1 m=1 mm_ok=1
XM11 HI_B HI AVDD AVDD sg13_hv_pmos w=0.8u l=0.4u ng=1 m=1 mm_ok=1
XM12 HI_B HI VSS VSS sg13_hv_nmos w=0.9u l=0.45u ng=1 m=1 mm_ok=1
.ends

.end
