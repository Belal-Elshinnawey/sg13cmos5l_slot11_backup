* Extracted by KLayout with SG13CMOS5L LVS runset on : 28/10/2026 17:05

.SUBCKT level_shifter AVDD DVDD HI HI_B IM IM_B LO LO_B LO_BB VSS
M$1 VSS LO_B IM VSS sg13_hv_nmos L=0.45u W=0.9u AS=0.306p AD=0.306p PS=2.48u
+ PD=2.48u rfmode=0
M$2 VSS HI HI_B VSS sg13_hv_nmos L=0.45u W=0.9u AS=0.306p AD=0.306p PS=2.48u
+ PD=2.48u rfmode=0
M$3 VSS IM_B HI VSS sg13_hv_nmos L=0.45u W=0.9u AS=0.306p AD=0.306p PS=2.48u
+ PD=2.48u rfmode=0
M$4 VSS LO_BB IM_B VSS sg13_hv_nmos L=0.45u W=0.9u AS=0.306p AD=0.306p PS=2.48u
+ PD=2.48u rfmode=0
M$5 AVDD HI HI_B AVDD sg13_hv_pmos L=0.4u W=0.8u AS=0.272p AD=0.272p PS=2.28u
+ PD=2.28u rfmode=0
M$6 AVDD IM_B HI AVDD sg13_hv_pmos L=0.4u W=0.8u AS=0.272p AD=0.272p PS=2.28u
+ PD=2.28u rfmode=0
M$7 AVDD IM IM_B AVDD sg13_hv_pmos L=0.4u W=0.8u AS=0.272p AD=0.272p PS=2.28u
+ PD=2.28u rfmode=0
M$8 AVDD IM_B IM AVDD sg13_hv_pmos L=0.4u W=0.8u AS=0.272p AD=0.272p PS=2.28u
+ PD=2.28u rfmode=0
M$9 VSS LO LO_B VSS sg13_lv_nmos L=0.13u W=0.87u AS=0.2958p AD=0.2958p PS=2.42u
+ PD=2.42u rfmode=0
M$10 VSS LO_B LO_BB VSS sg13_lv_nmos L=0.13u W=0.87u AS=0.2958p AD=0.2958p
+ PS=2.42u PD=2.42u rfmode=0
M$11 DVDD LO_B LO_BB DVDD sg13_lv_pmos L=0.13u W=0.87u AS=0.2958p AD=0.2958p
+ PS=2.42u PD=2.42u rfmode=0
M$12 DVDD LO LO_B DVDD sg13_lv_pmos L=0.13u W=0.87u AS=0.2958p AD=0.2958p
+ PS=2.42u PD=2.42u rfmode=0
.ENDS level_shifter
