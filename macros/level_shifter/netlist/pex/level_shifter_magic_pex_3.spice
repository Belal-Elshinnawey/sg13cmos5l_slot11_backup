* PEX produced on Wed Oct 28 05:05:35 PM CET 2026 using /foss/tools/sak/sak-pex.sh with m=3 and s=1 (extresist threshold=10000 mOhm, minres=1000 mOhm, mindelay=1 ps)
* NGSPICE file created from level_shifter_pex.ext - technology: ihp-sg13cmos5l

.subckt level_shifter_pex AVDD LO_B DVDD LO HI VSS HI_B
X0 LO_B LO VSS.t11 VSS.t10 sg13_lv_nmos ad=0.2958p pd=2.42u as=0.2958p ps=2.42u w=0.87u l=0.13u
X1 IM LO_B VSS.t5 VSS.t4 sg13_hv_nmos ad=0.306p pd=2.48u as=0.306p ps=2.48u w=0.9u l=0.45u
X2 HI_B HI AVDD AVDD sg13_hv_pmos ad=0.272p pd=2.28u as=0.272p ps=2.28u w=0.8u l=0.4u
X3 IM_B IM AVDD AVDD sg13_hv_pmos ad=0.272p pd=2.28u as=0.272p ps=2.28u w=0.8u l=0.4u
X4 HI IM_B AVDD AVDD sg13_hv_pmos ad=0.272p pd=2.28u as=0.272p ps=2.28u w=0.8u l=0.4u
X5 LO_BB LO_B DVDD DVDD sg13_lv_pmos ad=0.2958p pd=2.42u as=0.2958p ps=2.42u w=0.87u l=0.13u
X6 LO_BB LO_B VSS.t3 VSS.t2 sg13_lv_nmos ad=0.2958p pd=2.42u as=0.2958p ps=2.42u w=0.87u l=0.13u
X7 IM IM_B AVDD AVDD sg13_hv_pmos ad=0.272p pd=2.28u as=0.272p ps=2.28u w=0.8u l=0.4u
X8 HI_B HI VSS.t1 VSS.t0 sg13_hv_nmos ad=0.306p pd=2.48u as=0.306p ps=2.48u w=0.9u l=0.45u
X9 LO_B LO DVDD DVDD sg13_lv_pmos ad=0.2958p pd=2.42u as=0.2958p ps=2.42u w=0.87u l=0.13u
X10 IM_B LO_BB VSS.t9 VSS.t8 sg13_hv_nmos ad=0.306p pd=2.48u as=0.306p ps=2.48u w=0.9u l=0.45u
X11 HI IM_B VSS.t7 VSS.t6 sg13_hv_nmos ad=0.306p pd=2.48u as=0.306p ps=2.48u w=0.9u l=0.45u
R0 VSS.n5 VSS.n1 1687.33
R1 VSS.n8 VSS.n6 476.318
R2 VSS.n7 VSS.n4 476.32
R3 VSS.t4 VSS.n5 8.07578
R4 VSS.t8 VSS.n7 8.07483
R5 VSS.n1 VSS.n0 0.00363159
R6 VSS.n1 VSS.t2 82.1211
R7 VSS.n9 VSS.t6 8.0733
R8 VSS.n9 VSS.n8 0.00166992
R9 VSS.t10 VSS.n0 476.317
R10 VSS.n3 VSS.n45 0.64381
R11 VSS.n0 VSS.n3 4.10865
R12 VSS.n4 VSS.n5 0.00108593
R13 VSS.n6 VSS.n7 0.0010859
R14 VSS.n0 VSS.n2 4.14206
R15 VSS.n16 VSS.n15 4.20617
R16 VSS.n44 VSS.n0 4.20617
R17 VSS.n0 VSS.n43 4.20617
R18 VSS.n4 VSS.t5 4.14188
R19 VSS.t9 VSS.n6 4.14188
R20 VSS.t7 VSS.n8 4.14188
R21 VSS.t1 VSS.t0 4.14188
R22 VSS.n16 VSS.n12 4.10865
R23 VSS.n19 VSS.n4 4.10865
R24 VSS.n20 VSS.n6 4.10865
R25 VSS.n21 VSS.n8 4.10865
R26 VSS.n28 VSS.n4 3.3422
R27 VSS.n29 VSS.n6 3.3422
R28 VSS.n30 VSS.n8 3.3422
R29 VSS.n40 VSS.n4 3.34184
R30 VSS.n37 VSS.n6 3.34184
R31 VSS.n34 VSS.n8 3.34184
R32 VSS.n13 VSS.n16 1.92401
R33 VSS VSS.n46 1.0565
R34 VSS.n31 VSS.n23 0.981846
R35 VSS.n32 VSS.n31 0.98169
R36 VSS.n31 VSS.t0 0.865785
R37 VSS.t11 VSS.n13 0.817773
R38 VSS.n26 VSS.n19 0.654122
R39 VSS.n24 VSS.n20 0.654122
R40 VSS.n39 VSS.n19 0.654122
R41 VSS.n36 VSS.n20 0.654122
R42 VSS.n22 VSS.n21 0.654122
R43 VSS.n33 VSS.n21 0.654122
R44 VSS.n14 VSS.n12 0.64381
R45 VSS.n17 VSS.n12 0.64381
R46 VSS.n17 VSS.n13 0.552483
R47 VSS.n41 VSS.t5 0.500254
R48 VSS.n38 VSS.t9 0.500254
R49 VSS.n35 VSS.t7 0.500254
R50 VSS.n32 VSS.t1 0.500254
R51 VSS.n27 VSS.t9 0.500254
R52 VSS.n25 VSS.t7 0.500254
R53 VSS.n23 VSS.t1 0.500254
R54 VSS.t5 VSS.n10 0.500254
R55 VSS.n42 VSS.n3 0.64381
R56 VSS.t3 VSS.n11 0.405772
R57 VSS.n42 VSS.n41 0.401487
R58 VSS.n46 VSS.n10 0.3844
R59 VSS.n2 VSS.t3 0.0875159
R60 VSS.n28 VSS.n10 0.263268
R61 VSS.n29 VSS.n27 0.263268
R62 VSS.n30 VSS.n25 0.263268
R63 VSS.n41 VSS.n40 0.262646
R64 VSS.n38 VSS.n37 0.262646
R65 VSS.n35 VSS.n34 0.262646
R66 VSS.n40 VSS.n39 0.261552
R67 VSS.n37 VSS.n36 0.261552
R68 VSS.n34 VSS.n33 0.261552
R69 VSS.n26 VSS.n28 0.260944
R70 VSS.n24 VSS.n29 0.260944
R71 VSS.n22 VSS.n30 0.260944
R72 VSS.n18 VSS.n2 0.492011
R73 VSS.n15 VSS.t11 0.221603
R74 VSS.n44 VSS.n11 0.221603
R75 VSS.n43 VSS.n18 0.221603
R76 VSS.n15 VSS.n14 0.219774
R77 VSS.n45 VSS.n44 0.219774
R78 VSS.n43 VSS.n42 0.219774
R79 VSS.n39 VSS.n38 0.1116
R80 VSS.n36 VSS.n35 0.1116
R81 VSS.n33 VSS.n32 0.1116
R82 VSS.n27 VSS.n26 0.1116
R83 VSS.n25 VSS.n24 0.1116
R84 VSS.n23 VSS.n22 0.1116
R85 VSS.n14 VSS.n11 0.108364
R86 VSS.n18 VSS.n17 0.108364
R87 VSS.t11 VSS 0.0229272
R88 VSS.n46 VSS.n45 0.0175874
R89 VSS.n16 VSS.t10 0.00227852
R90 VSS.t0 VSS.n9 476.32
C0 LO_BB IM 0.13907f
C1 DVDD LO 1.25422f
C2 IM AVDD 1.6282f
C3 IM_B HI 0.5927f
C4 LO_BB AVDD 0.1074f
C5 LO_BB DVDD 0.22975f
C6 DVDD AVDD 0.07233f
C7 HI AVDD 1.60962f
C8 IM_B LO_B 0.04621f
C9 HI_B AVDD 0.16905f
C10 LO_B LO 0.66225f
C11 IM LO_B 0.23952f
C12 IM_B IM 0.66406f
C13 HI HI_B 0.52864f
C14 LO_BB LO_B 0.82331f
C15 LO_BB IM_B 0.45949f
C16 LO_B AVDD 0.04713f
C17 IM_B AVDD 2.95654f
C18 DVDD LO_B 1.65528f
C19 IM_B DVDD 0.01143f
C20 HI_B VSS 2.09842f
C21 HI VSS 0.50515f
C22 AVDD VSS 4.57694f
C23 DVDD VSS 0.49074f
C24 VSS.t5 VSS 2.03198f
C25 VSS.t11 VSS 0.72657f
C26 VSS.t1 VSS 0.80595f
C27 VSS.t7 VSS 0.50515f
C28 VSS.t9 VSS 1.01031f
.ends
