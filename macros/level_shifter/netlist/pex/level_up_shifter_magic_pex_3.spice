* PEX produced on Wed Nov  4 01:46:11 PM CET 2026 using /foss/tools/sak/sak-pex.sh with m=3 and s=1 (extresist threshold=10000 mOhm, minres=1000 mOhm, mindelay=1 ps)
* NGSPICE file created from level_up_shifter_pex.ext - technology: ihp-sg13cmos5l

.subckt level_up_shifter_pex VDD2 A B VSS VDD1
X0 VDD1 GROUP1_0.G GROUP1_0.pmos_priv1_0.D VDD1 sg13_lv_pmos ad=0.34p pd=2.68u as=0.34p ps=2.68u w=1u l=0.13u
X1 GROUP1_0.G GROUP1_0.G GROUP1_0.G VDD1 sg13_lv_pmos ad=0.34p pd=2.68u as=22.6164p ps=0.12324m w=1u l=0.13u
X2 VSS.t4 GROUP1_0.G GROUP1_0.pmos_priv1_0.D VSS.t3 sg13_lv_nmos ad=0.34p pd=2.68u as=0.34p ps=2.68u w=1u l=0.13u
X3 GROUP1_0.G GROUP1_0.G GROUP1_0.G VSS.t7 sg13_lv_nmos ad=0.34p pd=2.68u as=0 ps=0 w=1u l=0.13u
X4 B B B VDD2 sg13_hv_pmos ad=1.02p pd=6.68u as=7.2396p ps=29.16u w=3u l=0.5u
X5 VSS.t24 VSS.t21 VSS.t23 VSS.t22 sg13_lv_nmos ad=0.34p pd=2.68u as=0 ps=0 w=1u l=0.13u
X6 VDD1 VDD1 VDD1 VDD1 sg13_lv_pmos ad=0.34p pd=2.68u as=11.0108p ps=69.8u w=1u l=0.13u
X7 VSS.t16 VSS.t13 VSS.t15 VSS.t14 sg13_hv_nmos ad=0.34p pd=2.68u as=0 ps=0 w=1u l=0.5u
X8 GROUP1_0.pmos_priv1_0.D GROUP1_0.pmos_priv1_0.D GROUP1_0.pmos_priv1_0.D VSS.t10 sg13_lv_nmos ad=0.34p pd=2.68u as=15.3972p ps=73.32u w=1u l=0.13u
X9 VDD2 GROUP3_0.G B VDD2 sg13_hv_pmos ad=1.02p pd=6.68u as=1.02p ps=6.68u w=3u l=0.5u
X10 VSS.t6 GROUP1_0.G nmosHV_priv1_0.D VSS.t5 sg13_hv_nmos ad=3.4p pd=20.68u as=3.4p ps=20.68u w=10u l=0.5u
X11 VDD2 GROUP3_0.G nmosHV_priv1_0.D VDD2 sg13_hv_pmos ad=0.34p pd=2.68u as=0.34p ps=2.68u w=1u l=0.5u
X12 VDD1 A GROUP1_0.G VDD1 sg13_lv_pmos ad=0.34p pd=2.68u as=0.34p ps=2.68u w=1u l=0.13u
X13 GROUP3_0.G nmosHV_priv1_0.D VDD2 VDD2 sg13_hv_pmos ad=0.34p pd=2.68u as=0.34p ps=2.68u w=1u l=0.5u
X14 B B B VSS.t2 sg13_hv_nmos ad=0.34p pd=2.68u as=0 ps=0 w=1u l=0.5u
X15 VSS.t1 A GROUP1_0.G VSS.t0 sg13_lv_nmos ad=0.34p pd=2.68u as=0.34p ps=2.68u w=1u l=0.13u
X16 VDD2 VDD2 VDD2 VDD2 sg13_hv_pmos ad=1.02p pd=6.68u as=19.698p ps=0.12086m w=3u l=0.5u
X17 VSS.t20 VSS.t17 VSS.t19 VSS.t18 sg13_lv_nmos ad=0.34p pd=2.68u as=0 ps=0 w=1u l=0.13u
X18 VDD1 VDD1 VDD1 VDD1 sg13_lv_pmos ad=0.34p pd=2.68u as=0 ps=0 w=1u l=0.13u
X19 GROUP3_0.G GROUP1_0.pmos_priv1_0.D VSS.t9 VSS.t8 sg13_hv_nmos ad=3.4p pd=20.68u as=3.4p ps=20.68u w=10u l=0.5u
X20 B GROUP3_0.G VSS.t12 VSS.t11 sg13_hv_nmos ad=0.34p pd=2.68u as=0.34p ps=2.68u w=1u l=0.5u
X21 GROUP1_0.pmos_priv1_0.D GROUP1_0.pmos_priv1_0.D GROUP1_0.pmos_priv1_0.D VDD1 sg13_lv_pmos ad=0.34p pd=2.68u as=0 ps=0 w=1u l=0.13u
R0 VSS.n4 VSS.n79 103.338
R1 VSS.n78 VSS.n46 95.6065
R2 VSS.n24 VSS.n45 95.6065
R3 VSS.n26 VSS.n48 95.6065
R4 VSS.t3 VSS.n44 95.6065
R5 VSS.n23 VSS.n43 95.6065
R6 VSS.n28 VSS.n50 95.6065
R7 VSS.n29 VSS.n51 95.6065
R8 VSS.n27 VSS.t14 82.5693
R9 VSS.n22 VSS.t18 79.6722
R10 VSS.n21 VSS.t11 78.2236
R11 VSS.t10 VSS.n47 76.775
R12 VSS.n30 VSS.n52 69.5321
R13 VSS.n20 VSS.n40 69.5321
R14 VSS.n31 VSS.n53 69.5321
R15 VSS.n19 VSS.n39 69.5321
R16 VSS.n33 VSS.n55 69.5321
R17 VSS.n17 VSS.n37 69.5321
R18 VSS.n77 VSS.n36 69.5321
R19 VSS.n12 VSS.t8 27.0042
R20 VSS.n3 VSS.n8 56.2017
R21 VSS.n18 VSS.t0 52.1492
R22 VSS.n9 VSS.t5 31.4331
R23 VSS.n12 VSS.n4 53.1842
R24 VSS.t11 VSS.n41 49.2521
R25 VSS.n32 VSS.t2 42.0092
R26 VSS.t22 VSS.n56 36.2149
R27 VSS.n34 VSS.t22 33.3177
R28 VSS.n21 VSS.n52 28.972
R29 VSS.n30 VSS.n40 28.972
R30 VSS.n31 VSS.n39 28.972
R31 VSS.n19 VSS.n54 28.972
R32 VSS.n32 VSS.n38 28.972
R33 VSS.n18 VSS.n55 28.972
R34 VSS.n33 VSS.n37 28.972
R35 VSS.n17 VSS.n56 28.972
R36 VSS.n34 VSS.n36 28.972
R37 VSS.n20 VSS.t7 27.5234
R38 VSS.t2 VSS.n54 27.5234
R39 VSS.n75 VSS.t1 27.0005
R40 VSS.n62 VSS.t4 27.0005
R41 VSS.n15 VSS.t12 27.0005
R42 VSS.n25 VSS.t10 18.832
R43 VSS.t0 VSS.n38 17.3834
R44 VSS.n7 VSS.n34 17.0005
R45 VSS.n7 VSS.n17 8.49925
R46 VSS.n7 VSS.n33 17.0005
R47 VSS.n7 VSS.n6 0.00129643
R48 VSS.n7 VSS.n32 17.0005
R49 VSS.n7 VSS.n19 17.0005
R50 VSS.n7 VSS.n31 17.0005
R51 VSS.n7 VSS.n20 17.0005
R52 VSS.n7 VSS.n30 17.0005
R53 VSS.n6 VSS.n5 0.00375652
R54 VSS.n7 VSS.n29 17.0005
R55 VSS.n7 VSS.n28 17.0005
R56 VSS.n5 VSS.n23 8.49951
R57 VSS.n7 VSS.n27 17.0005
R58 VSS.n7 VSS.t3 17.0005
R59 VSS.n7 VSS.n26 17.0005
R60 VSS.n5 VSS.n24 8.49937
R61 VSS.n7 VSS.n25 17.0005
R62 VSS.n78 VSS.n7 17.0005
R63 VSS.n5 VSS.n34 17.0005
R64 VSS.n5 VSS.n33 17.0005
R65 VSS.n6 VSS.n18 8.50244
R66 VSS.n5 VSS.n32 17.0005
R67 VSS.n5 VSS.n19 17.0005
R68 VSS.n5 VSS.n31 17.0005
R69 VSS.n5 VSS.n20 17.0005
R70 VSS.n5 VSS.n30 17.0005
R71 VSS.n5 VSS.n21 8.49826
R72 VSS.n5 VSS.n29 17.0005
R73 VSS.n5 VSS.n22 8.49799
R74 VSS.n5 VSS.n28 17.0005
R75 VSS.n5 VSS.n27 17.0005
R76 VSS.n5 VSS.t3 17.0005
R77 VSS.n5 VSS.n26 17.0005
R78 VSS.n5 VSS.n25 17.0005
R79 VSS.n5 VSS.n78 17.0005
R80 VSS.n77 VSS.n3 36.8351
R81 VSS.n2 VSS.n36 8.49931
R82 VSS.n2 VSS.n56 8.50158
R83 VSS.n2 VSS.n37 8.49903
R84 VSS.n2 VSS.n55 8.4994
R85 VSS.n2 VSS.n38 8.49915
R86 VSS.n2 VSS.n54 8.4989
R87 VSS.n2 VSS.n39 8.49865
R88 VSS.n2 VSS.n53 8.4984
R89 VSS.n2 VSS.n40 8.49815
R90 VSS.n2 VSS.n52 8.4979
R91 VSS.n2 VSS.n41 8.49765
R92 VSS.n2 VSS.n51 8.49741
R93 VSS.n2 VSS.n42 8.49716
R94 VSS.n2 VSS.n50 8.49691
R95 VSS.n2 VSS.n43 8.49666
R96 VSS.n2 VSS.n49 8.49641
R97 VSS.n2 VSS.n44 8.49617
R98 VSS.n2 VSS.n48 8.49592
R99 VSS.n2 VSS.n45 8.49567
R100 VSS.n2 VSS.n47 8.5
R101 VSS.n2 VSS.n46 8.49543
R102 VSS.n73 VSS.t24 17.0005
R103 VSS.t23 VSS.n70 17.0005
R104 VSS.n60 VSS.t20 17.0005
R105 VSS.t19 VSS.n57 17.0005
R106 VSS.t16 VSS.n63 17.0005
R107 VSS.n66 VSS.t15 17.0005
R108 VSS.n8 VSS.n9 0.00104167
R109 VSS.t18 VSS.n42 15.9348
R110 VSS.t21 VSS.n73 15.0793
R111 VSS.t17 VSS.n60 15.0793
R112 VSS.t13 VSS.n66 15.0513
R113 VSS.n74 VSS.t21 15.0005
R114 VSS.n61 VSS.t17 15.0005
R115 VSS.n67 VSS.t13 15.0005
R116 VSS.t14 VSS.n49 13.0377
R117 VSS.n16 VSS.n14 9.4995
R118 VSS.n16 VSS.n69 9.0005
R119 VSS.n16 VSS.n68 9.0005
R120 VSS.n79 VSS.n7 1.3076
R121 VSS.n65 VSS.t16 8.49176
R122 VSS.n64 VSS.t15 8.49176
R123 VSS.t24 VSS.n72 8.48666
R124 VSS.n71 VSS.t23 8.48666
R125 VSS.t20 VSS.n59 8.48666
R126 VSS.n58 VSS.t19 8.48666
R127 VSS.n10 VSS.n13 2.1343
R128 VSS.n12 VSS.n11 0.00448912
R129 VSS.n77 VSS.n5 1.30785
R130 VSS.n10 VSS.n5 0.10534
R131 VSS.n79 VSS.n46 2.89765
R132 VSS.n78 VSS.n47 2.89765
R133 VSS.n25 VSS.n45 2.89765
R134 VSS.n24 VSS.n48 2.89765
R135 VSS.n26 VSS.n44 2.89765
R136 VSS.t3 VSS.n49 2.89765
R137 VSS.n27 VSS.n43 2.89765
R138 VSS.n23 VSS.n50 2.89765
R139 VSS.n28 VSS.n42 2.89765
R140 VSS.n22 VSS.n51 2.89765
R141 VSS.n29 VSS.n41 2.89765
R142 VSS.n2 VSS.n3 0.00981736
R143 VSS.n8 VSS.t6 9.72962
R144 VSS.t7 VSS.n53 1.44908
R145 VSS.n7 VSS.n35 1.08305
R146 VSS.n7 VSS.n13 0.978103
R147 VSS.n2 VSS.n4 0.103726
R148 VSS.n9 VSS.n11 37917.2
R149 VSS.n2 VSS.n0 0.126187
R150 VSS.n14 VSS.n1 1.38715
R151 VSS.n2 VSS.n1 0.125876
R152 VSS.n69 VSS.n1 1.38802
R153 VSS.n69 VSS.n0 1.36663
R154 VSS.n68 VSS.n13 0.712632
R155 VSS.t12 VSS.n67 0.653499
R156 VSS.n68 VSS.n35 0.703883
R157 VSS.n10 VSS.n35 2.075
R158 VSS.t1 VSS.n74 0.403213
R159 VSS.t4 VSS.n61 0.403213
R160 VSS.n14 VSS.n0 1.3714
R161 VSS.n76 VSS 0.24338
R162 VSS VSS.n80 0.141783
R163 VSS.n80 VSS.t9 0.09675
R164 VSS.t6 VSS.n76 0.08465
R165 VSS.n74 VSS.n70 0.079306
R166 VSS.n61 VSS.n57 0.079306
R167 VSS.n72 VSS.n71 0.0588657
R168 VSS.n59 VSS.n58 0.0588657
R169 VSS.n67 VSS.n63 0.0512692
R170 VSS.n75 VSS.n16 0.0500481
R171 VSS.t9 VSS 0.04571
R172 VSS.n65 VSS.n64 0.038479
R173 VSS.n72 VSS.n70 0.0296829
R174 VSS.n73 VSS.n71 0.0296829
R175 VSS.n59 VSS.n57 0.0296829
R176 VSS.n60 VSS.n58 0.0296829
R177 VSS.n15 VSS.n62 0.0265375
R178 VSS.n66 VSS.n65 0.0194895
R179 VSS.n64 VSS.n63 0.0194895
R180 VSS.n16 VSS.n15 0.0130243
R181 VSS.n80 VSS.n62 0.00709176
R182 VSS.n76 VSS.n75 0.00709176
R183 VSS.t9 VSS.n11 9.72566
C0 VDD2 B 0.79102f
C1 a_634_n1899# GROUP1_0.G 0.01716f
C2 GROUP1_0.G VDD1 2.60892f
C3 A a_1219_n1899# 0.01601f
C4 a_417_n1899# GROUP1_0.pmos_priv1_0.D 0.04581f
C5 B a_1051_1130# 0.01838f
C6 GROUP1_0.pmos_priv1_0.D a_417_n821# 0.04647f
C7 VDD2 a_1051_1130# 0.50196f
C8 A VDD1 1.82136f
C9 B GROUP1_0.G 0.03837f
C10 VDD2 GROUP1_0.G 0.19297f
C11 B GROUP3_0.G 2.08573f
C12 VDD2 GROUP3_0.G 5.8152f
C13 a_417_n1899# VDD1 0.07557f
C14 a_634_n821# GROUP1_0.G 0.01732f
C15 VDD2 nmosHV_priv1_0.D 1.93295f
C16 a_1436_n1899# VDD1 0.11971f
C17 B a_1048_160# 0.09758f
C18 a_1051_1130# GROUP3_0.G 0.04073f
C19 GROUP1_0.G GROUP3_0.G 0.03549f
C20 GROUP1_0.pmos_priv1_0.D VDD1 0.48885f
C21 A GROUP1_0.G 1.6402f
C22 GROUP1_0.G nmosHV_priv1_0.D 0.8371f
C23 a_1219_n1899# VDD1 0.07582f
C24 B a_686_1130# 0.18449f
C25 GROUP3_0.G nmosHV_priv1_0.D 0.84153f
C26 VDD2 a_686_1130# 0.3208f
C27 B GROUP1_0.pmos_priv1_0.D 0.01364f
C28 a_634_n1899# VDD1 0.11989f
C29 VDD2 GROUP1_0.pmos_priv1_0.D 0.15312f
C30 GROUP3_0.G a_1048_160# 0.02551f
C31 a_417_n1899# GROUP1_0.G 0.01647f
C32 GROUP1_0.G a_417_n821# 0.0166f
C33 GROUP1_0.G a_1219_n821# 0.04636f
C34 GROUP1_0.G GROUP1_0.pmos_priv1_0.D 1.30265f
C35 a_683_160# GROUP3_0.G 0.03011f
C36 a_1436_n1899# A 0.01793f
C37 a_686_1130# GROUP3_0.G 0.05625f
C38 GROUP1_0.pmos_priv1_0.D GROUP3_0.G 0.99529f
C39 GROUP1_0.G a_1219_n1899# 0.04597f
C40 A a_1219_n821# 0.01601f
C41 A a_1436_n821# 0.01793f
C42 B VSS 0.18342f
C43 a_1436_n821# VSS 0.12112f ; **FLOATING
C44 a_1219_n821# VSS 0.07694f ; **FLOATING
C45 a_634_n821# VSS 0.12144f ; **FLOATING
C46 a_417_n821# VSS 0.07703f ; **FLOATING
C47 a_1048_160# VSS 0.15405f ; **FLOATING
C48 a_683_160# VSS 0.24359f ; **FLOATING
C49 GROUP1_0.G VSS 0.99095f
C50 VSS.t12 VSS 0.18342f
.ends
