** sch_path: /foss/designs/sg13cmos5l_slot3_backup/macros/level_shifter/testbenches/xschem/level_shifter_tb_dc_hi_pex.sch
**.subckt level_shifter_tb_dc_hi_pex
x1 AVDD LO_B DVDD LO HI GND HI_B level_shifter_pex
V1 AVDD GND 3.3
V2 DVDD GND 1.2
V3 LO GND 0
**** begin user architecture code

.include ../../../netlist/pex/level_shifter_magic_pex_3.spice
.param temp=27
.control
save all
dc V3 0 1.2 1m
remzerovec
write tb__level_shifter_dc_hi_pex.raw
.endc

.lib cornerMOSlv.lib mos_tt
.lib cornerMOShv.lib mos_tt
.lib cornerRES.lib res_typ
.lib cornerCAP.lib cap_typ
.lib cornerDIO.lib dio_tt

**** end user architecture code
**.ends
.end
