** sch_path: /foss/designs/sg13cmos5l_slot2_backup/macros/level_shifter/testbenches/xschem/level_up_shifter_tb_tran.sch
**.subckt level_up_shifter_tb_tran
v_a A GND pulse(0 1.2 1u 10n 10n 1u 2u)
v_vdd1 net1 GND dc 1.2
v_vdd2 net2 GND dc 3.3
x1 net2 A B GND net1 level_up_shifter_pex
**** begin user architecture code

.lib cornerMOSlv.lib mos_tt
.lib cornerMOShv.lib mos_tt
.include ../../../netlist/pex/level_up_shifter_magic_pex_3.spice

.options klu reltol=1e-3 abstol=1e-12 vntol=1e-6 gmin=1e-12
.control
  tran 10n 5u
  set wr_vecnames
  set wr_singlescale
  wrdata ../plot_simulations/data/level_up_shifter_tb_tran.txt v(A) v(B)
  plot V(A) V(B)
.endc

**** end user architecture code
**.ends
.GLOBAL GND
.end
