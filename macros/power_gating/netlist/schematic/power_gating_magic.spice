** sch_path: /foss/designs/sg13cmos5l_slot3_backup/macros/power_gating/schematic/xschem/power_gating.sch
.subckt power_gating DOUT SG_AVDD DVDD EG_IBIAS SG_DVDD AVDD IBIAS EG_AVDD ENA STDBY VSS
*.PININFO DVDD:B VSS:B AVDD:B ENA:I STDBY:I DOUT:O IBIAS:I EG_AVDD:B SG_AVDD:B SG_DVDD:B EG_IBIAS:O
x3 AVDD ENA_B DVDD ENA ENA_H VSS ENA_BH level_shifter
x4 AVDD STDBY_B DVDD STDBY STDBY_H VSS STDBY_BH level_shifter
XM2 EG_IBIAS ENA_BH IBIAS AVDD sg13_hv_pmos w=25.6u l=0.4u ng=8 m=1 mm_ok=1
XM1 SG_AVDD STDBY_H AVDD AVDD sg13_hv_pmos w=25.6u l=0.4u ng=8 m=1 mm_ok=1
XM25 EG_AVDD ENA_BH AVDD AVDD sg13_hv_pmos w=25.6u l=0.4u ng=8 m=1 mm_ok=1
XM9 SG_AVDD STDBY_H VSS VSS sg13_hv_nmos w=28.8u l=0.45u ng=8 m=1 mm_ok=1
XM21 EG_AVDD ENA_BH VSS VSS sg13_hv_nmos w=28.8u l=0.45u ng=8 m=1 mm_ok=1
XM27 SG_DVDD STDBY DVDD DVDD sg13_lv_pmos w=27.76u l=0.13u ng=8 m=1 mm_ok=1
XM18 SG_DVDD STDBY VSS VSS sg13_lv_nmos w=27.76u l=0.13u ng=8 m=1 mm_ok=1
XM4 DOUT STDBY VSS VSS sg13_lv_nmos w=27.76u l=0.13u ng=8 m=1 mm_ok=1
XM3 VSS ENA_H IBIAS AVDD sg13_hv_pmos w=25.6u l=0.4u ng=8 m=1 mm_ok=1
.ends

* expanding   symbol:  level_shifter.sym # of pins=7
** sym_path: /foss/designs/sg13cmos5l_slot3_backup/macros/level_shifter/schematic/xschem/level_shifter.sym
** sch_path: /foss/designs/sg13cmos5l_slot3_backup/macros/level_shifter/schematic/xschem/level_shifter.sch
.subckt level_shifter AVDD LO_B DVDD LO HI VSS HI_B
*.PININFO DVDD:B VSS:B AVDD:B LO:I LO_B:O HI:O HI_B:O
XM1 IM_B IM AVDD AVDD sg13_hv_pmos w=0.8u l=0.4u ng=1 m=1 mm_ok=1
XM2 IM_B LO_BB VSS VSS sg13_hv_nmos w=0.9u l=0.45u ng=1 m=1 mm_ok=1
XM3 IM IM_B AVDD AVDD sg13_hv_pmos w=0.8u l=0.4u ng=1 m=1 mm_ok=1
XM4 IM LO_B VSS VSS sg13_hv_nmos w=0.9u l=0.45u ng=1 m=1 mm_ok=1
XM5 LO_B LO DVDD DVDD sg13_lv_pmos w=0.87u l=0.13u ng=1 m=1 mm_ok=1
XM6 LO_B LO VSS VSS sg13_lv_nmos w=0.87u l=0.13u ng=1 m=1 mm_ok=1
XM7 LO_BB LO_B DVDD DVDD sg13_lv_pmos w=0.87u l=0.13u ng=1 m=1 mm_ok=1
XM8 LO_BB LO_B VSS VSS sg13_lv_nmos w=0.87u l=0.13u ng=1 m=1 mm_ok=1
XM9 HI IM_B AVDD AVDD sg13_hv_pmos w=0.8u l=0.4u ng=1 m=1 mm_ok=1
XM10 HI IM_B VSS VSS sg13_hv_nmos w=0.9u l=0.45u ng=1 m=1 mm_ok=1
XM11 HI_B HI AVDD AVDD sg13_hv_pmos w=0.8u l=0.4u ng=1 m=1 mm_ok=1
XM12 HI_B HI VSS VSS sg13_hv_nmos w=0.9u l=0.45u ng=1 m=1 mm_ok=1
.ends
