* PEX produced on Thu Oct 29 04:15:53 PM CET 2026 using /foss/tools/sak/sak-pex.sh with m=3 and s=1 (extresist threshold=10000 mOhm, minres=1000 mOhm, mindelay=1 ps)
* NGSPICE file created from power_gating_pex.ext - technology: ihp-sg13cmos5l

.subckt power_gating_pex DOUT SG_AVDD DVDD EG_IBIAS SG_DVDD AVDD IBIAS EG_AVDD
+ ENA STDBY VSS
X0 x4.LO_B STDBY DVDD DVDD sg13_lv_pmos ad=0.2958p pd=2.42u as=0.2958p ps=2.42u w=0.87u l=0.13u
X1 x3.LO_B ENA VSS.t29 VSS.t28 sg13_lv_nmos ad=0.2958p pd=2.42u as=0.2958p ps=2.42u w=0.87u l=0.13u
X2 x3.LO_BB x3.LO_B VSS.t13 VSS.t12 sg13_lv_nmos ad=0.2958p pd=2.42u as=0.2958p ps=2.42u w=0.87u l=0.13u
X3 EG_AVDD ENA_BH.t9 VSS.t1 VSS.t0 sg13_hv_nmos ad=0.684p pd=3.98u as=1.224p ps=7.88u w=3.6u l=0.45u
X4 AVDD ENA_BH.t14 EG_AVDD AVDD sg13_hv_pmos ad=0.608p pd=3.58u as=0.608p ps=3.58u w=3.2u l=0.4u
X5 EG_AVDD ENA_BH.t13 AVDD AVDD sg13_hv_pmos ad=0.608p pd=3.58u as=0.608p ps=3.58u w=3.2u l=0.4u
X6 DVDD STDBY SG_DVDD DVDD sg13_lv_pmos ad=0.6593p pd=3.85u as=0.6593p ps=3.85u w=3.47u l=0.13u
X7 ENA_H x3.IM_B VSS.t23 VSS.t22 sg13_hv_nmos ad=0.306p pd=2.48u as=0.306p ps=2.48u w=0.9u l=0.45u
X8 SG_AVDD STDBY_H AVDD AVDD sg13_hv_pmos ad=0.608p pd=3.58u as=0.608p ps=3.58u w=3.2u l=0.4u
X9 SG_DVDD STDBY VSS.t35 VSS.t34 sg13_lv_nmos ad=0.6593p pd=3.85u as=1.1798p ps=7.62u w=3.47u l=0.13u
X10 EG_AVDD ENA_BH.t17 AVDD AVDD sg13_hv_pmos ad=0.608p pd=3.58u as=1.088p ps=7.08u w=3.2u l=0.4u
X11 AVDD ENA_BH.t12 EG_AVDD AVDD sg13_hv_pmos ad=0.608p pd=3.58u as=0.608p ps=3.58u w=3.2u l=0.4u
X12 EG_AVDD ENA_BH.t3 VSS.t3 VSS.t7 sg13_hv_nmos ad=0.684p pd=3.98u as=0.684p ps=3.98u w=3.6u l=0.45u
X13 VSS.t35 STDBY SG_DVDD VSS.t36 sg13_lv_nmos ad=0.6593p pd=3.85u as=0.6593p ps=3.85u w=3.47u l=0.13u
X14 SG_AVDD STDBY_H AVDD AVDD sg13_hv_pmos ad=0.608p pd=3.58u as=0.608p ps=3.58u w=3.2u l=0.4u
X15 SG_DVDD STDBY VSS.t35 VSS.t37 sg13_lv_nmos ad=0.6593p pd=3.85u as=0.6593p ps=3.85u w=3.47u l=0.13u
X16 SG_AVDD STDBY_H AVDD AVDD sg13_hv_pmos ad=0.608p pd=3.58u as=1.088p ps=7.08u w=3.2u l=0.4u
X17 IBIAS ENA_H VSS.t1 AVDD sg13_hv_pmos ad=0.608p pd=3.58u as=0.608p ps=3.58u w=3.2u l=0.4u
X18 VSS.t1 ENA_H IBIAS AVDD sg13_hv_pmos ad=0.608p pd=3.58u as=0.608p ps=3.58u w=3.2u l=0.4u
X19 ENA_H x3.IM_B AVDD AVDD sg13_hv_pmos ad=0.272p pd=2.28u as=0.272p ps=2.28u w=0.8u l=0.4u
X20 x4.HI_B STDBY_H VSS.t51 VSS.t50 sg13_hv_nmos ad=0.306p pd=2.48u as=0.306p ps=2.48u w=0.9u l=0.45u
X21 IBIAS ENA_BH.t25 EG_IBIAS AVDD sg13_hv_pmos ad=0.608p pd=3.58u as=1.088p ps=7.08u w=3.2u l=0.4u
X22 VSS.t3 ENA_BH.t6 EG_AVDD VSS.t21 sg13_hv_nmos ad=0.684p pd=3.98u as=0.684p ps=3.98u w=3.6u l=0.45u
X23 VSS.t35 STDBY SG_DVDD VSS.t38 sg13_lv_nmos ad=0.6593p pd=3.85u as=0.6593p ps=3.85u w=3.47u l=0.13u
X24 x4.LO_BB x4.LO_B VSS.t9 VSS.t8 sg13_lv_nmos ad=0.2958p pd=2.42u as=0.2958p ps=2.42u w=0.87u l=0.13u
X25 VSS.t3 ENA_BH.t8 EG_AVDD VSS.t2 sg13_hv_nmos ad=0.684p pd=3.98u as=0.684p ps=3.98u w=3.6u l=0.45u
X26 SG_AVDD STDBY_H VSS.t53 VSS.t55 sg13_hv_nmos ad=0.684p pd=3.98u as=0.684p ps=3.98u w=3.6u l=0.45u
X27 x4.LO_B STDBY VSS.t33 VSS.t32 sg13_lv_nmos ad=0.2958p pd=2.42u as=0.2958p ps=2.42u w=0.87u l=0.13u
X28 EG_IBIAS ENA_BH.t18 IBIAS AVDD sg13_hv_pmos ad=1.088p pd=7.08u as=0.608p ps=3.58u w=3.2u l=0.4u
X29 SG_DVDD STDBY DVDD DVDD sg13_lv_pmos ad=0.6593p pd=3.85u as=0.6593p ps=3.85u w=3.47u l=0.13u
X30 SG_DVDD STDBY VSS.t35 VSS.t39 sg13_lv_nmos ad=0.6593p pd=3.85u as=0.6593p ps=3.85u w=3.47u l=0.13u
X31 x3.IM_B x3.IM AVDD AVDD sg13_hv_pmos ad=0.272p pd=2.28u as=0.272p ps=2.28u w=0.8u l=0.4u
X32 x4.IM x4.LO_B VSS.t11 VSS.t10 sg13_hv_nmos ad=0.306p pd=2.48u as=0.306p ps=2.48u w=0.9u l=0.45u
X33 SG_DVDD STDBY DVDD DVDD sg13_lv_pmos ad=0.6593p pd=3.85u as=0.6593p ps=3.85u w=3.47u l=0.13u
X34 VSS.t5 ENA_BH.t2 EG_AVDD VSS.t4 sg13_hv_nmos ad=1.224p pd=7.88u as=0.684p ps=3.98u w=3.6u l=0.45u
X35 DOUT STDBY VSS.t31 VSS.t43 sg13_lv_nmos ad=0.6593p pd=3.85u as=1.1798p ps=7.62u w=3.47u l=0.13u
X36 IBIAS ENA_H VSS.t1 AVDD sg13_hv_pmos ad=0.608p pd=3.58u as=0.608p ps=3.58u w=3.2u l=0.4u
X37 VSS.t35 STDBY SG_DVDD VSS.t40 sg13_lv_nmos ad=0.6593p pd=3.85u as=0.6593p ps=3.85u w=3.47u l=0.13u
X38 x4.HI_B STDBY_H AVDD AVDD sg13_hv_pmos ad=0.272p pd=2.28u as=0.272p ps=2.28u w=0.8u l=0.4u
X39 IBIAS ENA_BH.t21 EG_IBIAS AVDD sg13_hv_pmos ad=0.608p pd=3.58u as=0.608p ps=3.58u w=3.2u l=0.4u
X40 AVDD STDBY_H SG_AVDD AVDD sg13_hv_pmos ad=0.608p pd=3.58u as=0.608p ps=3.58u w=3.2u l=0.4u
X41 VSS.t1 ENA_H IBIAS AVDD sg13_hv_pmos ad=1.088p pd=7.08u as=0.608p ps=3.58u w=3.2u l=0.4u
X42 SG_DVDD STDBY VSS.t35 VSS.t41 sg13_lv_nmos ad=0.6593p pd=3.85u as=0.6593p ps=3.85u w=3.47u l=0.13u
X43 VSS.t31 STDBY DOUT VSS.t44 sg13_lv_nmos ad=0.6593p pd=3.85u as=0.6593p ps=3.85u w=3.47u l=0.13u
X44 DOUT STDBY VSS.t31 VSS.t48 sg13_lv_nmos ad=0.6593p pd=3.85u as=0.6593p ps=3.85u w=3.47u l=0.13u
X45 EG_IBIAS ENA_BH.t22 IBIAS AVDD sg13_hv_pmos ad=0.608p pd=3.58u as=0.608p ps=3.58u w=3.2u l=0.4u
X46 EG_AVDD ENA_BH.t5 VSS.t3 VSS.t6 sg13_hv_nmos ad=0.684p pd=3.98u as=0.684p ps=3.98u w=3.6u l=0.45u
X47 VSS.t53 STDBY_H SG_AVDD VSS.t58 sg13_hv_nmos ad=0.684p pd=3.98u as=0.684p ps=3.98u w=3.6u l=0.45u
X48 VSS.t35 STDBY SG_DVDD VSS.t42 sg13_lv_nmos ad=1.1798p pd=7.62u as=0.6593p ps=3.85u w=3.47u l=0.13u
X49 DOUT STDBY VSS.t31 VSS.t30 sg13_lv_nmos ad=0.6593p pd=3.85u as=0.6593p ps=3.85u w=3.47u l=0.13u
X50 VSS.t31 STDBY DOUT VSS.t49 sg13_lv_nmos ad=1.1798p pd=7.62u as=0.6593p ps=3.85u w=3.47u l=0.13u
X51 x4.IM x4.IM_B AVDD AVDD sg13_hv_pmos ad=0.272p pd=2.28u as=0.272p ps=2.28u w=0.8u l=0.4u
X52 VSS.t31 STDBY DOUT VSS.t45 sg13_lv_nmos ad=0.6593p pd=3.85u as=0.6593p ps=3.85u w=3.47u l=0.13u
X53 DOUT STDBY VSS.t31 VSS.t46 sg13_lv_nmos ad=0.6593p pd=3.85u as=0.6593p ps=3.85u w=3.47u l=0.13u
X54 x4.IM_B x4.LO_BB VSS.t25 VSS.t24 sg13_hv_nmos ad=0.306p pd=2.48u as=0.306p ps=2.48u w=0.9u l=0.45u
X55 SG_DVDD STDBY DVDD DVDD sg13_lv_pmos ad=0.6593p pd=3.85u as=1.1798p ps=7.62u w=3.47u l=0.13u
X56 DVDD STDBY SG_DVDD DVDD sg13_lv_pmos ad=0.6593p pd=3.85u as=0.6593p ps=3.85u w=3.47u l=0.13u
X57 SG_AVDD STDBY_H VSS.t53 VSS.t52 sg13_hv_nmos ad=0.684p pd=3.98u as=1.224p ps=7.88u w=3.6u l=0.45u
X58 VSS.t31 STDBY DOUT VSS.t47 sg13_lv_nmos ad=0.6593p pd=3.85u as=0.6593p ps=3.85u w=3.47u l=0.13u
X59 ENA_BH.t1 ENA_H VSS.t27 VSS.t26 sg13_hv_nmos ad=0.306p pd=2.48u as=0.306p ps=2.48u w=0.9u l=0.45u
X60 EG_AVDD ENA_BH.t15 AVDD AVDD sg13_hv_pmos ad=0.608p pd=3.58u as=0.608p ps=3.58u w=3.2u l=0.4u
X61 AVDD ENA_BH.t10 EG_AVDD AVDD sg13_hv_pmos ad=1.088p pd=7.08u as=0.608p ps=3.58u w=3.2u l=0.4u
X62 SG_AVDD STDBY_H VSS.t53 VSS.t59 sg13_hv_nmos ad=0.684p pd=3.98u as=0.684p ps=3.98u w=3.6u l=0.45u
X63 AVDD ENA_BH.t16 EG_AVDD AVDD sg13_hv_pmos ad=0.608p pd=3.58u as=0.608p ps=3.58u w=3.2u l=0.4u
X64 SG_AVDD STDBY_H AVDD AVDD sg13_hv_pmos ad=0.608p pd=3.58u as=0.608p ps=3.58u w=3.2u l=0.4u
X65 AVDD STDBY_H SG_AVDD AVDD sg13_hv_pmos ad=1.088p pd=7.08u as=0.608p ps=3.58u w=3.2u l=0.4u
X66 IBIAS ENA_H VSS.t1 AVDD sg13_hv_pmos ad=0.608p pd=3.58u as=0.608p ps=3.58u w=3.2u l=0.4u
X67 VSS.t3 ENA_BH.t4 EG_AVDD VSS.t16 sg13_hv_nmos ad=0.684p pd=3.98u as=0.684p ps=3.98u w=3.6u l=0.45u
X68 IBIAS ENA_BH.t23 EG_IBIAS AVDD sg13_hv_pmos ad=0.608p pd=3.58u as=0.608p ps=3.58u w=3.2u l=0.4u
X69 x3.IM x3.LO_B VSS.t15 VSS.t14 sg13_hv_nmos ad=0.306p pd=2.48u as=0.306p ps=2.48u w=0.9u l=0.45u
X70 VSS.t1 ENA_H IBIAS AVDD sg13_hv_pmos ad=0.608p pd=3.58u as=0.608p ps=3.58u w=3.2u l=0.4u
X71 VSS.t53 STDBY_H SG_AVDD VSS.t56 sg13_hv_nmos ad=0.684p pd=3.98u as=0.684p ps=3.98u w=3.6u l=0.45u
X72 x3.LO_BB x3.LO_B DVDD DVDD sg13_lv_pmos ad=0.2958p pd=2.42u as=0.2958p ps=2.42u w=0.87u l=0.13u
X73 ENA_BH.t0 ENA_H AVDD AVDD sg13_hv_pmos ad=0.272p pd=2.28u as=0.272p ps=2.28u w=0.8u l=0.4u
X74 STDBY_H x4.IM_B VSS.t20 VSS.t19 sg13_hv_nmos ad=0.306p pd=2.48u as=0.306p ps=2.48u w=0.9u l=0.45u
X75 EG_AVDD ENA_BH.t7 VSS.t3 VSS.t61 sg13_hv_nmos ad=0.684p pd=3.98u as=0.684p ps=3.98u w=3.6u l=0.45u
X76 x3.LO_B ENA DVDD DVDD sg13_lv_pmos ad=0.2958p pd=2.42u as=0.2958p ps=2.42u w=0.87u l=0.13u
X77 VSS.t53 STDBY_H SG_AVDD VSS.t54 sg13_hv_nmos ad=0.684p pd=3.98u as=0.684p ps=3.98u w=3.6u l=0.45u
X78 x3.IM x3.IM_B AVDD AVDD sg13_hv_pmos ad=0.272p pd=2.28u as=0.272p ps=2.28u w=0.8u l=0.4u
X79 IBIAS ENA_BH.t19 EG_IBIAS AVDD sg13_hv_pmos ad=0.608p pd=3.58u as=0.608p ps=3.58u w=3.2u l=0.4u
X80 DVDD STDBY SG_DVDD DVDD sg13_lv_pmos ad=0.6593p pd=3.85u as=0.6593p ps=3.85u w=3.47u l=0.13u
X81 SG_DVDD STDBY DVDD DVDD sg13_lv_pmos ad=0.6593p pd=3.85u as=0.6593p ps=3.85u w=3.47u l=0.13u
X82 DVDD STDBY SG_DVDD DVDD sg13_lv_pmos ad=1.1798p pd=7.62u as=0.6593p ps=3.85u w=3.47u l=0.13u
X83 STDBY_H x4.IM_B AVDD AVDD sg13_hv_pmos ad=0.272p pd=2.28u as=0.272p ps=2.28u w=0.8u l=0.4u
X84 EG_IBIAS ENA_BH.t20 IBIAS AVDD sg13_hv_pmos ad=0.608p pd=3.58u as=0.608p ps=3.58u w=3.2u l=0.4u
X85 EG_AVDD ENA_BH.t11 AVDD AVDD sg13_hv_pmos ad=0.608p pd=3.58u as=0.608p ps=3.58u w=3.2u l=0.4u
X86 AVDD STDBY_H SG_AVDD AVDD sg13_hv_pmos ad=0.608p pd=3.58u as=0.608p ps=3.58u w=3.2u l=0.4u
X87 VSS.t53 STDBY_H SG_AVDD VSS.t60 sg13_hv_nmos ad=1.224p pd=7.88u as=0.684p ps=3.98u w=3.6u l=0.45u
X88 x3.IM_B x3.LO_BB VSS.t18 VSS.t17 sg13_hv_nmos ad=0.306p pd=2.48u as=0.306p ps=2.48u w=0.9u l=0.45u
X89 AVDD STDBY_H SG_AVDD AVDD sg13_hv_pmos ad=0.608p pd=3.58u as=0.608p ps=3.58u w=3.2u l=0.4u
X90 VSS.t1 ENA_H IBIAS AVDD sg13_hv_pmos ad=0.608p pd=3.58u as=0.608p ps=3.58u w=3.2u l=0.4u
X91 EG_IBIAS ENA_BH.t24 IBIAS AVDD sg13_hv_pmos ad=0.608p pd=3.58u as=0.608p ps=3.58u w=3.2u l=0.4u
X92 SG_AVDD STDBY_H VSS.t53 VSS.t57 sg13_hv_nmos ad=0.684p pd=3.98u as=0.684p ps=3.98u w=3.6u l=0.45u
X93 x4.LO_BB x4.LO_B DVDD DVDD sg13_lv_pmos ad=0.2958p pd=2.42u as=0.2958p ps=2.42u w=0.87u l=0.13u
X94 x4.IM_B x4.IM AVDD AVDD sg13_hv_pmos ad=0.272p pd=2.28u as=0.272p ps=2.28u w=0.8u l=0.4u
X95 IBIAS ENA_H VSS.t1 AVDD sg13_hv_pmos ad=0.608p pd=3.58u as=1.088p ps=7.08u w=3.2u l=0.4u
R0 VSS.n77 VSS.n76 352618
R1 VSS.n174 VSS.n173 28416
R2 VSS.n131 VSS.n130 16896
R3 VSS.n77 VSS.n22 16896
R4 VSS.n186 VSS.n78 7851.3
R5 VSS.n138 VSS.n131 2437.69
R6 VSS.n186 VSS.n185 932.001
R7 VSS.n23 VSS.n22 870.696
R8 VSS.n130 VSS.n127 870.692
R9 VSS.t0 VSS.n0 659.683
R10 VSS.n45 VSS.n22 633.635
R11 VSS.n130 VSS.n129 633.635
R12 VSS.n78 VSS.n77 518.455
R13 VSS.n173 VSS.n30 467.094
R14 VSS.n173 VSS.n0 432.781
R15 VSS.n16 VSS.n15 425.313
R16 VSS.n17 VSS.n13 425.315
R17 VSS.n14 VSS.n24 425.315
R18 VSS.n48 VSS.n40 425.31
R19 VSS.n128 VSS.n81 425.31
R20 VSS.n25 VSS.n175 425.228
R21 VSS.n176 VSS.n18 421.103
R22 VSS.n151 VSS.n119 311.276
R23 VSS.t17 VSS.n14 8.02669
R24 VSS.t22 VSS.n17 8.02669
R25 VSS.n127 VSS.t10 286.183
R26 VSS.t19 VSS.n19 8.02669
R27 VSS.n176 VSS.n119 273.842
R28 VSS.n131 VSS.n78 250.482
R29 VSS.n174 VSS.n120 208.284
R30 VSS.n0 VSS.t52 14.1383
R31 VSS.t0 VSS.t16 28.303
R32 VSS.n0 VSS.t55 28.3026
R33 VSS.t12 VSS.n45 147.22
R34 VSS.n40 VSS.t28 147.22
R35 VSS.n81 VSS.t32 147.22
R36 VSS.n129 VSS.t8 147.22
R37 VSS.n76 VSS.t28 147.22
R38 VSS.n48 VSS.t12 147.219
R39 VSS.n185 VSS.t32 147.219
R40 VSS.t8 VSS.n128 147.219
R41 VSS.t34 VSS.n30 133.106
R42 VSS.t56 VSS.n0 38.2858
R43 VSS.t0 VSS.t21 38.2862
R44 VSS.n145 VSS.t36 125.001
R45 VSS.t37 VSS.n145 125.001
R46 VSS.n147 VSS.t38 125.001
R47 VSS.t39 VSS.n147 125.001
R48 VSS.n149 VSS.t40 125.001
R49 VSS.t41 VSS.n149 125.001
R50 VSS.t54 VSS.n0 44.076
R51 VSS.t0 VSS.t2 44.0761
R52 VSS.n0 VSS.t59 44.0766
R53 VSS.n175 VSS.n174 85.9041
R54 VSS.t0 VSS.t7 44.0754
R55 VSS.n125 VSS.n104 60.1533
R56 VSS.t57 VSS.n0 38.2876
R57 VSS.t0 VSS.t6 38.2871
R58 VSS.n126 VSS.n102 52.5148
R59 VSS.n150 VSS.t41 49.3816
R60 VSS.n148 VSS.t39 49.3816
R61 VSS.n146 VSS.t37 49.3816
R62 VSS.n144 VSS.t34 49.3816
R63 VSS.t36 VSS.n144 49.3809
R64 VSS.t38 VSS.n146 49.3809
R65 VSS.t40 VSS.n148 49.3809
R66 VSS.t42 VSS.n150 49.3809
R67 VSS.n124 VSS.t43 48.6956
R68 VSS.t30 VSS.n132 48.6956
R69 VSS.n132 VSS.n100 45.8312
R70 VSS.n134 VSS.t45 39.7821
R71 VSS.t46 VSS.n134 39.7821
R72 VSS.n136 VSS.t47 39.7821
R73 VSS.t48 VSS.n136 39.7821
R74 VSS.n0 VSS.t58 28.3013
R75 VSS.n119 VSS.n104 32.4639
R76 VSS.n139 VSS.n143 30.3756
R77 VSS.n32 VSS.t44 22.969
R78 VSS.n133 VSS.t30 22.8273
R79 VSS.n169 VSS.n37 21.3756
R80 VSS.t45 VSS.n133 19.8555
R81 VSS.n137 VSS.t48 19.6992
R82 VSS.n135 VSS.t46 19.6992
R83 VSS.t47 VSS.n135 19.6986
R84 VSS.t49 VSS.n137 19.6986
R85 VSS.n191 VSS.n190 19.5711
R86 VSS.n32 VSS.n101 19.1504
R87 VSS.n169 VSS.n168 18.3616
R88 VSS.n190 VSS.n189 18.0012
R89 VSS.n160 VSS.n34 17.0005
R90 VSS.n152 VSS.n8 17.0005
R91 VSS.n21 VSS.t26 8.02491
R92 VSS.n26 VSS.t24 8.02517
R93 VSS.n24 VSS.t14 8.02511
R94 VSS.n24 VSS.n23 0.00177135
R95 VSS.n26 VSS.n25 0.00170931
R96 VSS.n21 VSS.n15 0.00172327
R97 VSS.n151 VSS.n31 2.39889
R98 VSS.t4 VSS.t0 14.1375
R99 VSS.n0 VSS.t60 14.1367
R100 VSS.n35 VSS.t49 47.1942
R101 VSS.n140 VSS 13.5933
R102 VSS.n126 VSS.t50 12.413
R103 VSS.n124 VSS.n102 12.413
R104 VSS.n125 VSS.n103 11.5113
R105 VSS.n142 VSS.n141 10.5724
R106 VSS.n190 VSS.t5 10.525
R107 VSS.n159 VSS.t31 9.42522
R108 VSS.t35 VSS.n121 9.37241
R109 VSS.n122 VSS.t5 9.37241
R110 VSS.n156 VSS.n139 9.36885
R111 VSS.n141 VSS.n98 9.1765
R112 VSS.t3 VSS.n169 9.0005
R113 VSS.n35 VSS.n138 3.20798
R114 VSS.n12 VSS.n10 0.00257105
R115 VSS.n138 VSS.n12 2.42943
R116 VSS.n8 VSS.n31 0.00539724
R117 VSS.n8 VSS.n5 0.00138115
R118 VSS.n151 VSS.n6 3.40102
R119 VSS.n149 VSS.n8 8.5005
R120 VSS.n147 VSS.n8 8.5005
R121 VSS.n145 VSS.n8 8.5005
R122 VSS.n136 VSS.n34 8.5005
R123 VSS.n134 VSS.n34 8.5005
R124 VSS.n132 VSS.n34 8.5005
R125 VSS.n34 VSS.n124 8.5005
R126 VSS.n34 VSS.n126 8.5005
R127 VSS.n177 VSS.n101 8.5005
R128 VSS.n177 VSS.n102 8.5005
R129 VSS.n177 VSS.n104 8.5005
R130 VSS.n27 VSS.n9 4.10865
R131 VSS.n11 VSS.n10 4.10865
R132 VSS.n28 VSS.n5 4.10972
R133 VSS.n6 VSS.n7 3.22124
R134 VSS.n123 VSS.n8 8.44296
R135 VSS.n13 VSS.n14 0.00110979
R136 VSS.n16 VSS.n17 0.00110979
R137 VSS.n18 VSS.n19 0.00110979
R138 VSS.t10 VSS.n120 8.01193
R139 VSS.t50 VSS.n103 6.73723
R140 VSS.n140 VSS 6.44031
R141 VSS.n36 VSS 6.4355
R142 VSS.n12 VSS.n34 0.00342844
R143 VSS.n28 VSS.n7 1.03242
R144 VSS.n142 VSS.n140 4.7481
R145 VSS.n177 VSS.n100 4.25169
R146 VSS.n177 VSS.n176 4.2505
R147 VSS.n73 VSS.n72 4.20617
R148 VSS.n184 VSS.n183 4.20617
R149 VSS.n82 VSS.n84 4.20617
R150 VSS.n74 VSS.n73 4.20598
R151 VSS.n107 VSS.n84 4.20598
R152 VSS.n73 VSS.t13 4.14188
R153 VSS.t15 VSS.n23 4.14188
R154 VSS.t18 VSS.n13 4.14188
R155 VSS.t23 VSS.n16 4.14188
R156 VSS.n15 VSS.t27 4.14188
R157 VSS.t9 VSS.n84 4.14188
R158 VSS.t11 VSS.n88 4.14188
R159 VSS.t25 VSS.n25 4.14188
R160 VSS.t20 VSS.n18 4.14188
R161 VSS.n177 VSS.t51 4.14188
R162 VSS.n75 VSS.n39 4.10865
R163 VSS.n73 VSS.n47 4.10865
R164 VSS.n51 VSS.n23 4.10865
R165 VSS.n54 VSS.n13 4.10865
R166 VSS.n67 VSS.n16 4.10865
R167 VSS.n184 VSS.n80 4.10865
R168 VSS.n85 VSS.n84 4.10865
R169 VSS.n89 VSS.n88 4.10865
R170 VSS.n92 VSS.n25 4.10865
R171 VSS.n95 VSS.n18 4.10865
R172 VSS.t43 VSS.n101 3.81972
R173 VSS.n49 VSS.n23 3.3422
R174 VSS.n52 VSS.n13 3.3422
R175 VSS.n55 VSS.n16 3.3422
R176 VSS.n187 VSS.n15 3.3422
R177 VSS.n86 VSS.n88 3.3422
R178 VSS.n90 VSS.n25 3.3422
R179 VSS.n93 VSS.n18 3.3422
R180 VSS.n59 VSS.n23 3.34202
R181 VSS.n62 VSS.n13 3.34202
R182 VSS.n110 VSS.n88 3.34202
R183 VSS.n113 VSS.n25 3.34202
R184 VSS.n96 VSS.n177 3.34202
R185 VSS.n65 VSS.n16 3.34184
R186 VSS.n116 VSS.n18 3.34184
R187 VSS.n37 VSS 3.2389
R188 VSS VSS.n192 3.01749
R189 VSS.t44 VSS.n100 2.86492
R190 VSS.n141 VSS.t31 2.80257
R191 VSS.n3 VSS.t0 0.576749
R192 VSS.n4 VSS.t1 9.74191
R193 VSS.n192 VSS.n191 2.0476
R194 VSS.n2 VSS.n0 0.466745
R195 VSS.n161 VSS.n11 2.19606
R196 VSS.n0 VSS.n1 0.461846
R197 VSS.n184 VSS.n79 1.92362
R198 VSS.n167 VSS.t0 1.78414
R199 VSS.n162 VSS.n161 1.77553
R200 VSS.n15 VSS.n20 1.64228
R201 VSS.n177 VSS.n99 1.64228
R202 VSS.n165 VSS.n164 1.59851
R203 VSS.n164 VSS.n163 1.59093
R204 VSS.n143 VSS.n36 1.4426
R205 VSS.n34 VSS.n125 1.41717
R206 VSS.n170 VSS.n2 1.73556
R207 VSS.n2 VSS.n3 2.17479
R208 VSS.n153 VSS.n29 1.35781
R209 VSS.n157 VSS.n33 1.35781
R210 VSS.n165 VSS.n29 1.35571
R211 VSS.n162 VSS.n33 1.35571
R212 VSS.t35 VSS.t53 1.24219
R213 VSS.n1 VSS.n165 1.82859
R214 VSS.n4 VSS.t0 0.648032
R215 VSS.n75 VSS.n42 1.12953
R216 VSS.n188 VSS.n20 1.1035
R217 VSS.n99 VSS.n98 1.1035
R218 VSS.n139 VSS.t35 1.05874
R219 VSS.n8 VSS.n29 1.04205
R220 VSS.n34 VSS.n33 1.04205
R221 VSS.n137 VSS.n34 1.03277
R222 VSS.n135 VSS.n34 1.03277
R223 VSS.n139 VSS.t31 1.01101
R224 VSS.n154 VSS.n8 0.984588
R225 VSS.n158 VSS.n34 0.984588
R226 VSS.n133 VSS.n34 0.954291
R227 VSS.n191 VSS.n37 0.93
R228 VSS.n34 VSS.n32 0.883132
R229 VSS.n177 VSS.n103 0.882885
R230 VSS.n42 VSS.t29 0.831217
R231 VSS.n42 VSS.n41 0.829921
R232 VSS.n79 VSS.t33 0.818313
R233 VSS.n171 VSS.n170 0.791044
R234 VSS.n172 VSS.n171 0.786115
R235 VSS.t1 VSS.t3 0.779076
R236 VSS.n163 VSS.n162 0.7705
R237 VSS.n164 VSS.n8 0.712108
R238 VSS.n69 VSS.n54 0.654122
R239 VSS.n180 VSS.n89 0.654122
R240 VSS.n179 VSS.n92 0.654122
R241 VSS.n111 VSS.n89 0.654122
R242 VSS.n114 VSS.n92 0.654122
R243 VSS.n178 VSS.n95 0.654122
R244 VSS.n117 VSS.n95 0.654122
R245 VSS.n68 VSS.n67 0.654122
R246 VSS.n67 VSS.n66 0.654122
R247 VSS.n63 VSS.n54 0.654122
R248 VSS.n70 VSS.n51 0.654122
R249 VSS.n60 VSS.n51 0.654122
R250 VSS.n41 VSS.n39 0.64381
R251 VSS.n71 VSS.n47 0.64381
R252 VSS.n181 VSS.n85 0.64381
R253 VSS.n108 VSS.n85 0.64381
R254 VSS.n182 VSS.n80 0.64381
R255 VSS.n105 VSS.n80 0.64381
R256 VSS.n47 VSS.n44 0.64381
R257 VSS.t29 VSS.n39 0.64381
R258 VSS.n143 VSS.n142 0.6418
R259 VSS.t3 VSS.t5 0.63067
R260 VSS.n118 VSS.n99 0.628933
R261 VSS.n57 VSS.n20 0.628933
R262 VSS.n1 VSS.n172 1.73604
R263 VSS.n105 VSS.n79 0.551803
R264 VSS.n4 VSS.n168 0.593216
R265 VSS.n154 VSS.n153 0.522019
R266 VSS.n158 VSS.n157 0.522019
R267 VSS.n155 VSS.n154 0.519426
R268 VSS.n159 VSS.n158 0.519426
R269 VSS.n109 VSS.t11 0.500254
R270 VSS.n115 VSS.t20 0.500254
R271 VSS.n57 VSS.t27 0.500254
R272 VSS.n64 VSS.t23 0.500254
R273 VSS.n61 VSS.t18 0.500254
R274 VSS.n112 VSS.t25 0.500254
R275 VSS.n118 VSS.t51 0.500254
R276 VSS.n97 VSS.t51 0.500254
R277 VSS.n94 VSS.t20 0.500254
R278 VSS.n91 VSS.t25 0.500254
R279 VSS.n87 VSS.t11 0.500254
R280 VSS.n58 VSS.t15 0.500254
R281 VSS.n56 VSS.t23 0.500254
R282 VSS.n53 VSS.t18 0.500254
R283 VSS.n50 VSS.t15 0.500254
R284 VSS.t27 VSS.n38 0.500254
R285 VSS.n43 VSS.t13 0.492397
R286 VSS.n106 VSS.t9 0.492397
R287 VSS.n83 VSS.t9 0.492397
R288 VSS.n46 VSS.t13 0.492397
R289 VSS.n161 VSS.n34 0.474583
R290 VSS.n27 VSS.n160 0.578497
R291 VSS.n11 VSS.n27 0.922744
R292 VSS.n152 VSS.n28 0.578497
R293 VSS.n7 VSS.n123 0.804731
R294 VSS.n167 VSS.n166 0.406832
R295 VSS.n181 VSS.n87 0.401487
R296 VSS.n109 VSS.n108 0.401487
R297 VSS.n58 VSS.n44 0.401487
R298 VSS.n71 VSS.n50 0.401487
R299 VSS.t61 VSS.t0 28.3021
R300 VSS.n150 VSS.n8 0.394625
R301 VSS.n148 VSS.n8 0.394625
R302 VSS.n146 VSS.n8 0.394625
R303 VSS.n144 VSS.n8 0.394625
R304 VSS.n163 VSS.n123 0.374889
R305 VSS.n168 VSS.n167 0.366078
R306 VSS.n189 VSS.t33 0.323227
R307 VSS.n87 VSS.n86 0.263268
R308 VSS.n91 VSS.n90 0.263268
R309 VSS.n94 VSS.n93 0.263268
R310 VSS.n50 VSS.n49 0.263268
R311 VSS.n53 VSS.n52 0.263268
R312 VSS.n56 VSS.n55 0.263268
R313 VSS.n187 VSS.n38 0.263268
R314 VSS.n110 VSS.n109 0.262958
R315 VSS.n113 VSS.n112 0.262958
R316 VSS.n97 VSS.n96 0.262958
R317 VSS.n59 VSS.n58 0.262958
R318 VSS.n62 VSS.n61 0.262958
R319 VSS.n116 VSS.n115 0.262646
R320 VSS.n65 VSS.n64 0.262646
R321 VSS.n117 VSS.n116 0.261552
R322 VSS.n66 VSS.n65 0.261552
R323 VSS.n111 VSS.n110 0.261244
R324 VSS.n114 VSS.n113 0.261244
R325 VSS.n96 VSS.n98 0.261244
R326 VSS.n60 VSS.n59 0.261244
R327 VSS.n63 VSS.n62 0.261244
R328 VSS.n86 VSS.n180 0.260944
R329 VSS.n90 VSS.n179 0.260944
R330 VSS.n93 VSS.n178 0.260944
R331 VSS.n49 VSS.n70 0.260944
R332 VSS.n52 VSS.n69 0.260944
R333 VSS.n55 VSS.n68 0.260944
R334 VSS.n188 VSS.n187 0.260944
R335 VSS.n160 VSS.n159 0.258312
R336 VSS.n155 VSS.n152 0.258312
R337 VSS.n120 VSS.n88 0.246341
R338 VSS.n183 VSS.t33 0.221603
R339 VSS.n83 VSS.n82 0.221603
R340 VSS.n72 VSS.n46 0.221603
R341 VSS.n107 VSS.n106 0.221222
R342 VSS.n43 VSS.n74 0.221222
R343 VSS.n74 VSS.n44 0.220154
R344 VSS.n108 VSS.n107 0.220154
R345 VSS.n183 VSS.n182 0.219774
R346 VSS.n82 VSS.n181 0.219774
R347 VSS.n72 VSS.n71 0.219774
R348 VSS.n189 VSS.n188 0.219097
R349 VSS.t53 VSS.t5 0.21528
R350 VSS.n35 VSS.n34 0.0461255
R351 VSS.n172 VSS.n121 0.1369
R352 VSS.n153 VSS.n121 0.134875
R353 VSS.n112 VSS.n111 0.1116
R354 VSS.n115 VSS.n114 0.1116
R355 VSS.n118 VSS.n117 0.1116
R356 VSS.n180 VSS.n91 0.1116
R357 VSS.n179 VSS.n94 0.1116
R358 VSS.n178 VSS.n97 0.1116
R359 VSS.n70 VSS.n53 0.1116
R360 VSS.n69 VSS.n56 0.1116
R361 VSS.n68 VSS.n38 0.1116
R362 VSS.n61 VSS.n60 0.1116
R363 VSS.n64 VSS.n63 0.1116
R364 VSS.n66 VSS.n57 0.1116
R365 VSS.n156 VSS.n155 0.109527
R366 VSS.n157 VSS.n156 0.109527
R367 VSS.n182 VSS.n83 0.108364
R368 VSS.n106 VSS.n105 0.108364
R369 VSS.t29 VSS.n43 0.108364
R370 VSS.n46 VSS.n41 0.108364
R371 VSS.n192 VSS.n36 0.107296
R372 VSS.n175 VSS.n88 0.0863205
R373 VSS.n166 VSS.n122 0.083
R374 VSS.n170 VSS.n122 0.083
R375 VSS.t42 VSS.n31 133.105
R376 VSS.n127 VSS.n88 0.00371352
R377 VSS.n73 VSS.n48 0.00366734
R378 VSS.n185 VSS.n184 0.00366734
R379 VSS.n128 VSS.n84 0.00366734
R380 VSS.n6 VSS.n5 0.00267122
R381 VSS.n75 VSS.n40 0.00366299
R382 VSS.n184 VSS.n81 0.00366128
R383 VSS.n129 VSS.n84 0.00366128
R384 VSS.n8 VSS.n30 0.00354385
R385 VSS.n76 VSS.n75 0.00341687
R386 VSS.n73 VSS.n45 0.00341095
R387 VSS.n34 VSS.n9 0.00299994
R388 VSS.n10 VSS.n9 0.002
R389 VSS.n19 VSS.n26 425.315
R390 VSS.n21 VSS.n186 1160.89
R391 VSS.n166 VSS.n3 1.77167
R392 VSS.n171 VSS.n0 1.0427
R393 ENA_BH.n0 ENA_BH.n5 18.5348
R394 x3.MM11.S ENA_BH.t0 17.0724
R395 x3.MM11.S ENA_BH.t0 17.0724
R396 MM25.G ENA_BH.t11 15.0005
R397 MM25.G ENA_BH.t12 15.0005
R398 ENA_BH.t13 MM25.G 15.0005
R399 MM25.G ENA_BH.t14 15.0005
R400 MM25.G ENA_BH.t15 15.0005
R401 MM25.G ENA_BH.t16 15.0005
R402 ENA_BH.n46 ENA_BH.t16 15.0005
R403 ENA_BH.n45 ENA_BH.t15 15.0005
R404 ENA_BH.n29 ENA_BH.t14 15.0005
R405 ENA_BH.n44 ENA_BH.t13 15.0005
R406 ENA_BH.n43 ENA_BH.t12 15.0005
R407 ENA_BH.n42 ENA_BH.t11 15.0005
R408 MM3.G ENA_BH.t19 15.0005
R409 MM3.G ENA_BH.t20 15.0005
R410 MM3.G ENA_BH.t21 15.0005
R411 MM3.G ENA_BH.t22 15.0005
R412 MM3.G ENA_BH.t23 15.0005
R413 MM3.G ENA_BH.t24 15.0005
R414 ENA_BH.n7 ENA_BH.t24 15.0005
R415 ENA_BH.n7 ENA_BH.t23 15.0005
R416 ENA_BH.n7 ENA_BH.t22 15.0005
R417 ENA_BH.t21 ENA_BH.n6 15.0005
R418 ENA_BH.n6 ENA_BH.t20 15.0005
R419 ENA_BH.n6 ENA_BH.t19 15.0005
R420 ENA_BH.n36 ENA_BH.t3 15.0005
R421 ENA_BH.t4 ENA_BH.n38 15.0005
R422 ENA_BH.t5 ENA_BH.n35 15.0005
R423 ENA_BH.n39 ENA_BH.t6 15.0005
R424 ENA_BH.t7 ENA_BH.n34 15.0005
R425 ENA_BH.n40 ENA_BH.t8 15.0005
R426 ENA_BH.t8 MM21.G 15.0005
R427 MM21.G ENA_BH.t7 15.0005
R428 ENA_BH.t6 MM21.G 15.0005
R429 MM21.G ENA_BH.t5 15.0005
R430 MM21.G ENA_BH.t4 15.0005
R431 ENA_BH.t3 MM21.G 15.0005
R432 ENA_BH.n3 ENA_BH.n9 9.63245
R433 ENA_BH.n10 ENA_BH.n3 9.56831
R434 ENA_BH.n2 ENA_BH.n9 9.48329
R435 ENA_BH.n8 ENA_BH.n9 9.47509
R436 ENA_BH.n8 ENA_BH.n10 9.47509
R437 ENA_BH.n10 ENA_BH.n1 9.3856
R438 ENA_BH.n1 ENA_BH.n9 9.1243
R439 ENA_BH.n10 ENA_BH.n2 9.03406
R440 x3.MM11.S x3.HI_B 9.01319
R441 ENA_BH.n5 ENA_BH.n22 4.38436
R442 MM3.G ENA_BH.n22 0.234272
R443 MM3.G ENA_BH.n23 0.234272
R444 ENA_BH.n5 ENA_BH.n23 4.38436
R445 ENA_BH.n24 MM3.G 0.234272
R446 ENA_BH.n24 ENA_BH.n5 4.38436
R447 MM3.G ENA_BH.n25 0.234272
R448 ENA_BH.n25 ENA_BH.n5 4.38436
R449 ENA_BH.n8 ENA_BH.n12 4.38436
R450 MM25.G ENA_BH.n12 0.234272
R451 MM25.G ENA_BH.n26 0.234272
R452 ENA_BH.n8 ENA_BH.n26 4.38436
R453 ENA_BH.n27 MM25.G 0.234272
R454 ENA_BH.n27 ENA_BH.n8 4.38436
R455 MM25.G ENA_BH.n28 0.234272
R456 ENA_BH.n8 ENA_BH.n28 4.38436
R457 ENA_BH.n40 ENA_BH.n14 0.24668
R458 ENA_BH.n15 ENA_BH.n34 0.24668
R459 ENA_BH.n3 ENA_BH.n15 4.37816
R460 ENA_BH.n35 ENA_BH.n16 0.24668
R461 ENA_BH.n16 ENA_BH.n3 4.37816
R462 ENA_BH.n17 ENA_BH.n36 0.24668
R463 ENA_BH.n3 ENA_BH.n17 4.37816
R464 ENA_BH.n0 ENA_BH.n4 0.681681
R465 ENA_BH.n4 ENA_BH.n6 0.96373
R466 ENA_BH.n1 ENA_BH.n11 4.38436
R467 ENA_BH.n46 ENA_BH.n11 0.234272
R468 ENA_BH.n45 ENA_BH.n30 0.234272
R469 ENA_BH.n1 ENA_BH.n30 4.38436
R470 ENA_BH.n31 ENA_BH.n44 0.234272
R471 ENA_BH.n31 ENA_BH.n1 4.38436
R472 ENA_BH.n42 ENA_BH.n33 0.234272
R473 ENA_BH.n1 ENA_BH.n33 4.38436
R474 ENA_BH.n13 MM21.G 0.24668
R475 ENA_BH.n18 MM21.G 0.24668
R476 ENA_BH.n18 ENA_BH.n2 4.37816
R477 ENA_BH.n19 MM21.G 0.24668
R478 ENA_BH.n2 ENA_BH.n19 4.37816
R479 MM21.G ENA_BH.n20 0.24668
R480 ENA_BH.n20 ENA_BH.n2 4.37816
R481 x3.MM12.S ENA_BH.t1 8.53746
R482 ENA_BH.n32 ENA_BH.t10 6.73043
R483 ENA_BH.n47 ENA_BH.t17 6.73043
R484 ENA_BH.n48 ENA_BH.t18 6.73043
R485 ENA_BH.n21 ENA_BH.t25 6.73043
R486 ENA_BH.n37 ENA_BH.t2 6.67035
R487 ENA_BH.n41 ENA_BH.t9 6.67035
R488 ENA_BH.n14 ENA_BH.n3 5.24474
R489 ENA_BH.n2 ENA_BH.n13 5.24474
R490 x3.HI_B x3.MM12.S 4.67503
R491 ENA_BH.n8 ENA_BH.n5 2.3586
R492 ENA_BH.n1 ENA_BH.n0 2.23481
R493 x3.HI_B ENA_BH.n8 2.03526
R494 ENA_BH.n37 MM21.G 1.66229
R495 ENA_BH.n17 ENA_BH.n37 1.90847
R496 MM21.G ENA_BH.n41 1.66229
R497 ENA_BH.n33 ENA_BH.n32 1.77591
R498 MM25.G ENA_BH.n32 1.54213
R499 ENA_BH.n47 MM25.G 1.54213
R500 ENA_BH.n6 ENA_BH.n48 1.77591
R501 MM3.G ENA_BH.n48 1.54213
R502 MM3.G ENA_BH.n21 1.54213
R503 ENA_BH.n38 ENA_BH.n36 0.505649
R504 ENA_BH.n38 ENA_BH.n16 0.24668
R505 ENA_BH.n39 ENA_BH.n35 0.505649
R506 ENA_BH.n39 ENA_BH.n15 0.24668
R507 ENA_BH.n40 ENA_BH.n34 0.505649
R508 ENA_BH.n41 ENA_BH.n14 1.90847
R509 MM21.G ENA_BH.n13 0.24668
R510 MM21.G ENA_BH.n18 0.24668
R511 MM21.G ENA_BH.n19 0.24668
R512 MM21.G ENA_BH.n20 0.24668
R513 MM25.G ENA_BH.n28 0.234272
R514 MM25.G ENA_BH.n27 0.234272
R515 MM25.G ENA_BH.n26 0.234272
R516 ENA_BH.n12 MM25.G 0.234272
R517 ENA_BH.n47 ENA_BH.n11 1.77591
R518 ENA_BH.n46 ENA_BH.n45 0.479458
R519 ENA_BH.n30 ENA_BH.n29 0.234272
R520 ENA_BH.n44 ENA_BH.n29 0.479458
R521 ENA_BH.n31 ENA_BH.n43 0.234272
R522 ENA_BH.n43 ENA_BH.n42 0.479458
R523 ENA_BH.n25 MM3.G 0.234272
R524 ENA_BH.n24 MM3.G 0.234272
R525 ENA_BH.n23 MM3.G 0.234272
R526 MM3.G ENA_BH.n22 0.234272
R527 ENA_BH.n7 ENA_BH.n21 1.77591
R528 ENA_BH.n4 ENA_BH.n7 1.12498
C0 x3.IM_B ENA_H 0.59753f
C1 x3.IM ENA_H 0.02044f
C2 STDBY_H x4.LO_BB 0.0268f
C3 x3.IM_B x3.LO_B 0.04605f
C4 IBIAS EG_AVDD 0.0126f
C5 AVDD x4.LO_BB 0.10944f
C6 x3.IM x3.LO_B 0.23952f
C7 x3.LO_BB DVDD 0.24482f
C8 STDBY_H x4.HI_B 0.51678f
C9 DVDD STDBY 7.05552f
C10 AVDD x4.HI_B 0.16996f
C11 x4.IM_B DVDD 0.03259f
C12 IBIAS EG_IBIAS 1.81959f
C13 x4.LO_BB x4.IM 0.13907f
C14 x4.LO_B STDBY_H 0.01156f
C15 x4.LO_B AVDD 0.07009f
C16 x4.LO_B x4.IM 0.23952f
C17 STDBY_H SG_AVDD 3.82262f
C18 AVDD SG_AVDD 1.91079f
C19 x3.IM_B DVDD 0.0193f
C20 x4.IM_B STDBY 0.01138f
C21 STDBY_H AVDD 8.77835f
C22 AVDD x4.IM 1.64095f
C23 AVDD ENA 0.16456f
C24 x3.LO_BB x3.IM_B 0.45949f
C25 x3.LO_BB x3.IM 0.13907f
C26 DVDD x4.LO_BB 0.28481f
C27 AVDD ENA_H 6.99244f
C28 DVDD SG_DVDD 3.02603f
C29 AVDD x3.LO_B 0.38997f
C30 DVDD x4.HI_B 0.1867f
C31 x4.LO_B DVDD 2.02298f
C32 EG_AVDD SG_AVDD 0.01311f
C33 x3.LO_B ENA 0.6001f
C34 x3.IM_B x3.IM 0.66406f
C35 STDBY x4.LO_BB 0.03827f
C36 AVDD EG_AVDD 1.92131f
C37 x4.IM_B x4.LO_BB 0.45949f
C38 STDBY SG_DVDD 2.7984f
C39 x3.LO_B ENA_H 0.03706f
C40 STDBY_H DVDD 0.94708f
C41 DVDD AVDD 5.10961f
C42 AVDD EG_IBIAS 0.05482f
C43 x4.LO_B STDBY 0.68245f
C44 x4.IM_B x4.LO_B 0.04605f
C45 DVDD x4.IM 0.02129f
C46 DVDD ENA 1.24426f
C47 STDBY SG_AVDD 0.02894f
C48 x3.LO_BB AVDD 0.14031f
C49 STDBY_H STDBY 0.61074f
C50 AVDD STDBY 0.22245f
C51 x4.IM_B STDBY_H 0.61359f
C52 EG_IBIAS ENA_H 0.08518f
C53 x4.IM_B AVDD 2.97099f
C54 IBIAS AVDD 0.22807f
C55 DVDD x3.LO_B 1.65707f
C56 x4.IM_B x4.IM 0.66406f
C57 STDBY DOUT 0.78728f
C58 x3.IM_B AVDD 2.97518f
C59 x3.LO_BB ENA_H 0.0294f
C60 AVDD x3.IM 1.63605f
C61 x3.LO_BB x3.LO_B 0.82331f
C62 IBIAS ENA_H 2.03439f
C63 x4.LO_B x4.LO_BB 0.82331f
C64 SG_DVDD SG_AVDD 0.01148f
C65 DOUT VSS 2.97283f
C66 SG_DVDD VSS 3.06488f
C67 SG_AVDD VSS 8.19028f
C68 EG_AVDD VSS 5.48614f
C69 IBIAS VSS 6.3651f
C70 EG_IBIAS VSS 1.38337f
C71 AVDD VSS 2.89361p
C72 DVDD VSS 2.89375p
C73 x4.HI_B VSS 0.44871f
C74 x4.IM_B VSS 0.67419f
C75 x3.IM VSS 0.09833f
C76 x3.IM_B VSS 1.90924f
C77 x3.HI_B VSS 0.4969f
C78 ENA_BH.n0 VSS 1.27633f
C79 ENA_BH.n1 VSS 1.15943f
C80 ENA_BH.n2 VSS 0.96151f
C81 ENA_BH.n3 VSS 0.9934f
C82 ENA_BH.n5 VSS 1.27633f
C83 ENA_BH.n6 VSS 0.18817f
C84 ENA_BH.n7 VSS 0.18817f
C85 ENA_BH.n8 VSS 1.25153f
C86 ENA_BH.n9 VSS 1.33337f
C87 ENA_BH.n10 VSS 1.3304f
C88 ENA_BH.n11 VSS 0.0948f
C89 ENA_BH.n14 VSS 0.10318f
C90 ENA_BH.n17 VSS 0.10318f
C91 ENA_BH.n21 VSS 0.01437f
C92 MM3.G VSS 0.40509f
C93 ENA_BH.n29 VSS 0.03113f
C94 ENA_BH.n32 VSS 0.01437f
C95 ENA_BH.n33 VSS 0.0948f
C96 MM25.G VSS 0.40509f
C97 ENA_BH.t0 VSS 0.05961f
C98 MM21.G VSS 0.43747f
C99 ENA_BH.n34 VSS 0.03342f
C100 ENA_BH.n35 VSS 0.03342f
C101 ENA_BH.n36 VSS 0.03342f
C102 ENA_BH.n37 VSS 0.01529f
C103 ENA_BH.n38 VSS 0.03342f
C104 ENA_BH.n39 VSS 0.03342f
C105 ENA_BH.n40 VSS 0.03342f
C106 ENA_BH.n41 VSS 0.01529f
C107 ENA_BH.n42 VSS 0.03113f
C108 ENA_BH.n43 VSS 0.03113f
C109 ENA_BH.n44 VSS 0.03113f
C110 ENA_BH.n45 VSS 0.03113f
C111 ENA_BH.n46 VSS 0.03113f
C112 ENA_BH.n47 VSS 0.01437f
C113 ENA_BH.n48 VSS 0.01437f
C114 ENA_BH.t1 VSS 0.06707f
C115 x3.MM12.S VSS 0.04479f
C116 x3.MM11.S VSS 0.0375f
C117 VSS.t5 VSS 0.21359f
C118 VSS.t29 VSS 0.70481f
C119 VSS.t13 VSS 1.92427f
C120 VSS.t18 VSS 1.90924f
C121 VSS.t23 VSS 1.04656f
C122 VSS.t9 VSS 4.87351f
C123 VSS.t25 VSS 3.37299f
C124 VSS.t20 VSS 1.68649f
C125 VSS.t53 VSS 0.84325f
C126 VSS.t3 VSS 1.28156f
C127 VSS.t1 VSS 3.31728f
.ends
