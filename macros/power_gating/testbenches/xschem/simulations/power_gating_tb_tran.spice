** sch_path: /foss/designs/sg13cmos5l_slot3_backup/macros/power_gating/testbenches/xschem/power_gating_tb_tran.sch
**.subckt power_gating_tb_tran
x1 DOUT SG_AVDD DVDD EG_IBIAS SG_DVDD AVDD IBIAS EG_AVDD ENA STDBY GND power_gating
VAVDD AVDD GND {AVDD}
VDVDD DVDD GND {DVDD}
IBIAS GND IBIAS {IBIAS}
VENA ENA GND PWL(0 0 10u 0 10.01u 1.2 20u 1.2 20.01u 0 50u 0 50.01u 1.2 60u 1.2 60.01u 0 70u 0)
VSTDBY STDBY GND PWL(0 0 30u 0 30.01u 1.2 40u 1.2 40.01u 0 50u 0 50.01u 1.2 60u 1.2 60.01u 0 70u 0)
Vmeas_ibias EG_IBIAS net1 0
.save i(vmeas_ibias)
VCOMPL net1 GND 1.0
**** begin user architecture code

.include ../../../netlist/pex/power_gating_magic_pex_3.spice
.param AVDD=3.3
.csparam AVDD=AVDD
.param DVDD=1.2
.csparam DVDD=DVDD
.param IBIAS=1u
.csparam IBIAS=IBIAS
.temp 27
.options savecurrents klu method=gear reltol=1e-4 abstol=1e-15 gmin=1e-15
.control

save all

* Operating Point Analysis
op
remzerovec
write power_gating_tb_tran.raw
set appendwrite

* Transient Analysis: ENA/STDBY sweep, each combination held 10us,
* with a return to 00 between each non-00 state to avoid carryover:
* 00 (0-10u) -> 10 (10-20u) -> 00 (20-30u) -> 01 (30-40u) -> 00 (40-50u) -> 11 (50-60u) -> 00 (60-70u)
tran 1n 70u
write power_gating_tb_tran.raw

* Plotting
plot ena stdby
plot eg_avdd sg_avdd
plot sg_dvdd
plot eg_ibias dout

* Write Data
unset appendwrite
set wr_vecnames
set wr_singlescale
wrdata ../plot_simulations/data/power_gating_tb_tran.txt v(ena) v(stdby) v(eg_avdd) v(sg_avdd) v(sg_dvdd) v(eg_ibias) v(dout) i(vmeas_ibias)

*quit
.endc

.lib cornerMOSlv.lib mos_tt
.lib cornerMOShv.lib mos_tt
.lib cornerRES.lib res_typ
.lib cornerCAP.lib cap_typ
.lib cornerDIO.lib dio_tt

.include power_gating_tb_tran.save

**** end user architecture code
**.ends

* expanding   symbol:  power_gating.sym # of pins=11
** sym_path: /foss/designs/sg13cmos5l_slot3_backup/macros/power_gating/schematic/xschem/power_gating.sym
** sch_path: /foss/designs/sg13cmos5l_slot3_backup/macros/power_gating/schematic/xschem/power_gating.sch
.subckt power_gating DOUT SG_AVDD DVDD EG_IBIAS SG_DVDD AVDD IBIAS EG_AVDD ENA STDBY VSS
*.iopin DVDD
*.iopin VSS
*.iopin AVDD
*.ipin ENA
*.ipin STDBY
*.opin DOUT
*.ipin IBIAS
*.iopin EG_AVDD
*.iopin SG_AVDD
*.iopin SG_DVDD
*.opin EG_IBIAS
x3 AVDD ENA_B DVDD ENA ENA_H VSS ENA_BH level_shifter
x4 AVDD STDBY_B DVDD STDBY STDBY_H VSS STDBY_BH level_shifter
XC3 VSS AVDD cap_cmomf w=30.0e-6 l=75.0e-6 mmin=1 mmax=4 subblock=0 m=1 mm_ok=1
XC4 VSS DVDD cap_cmomf w=30.0e-6 l=75.0e-6 mmin=1 mmax=4 subblock=0 m=1 mm_ok=1
XM2 EG_IBIAS ENA_BH net1 AVDD sg13_hv_pmos w=25.6u l=0.4u ng=8 m=1 mm_ok=1
XM1 SG_AVDD STDBY_H AVDD AVDD sg13_hv_pmos w=25.6u l=0.4u ng=8 m=1 mm_ok=1
XM25 EG_AVDD ENA_BH AVDD AVDD sg13_hv_pmos w=25.6u l=0.4u ng=8 m=1 mm_ok=1
XM9 SG_AVDD STDBY_H VSS VSS sg13_hv_nmos w=28.8u l=0.45u ng=8 m=1 mm_ok=1
XM21 EG_AVDD ENA_BH VSS VSS sg13_hv_nmos w=28.8u l=0.45u ng=8 m=1 mm_ok=1
XM27 SG_DVDD STDBY DVDD DVDD sg13_lv_pmos w=27.76u l=0.13u ng=8 m=1 mm_ok=1
XM18 SG_DVDD STDBY VSS VSS sg13_lv_nmos w=27.76u l=0.13u ng=8 m=1 mm_ok=1
XM4 DOUT STDBY VSS VSS sg13_lv_nmos w=27.76u l=0.13u ng=8 m=1 mm_ok=1
Vmeas1 IBIAS net1 0
.save i(vmeas1)
Vmeas2 IBIAS net2 0
.save i(vmeas2)
XM3 VSS ENA_H net2 AVDD sg13_hv_pmos w=25.6u l=0.4u ng=8 m=1 mm_ok=1
.ends

* expanding   symbol:  level_shifter.sym # of pins=7
** sym_path: /foss/designs/sg13cmos5l_slot3_backup/macros/level_shifter/schematic/xschem/level_shifter.sym
** sch_path: /foss/designs/sg13cmos5l_slot3_backup/macros/level_shifter/schematic/xschem/level_shifter.sch
.subckt level_shifter AVDD LO_B DVDD LO HI VSS HI_B
*.iopin DVDD
*.iopin VSS
*.iopin AVDD
*.ipin LO
*.opin LO_B
*.opin HI
*.opin HI_B
XM1 IM_B IM AVDD AVDD sg13_hv_pmos w=0.8u l=0.4u ng=1 m=1 mm_ok=1
XM2 IM_B LO_BB VSS VSS sg13_hv_nmos w=0.9u l=0.45u ng=1 m=1 mm_ok=1
XM3 IM IM_B AVDD AVDD sg13_hv_pmos w=0.8u l=0.4u ng=1 m=1 mm_ok=1
XM4 IM LO_B VSS VSS sg13_hv_nmos w=0.9u l=0.45u ng=1 m=1 mm_ok=1
XM5 LO_B LO DVDD DVDD sg13_lv_pmos w=0.87u l=0.13u ng=1 m=1 mm_ok=1
XM6 LO_B LO VSS VSS sg13_lv_nmos w=0.87u l=0.13u ng=1 m=1 mm_ok=1
XM7 LO_BB LO_B DVDD DVDD sg13_lv_pmos w=0.87u l=0.13u ng=1 m=1 mm_ok=1
XM8 LO_BB LO_B VSS VSS sg13_lv_nmos w=0.87u l=0.13u ng=1 m=1 mm_ok=1
XM9 HI IM_B AVDD AVDD sg13_hv_pmos w=0.8u l=0.4u ng=1 m=1 mm_ok=1
XM10 HI IM_B VSS VSS sg13_hv_nmos w=0.9u l=0.45u ng=1 m=1 mm_ok=1
XM11 HI_B HI AVDD AVDD sg13_hv_pmos w=0.8u l=0.4u ng=1 m=1 mm_ok=1
XM12 HI_B HI VSS VSS sg13_hv_nmos w=0.9u l=0.45u ng=1 m=1 mm_ok=1
.ends

.end
