** sch_path: /foss/designs/sg13cmos5l_slot3_backup/macros/resistor_network/testbenches/xschem/tb_resistor_network_pex.sch
**.subckt tb_resistor_network_pex
v_vdd vdd_net GND dc {xvdd}
x1 vdd_net GND vdd_net p1_net p2_net GND resistor_network_pex
**** begin user architecture code

.lib $PDK_ROOT/$PDK/libs.tech/ngspice/models/cornerMOShv.lib mos_tt
.lib $PDK_ROOT/$PDK/libs.tech/ngspice/models/cornerRES.lib res_typ
.include ../../../netlist/pex/resistor_network_magic_pex_3.spice

.op
.control
  run
  let itest = -i(v_vdd)
  let r_top = (v(vdd_net) - v(p1_net)) / itest
  let r_mid = (v(p1_net) - v(p2_net)) / itest
  let r_bot = v(p2_net) / itest
  let rtotal = v(vdd_net) / itest
  print itest
  print r_top
  print r_mid
  print r_bot
  print rtotal
.endc

.param xvdd = 3.3

**** end user architecture code
**.ends
.GLOBAL GND
.end
