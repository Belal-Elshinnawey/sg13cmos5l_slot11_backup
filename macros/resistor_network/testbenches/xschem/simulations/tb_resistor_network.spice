** sch_path: /foss/designs/sg13cmos5l_slot3_backup/macros/resistor_network/testbenches/xschem/tb_resistor_network.sch
**.subckt tb_resistor_network
v_vdd vdd_net GND dc {xvdd}
x1 vdd_net GND vdd_net p1_net p2_net GND resistor_network
**** begin user architecture code

.lib $PDK_ROOT/$PDK/libs.tech/ngspice/models/cornerMOShv.lib mos_tt
.lib $PDK_ROOT/$PDK/libs.tech/ngspice/models/cornerRES.lib res_typ

.op
.control
  run
  let itest = -i(v_vdd)
  let r_top = (v(vdd_net) - v(p1_net)) / itest
  let r_mid = (v(p1_net) - v(p2_net)) / itest
  let r_bot = v(p2_net) / itest
  let rtotal = v(vdd_net) / itest
  print itest
  print r_top
  print r_mid
  print r_bot
  print rtotal
.endc

.param xvdd = 3.3

**** end user architecture code
**.ends

* expanding   symbol:  resistor_network.sym # of pins=6
** sym_path: /foss/designs/sg13cmos5l_slot3_backup/macros/resistor_network/schematic/xschem/resistor_network.sym
** sch_path: /foss/designs/sg13cmos5l_slot3_backup/macros/resistor_network/schematic/xschem/resistor_network.sch
.subckt resistor_network pt VSS VDD p1 p2 pb
*.iopin pt
*.iopin VDD
*.iopin VSS
*.iopin p1
*.iopin p2
*.iopin pb
xA pt VSS VDD a_p1 p1 n_ab resistor_leg
xB n_ab VSS VDD p2 b_p2 pb resistor_leg
xC pt VSS VDD c_p1 p1 n_cd resistor_leg
xD n_cd VSS VDD p2 d_p2 pb resistor_leg
.ends

* expanding   symbol:  resistor_leg.sym # of pins=6
** sym_path: /foss/designs/sg13cmos5l_slot3_backup/macros/resistor_network/schematic/xschem/resistor_leg.sym
** sch_path: /foss/designs/sg13cmos5l_slot3_backup/macros/resistor_network/schematic/xschem/resistor_leg.sch
.subckt resistor_leg pt VSS VDD p1 p2 pb
*.iopin pt
*.iopin pb
*.iopin p2
*.iopin p1
*.iopin VDD
*.iopin VSS
XR1 pt p1 VDD rhigh w=0.5e-6 l=13.42e-6 m=8 b=0 mm_ok=1
XR2 p1 p2 VDD rhigh w=0.5e-6 l=13.42e-6 m=8 b=0 mm_ok=1
XR3 p2 pb VDD rhigh w=0.5e-6 l=13.42e-6 m=8 b=0 mm_ok=1
XRdummy VSS VSS VDD rhigh w=0.5e-6 l=13.42e-6 m=24 b=0 mm_ok=1
.ends

.GLOBAL GND
.end
