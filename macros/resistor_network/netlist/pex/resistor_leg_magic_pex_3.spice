* PEX produced on Sun Nov  8 11:31:04 AM CET 2026 using /foss/tools/sak/sak-pex.sh with m=3 and s=1 (extresist threshold=10000 mOhm, minres=1000 mOhm, mindelay=1 ps)
* NGSPICE file created from resistor_leg_pex.ext - technology: ihp-sg13cmos5l

.subckt resistor_leg_pex pt VSS VDD p1 p2 pb
X0 p1 pt VDD.t0 rhigh l=13.42u w=0.5u
X1 VSS VSS VDD.t0 rhigh l=13.42u w=0.5u
X2 p2 pb VDD.t0 rhigh l=13.42u w=0.5u
X3 p2 p1 VDD.t0 rhigh l=13.42u w=0.5u
X4 VSS VSS VDD.t0 rhigh l=13.42u w=0.5u
X5 VSS VSS VDD.t0 rhigh l=13.42u w=0.5u
X6 VSS VSS VDD.t0 rhigh l=13.42u w=0.5u
X7 VSS VSS VDD.t0 rhigh l=13.42u w=0.5u
X8 VSS VSS VDD.t0 rhigh l=13.42u w=0.5u
X9 VSS VSS VDD.t0 rhigh l=13.42u w=0.5u
X10 p2 p1 VDD.t0 rhigh l=13.42u w=0.5u
X11 pt p1 VDD.t0 rhigh l=13.42u w=0.5u
X12 p2 p1 VDD.t0 rhigh l=13.42u w=0.5u
X13 pt p1 VDD.t0 rhigh l=13.42u w=0.5u
X14 VSS VSS VDD.t0 rhigh l=13.42u w=0.5u
X15 pb p2 VDD.t0 rhigh l=13.42u w=0.5u
X16 VSS VSS VDD.t0 rhigh l=13.42u w=0.5u
X17 pt p1 VDD.t0 rhigh l=13.42u w=0.5u
X18 pb p2 VDD.t0 rhigh l=13.42u w=0.5u
X19 VSS VSS VDD.t0 rhigh l=13.42u w=0.5u
X20 p2 pb VDD.t0 rhigh l=13.42u w=0.5u
X21 p2 p1 VDD.t0 rhigh l=13.42u w=0.5u
X22 VSS VSS VDD.t0 rhigh l=13.42u w=0.5u
X23 VSS VSS VDD.t0 rhigh l=13.42u w=0.5u
X24 VSS VSS VDD.t0 rhigh l=13.42u w=0.5u
X25 p2 pb VDD.t0 rhigh l=13.42u w=0.5u
X26 VSS VSS VDD.t0 rhigh l=13.42u w=0.5u
X27 p1 p2 VDD.t0 rhigh l=13.42u w=0.5u
X28 VSS VSS VDD.t0 rhigh l=13.42u w=0.5u
X29 VSS VSS VDD.t0 rhigh l=13.42u w=0.5u
X30 pt p1 VDD.t0 rhigh l=13.42u w=0.5u
X31 VSS VSS VDD.t0 rhigh l=13.42u w=0.5u
X32 VSS VSS VDD.t0 rhigh l=13.42u w=0.5u
X33 p1 pt VDD.t0 rhigh l=13.42u w=0.5u
X34 p1 p2 VDD.t0 rhigh l=13.42u w=0.5u
X35 pb p2 VDD.t0 rhigh l=13.42u w=0.5u
X36 VSS VSS VDD.t0 rhigh l=13.42u w=0.5u
X37 p1 pt VDD.t0 rhigh l=13.42u w=0.5u
X38 VSS VSS VDD.t0 rhigh l=13.42u w=0.5u
X39 VSS VSS VDD.t0 rhigh l=13.42u w=0.5u
X40 p1 p2 VDD.t0 rhigh l=13.42u w=0.5u
X41 pb p2 VDD.t0 rhigh l=13.42u w=0.5u
X42 p1 p2 VDD.t0 rhigh l=13.42u w=0.5u
X43 VSS VSS VDD.t0 rhigh l=13.42u w=0.5u
X44 VSS VSS VDD.t0 rhigh l=13.42u w=0.5u
X45 p2 pb VDD.t0 rhigh l=13.42u w=0.5u
X46 VSS VSS VDD.t0 rhigh l=13.42u w=0.5u
X47 p1 pt VDD.t0 rhigh l=13.42u w=0.5u
R0 VDD.n2 VDD.n6 1.49427
R1 VDD.n4 VDD.t0 0.0687655
R2 VDD.n3 VDD.t0 0.227626
R3 VDD.n3 VDD.n8 1.1769
R4 VDD.n9 VDD.n8 0.7505
R5 VDD.n6 VDD.n5 0.7505
R6 VDD.n7 VDD.n0 1.14498
R7 VDD.n7 VDD.n5 0.540644
R8 VDD.n9 VDD.n5 0.527092
R9 VDD.n3 VDD.n1 2.05841
R10 VDD.n4 VDD.n6 1.33902
R11 VDD.n1 VDD.n9 0.210996
R12 VDD.t0 VDD.n0 0.0203141
R13 VDD.n8 VDD.n4 1.45907
R14 VDD.n7 VDD.n2 1.43925
R15 VDD.n2 VDD.t0 0.196956
R16 VDD.n0 VDD.n1 1.06905
R17 VDD VDD.t0 0.0005
C0 VDD a_6430_n8196# 1.33134f
C1 a_5890_3876# a_5620_3876# 0.30437f
C2 a_6430_n5178# VSS 0.06505f
C3 VDD a_5890_6894# 1.33142f
C4 VDD a_6160_n2160# 1.34725f
C5 VSS a_4810_858# 0.68809f
C6 a_6160_n2160# p1 0.29404f
C7 a_5080_6894# a_4810_6894# 0.30437f
C8 a_6700_n8196# a_6430_n8196# 0.30437f
C9 VDD pb 3.81685f
C10 pb p1 2.63577f
C11 a_5350_n2160# pt 0.09693f
C12 VDD a_6160_n8196# 1.33134f
C13 a_6160_n5178# VSS 0.01114f
C14 VDD a_6700_858# 1.50711f
C15 a_6430_858# VSS 0.05629f
C16 a_4810_3876# a_5080_3876# 0.30437f
C17 a_5890_n5178# pt 0.12211f
C18 pt p2 2.02543f
C19 VDD p1 6.60277f
C20 a_4810_3876# VSS 0.68809f
C21 a_5890_3876# pb 0.07531f
C22 a_5080_n2160# pb 0.19811f
C23 VDD a_4810_n8190# 1.49013f
C24 pt a_5080_n5178# 0.24531f
C25 VDD a_6700_n8196# 1.49271f
C26 pt a_6160_858# 0.08551f
C27 a_5350_n2160# p2 0.09078f
C28 VDD a_5890_3876# 1.33651f
C29 VDD a_5080_858# 1.33487f
C30 a_5890_3876# p1 0.35346f
C31 p1 a_5080_858# 0.1023f
C32 VDD a_5080_n2160# 1.33589f
C33 a_5080_n2160# p1 0.02314f
C34 a_5620_n8196# VSS 0.89634f
C35 a_6160_n2160# a_6430_n2160# 0.30437f
C36 a_5890_n5178# p2 0.05404f
C37 a_5620_n2160# pt 0.04982f
C38 a_5350_858# pt 0.02531f
C39 a_6430_3876# a_6700_3876# 0.30437f
C40 VSS a_6430_n8196# 0.89634f
C41 pb a_6430_n2160# 0.05228f
C42 VDD a_4810_n2160# 1.50688f
C43 VDD a_5080_n8196# 1.33134f
C44 a_5890_6894# VSS 0.89585f
C45 a_6160_n2160# VSS 0.01227f
C46 pb a_5080_3876# 0.01183f
C47 p2 a_6160_858# 0.14836f
C48 VDD a_6430_6894# 1.3315f
C49 a_5350_n2160# a_5620_n2160# 0.30437f
C50 pb VSS 0.5f
C51 a_4810_n8190# a_5080_n8196# 0.30369f
C52 a_5620_6894# a_5350_6894# 0.30437f
C53 VDD a_6430_n2160# 1.36025f
C54 a_5620_858# pb 0.06469f
C55 a_6430_n2160# p1 0.17395f
C56 VSS a_6160_n8196# 0.89634f
C57 a_6160_3876# p2 0.34222f
C58 a_6700_858# VSS 0.7044f
C59 VDD a_5080_3876# 1.34046f
C60 p1 a_5080_3876# 0.04257f
C61 a_5080_n2160# a_4810_n2160# 0.30437f
C62 a_5620_n2160# p2 0.2364f
C63 a_5890_n2160# pt 0.05102f
C64 a_6430_3876# p2 0.13689f
C65 a_5350_858# p2 0.13619f
C66 VDD VSS 46.6629f
C67 VSS p1 0.76836f
C68 VDD a_5620_858# 1.33276f
C69 a_5620_858# p1 0.16894f
C70 a_5080_n5178# a_4810_n5178# 0.30437f
C71 a_5350_3876# a_5620_3876# 0.30437f
C72 a_5350_6894# a_5080_6894# 0.30437f
C73 VSS a_4810_n8190# 0.87306f
C74 a_6430_858# pt 0.13568f
C75 a_6700_n8196# VSS 0.88869f
C76 pb a_5890_858# 0.06919f
C77 VSS a_5080_858# 0.04789f
C78 a_5080_n2160# VSS 0.04173f
C79 a_6430_3876# a_6160_3876# 0.30437f
C80 VDD a_5890_858# 1.34056f
C81 a_6430_n5178# p2 0.32224f
C82 p1 a_5890_858# 0.15772f
C83 a_5890_n2160# p2 0.23663f
C84 pt a_5620_3876# 0.05194f
C85 a_5350_3876# pb 0.04774f
C86 a_5620_n5178# pt 0.11113f
C87 VDD a_4810_6894# 1.49506f
C88 a_6160_n5178# a_5890_n5178# 0.30437f
C89 VSS a_4810_n2160# 0.68809f
C90 a_6160_n5178# p2 0.12563f
C91 VSS a_5080_n8196# 0.89702f
C92 a_6430_858# p2 0.0179f
C93 VSS a_6430_6894# 0.89601f
C94 VDD a_5350_3876# 1.33532f
C95 VDD a_6700_n2160# 1.50711f
C96 a_5350_3876# p1 0.19648f
C97 a_6430_n2160# VSS 0.06219f
C98 a_5350_n5178# pt 0.12531f
C99 VSS a_5080_3876# 0.08249f
C100 a_6430_858# a_6160_858# 0.30437f
C101 a_5890_n2160# a_5620_n2160# 0.30437f
C102 a_6430_n5178# a_6700_n5178# 0.30437f
C103 a_6160_n2160# pt 0.04651f
C104 a_5890_n5178# a_5620_n5178# 0.30437f
C105 a_5620_3876# p2 0.12153f
C106 a_5620_n5178# p2 0.05204f
C107 pb pt 0.61713f
C108 a_5890_6894# a_6160_6894# 0.30437f
C109 a_5890_n8196# a_5620_n8196# 0.30437f
C110 VDD pt 4.61766f
C111 pt p1 5.15359f
C112 VDD a_6700_3876# 1.50711f
C113 a_5350_n5178# p2 0.26451f
C114 a_5350_n2160# pb 0.06142f
C115 a_6160_n2160# p2 0.1294f
C116 a_5620_858# a_5890_858# 0.30437f
C117 a_5620_n8196# a_5350_n8196# 0.30437f
C118 VDD a_6160_6894# 1.33144f
C119 a_5350_n5178# a_5080_n5178# 0.30437f
C120 a_6430_n5178# a_6160_n5178# 0.30437f
C121 pb p2 2.62804f
C122 a_5890_6894# a_5620_6894# 0.30437f
C123 VSS a_4810_6894# 0.87197f
C124 a_5350_n2160# VDD 1.33134f
C125 a_5350_n2160# p1 0.28205f
C126 a_5890_3876# pt 0.04603f
C127 a_6700_n2160# a_6430_n2160# 0.30437f
C128 pt a_5080_858# 0.09503f
C129 a_5080_n2160# pt 0.0825f
C130 a_5890_n8196# a_6160_n8196# 0.30437f
C131 a_5350_3876# a_5080_3876# 0.30437f
C132 VDD a_5890_n5178# 1.33134f
C133 VDD p2 6.42539f
C134 a_5890_n5178# p1 0.41099f
C135 p1 p2 8.39651f
C136 a_5350_3876# VSS 0.02038f
C137 a_6700_n2160# VSS 0.7044f
C138 pb a_6160_858# 0.14996f
C139 VDD a_5890_n8196# 1.33134f
C140 VDD a_6700_6894# 1.49746f
C141 VDD a_5620_6894# 1.33142f
C142 a_5350_n2160# a_5080_n2160# 0.30437f
C143 a_6160_3876# pb 0.09876f
C144 VDD a_5080_n5178# 1.33622f
C145 VDD a_5350_6894# 1.33144f
C146 a_5080_n5178# p1 0.31682f
C147 VDD a_5350_n8196# 1.33134f
C148 VDD a_6160_858# 1.34951f
C149 p1 a_6160_858# 0.07826f
C150 pb a_5620_n2160# 0.06101f
C151 a_6430_3876# pb 0.35385f
C152 a_5350_858# pb 0.14031f
C153 a_5890_3876# p2 0.09085f
C154 p2 a_5080_858# 0.1983f
C155 a_5080_n2160# p2 0.13538f
C156 a_6160_3876# VDD 1.33984f
C157 a_6160_3876# p1 0.09812f
C158 VDD a_4810_n5178# 1.50688f
C159 pt a_5080_3876# 0.21859f
C160 VDD a_5080_6894# 1.33151f
C161 a_6430_6894# a_6160_6894# 0.30437f
C162 VDD a_5620_n2160# 1.33196f
C163 a_6430_3876# VDD 1.34592f
C164 VDD a_5350_858# 1.33361f
C165 a_5620_n2160# p1 0.22844f
C166 a_5350_858# p1 0.16171f
C167 VSS pt 0.58615f
C168 VDD a_6700_n5178# 1.50711f
C169 a_5620_858# pt 0.08403f
C170 a_6700_3876# VSS 0.7044f
C171 a_6160_n2160# a_5890_n2160# 0.30437f
C172 a_6160_3876# a_5890_3876# 0.30437f
C173 VSS a_6160_6894# 0.89587f
C174 a_6430_n5178# pb 0.03874f
C175 pb a_5890_n2160# 0.12716f
C176 a_6430_n2160# p2 0.12223f
C177 a_5350_n2160# VSS 0.01077f
C178 a_5350_858# a_5080_858# 0.30437f
C179 a_6700_6894# a_6430_6894# 0.30437f
C180 a_5080_n8196# a_5350_n8196# 0.30437f
C181 a_6430_n5178# VDD 1.33867f
C182 pt a_5890_858# 0.06804f
C183 a_6430_n5178# p1 0.02978f
C184 VDD a_4810_858# 1.50688f
C185 VDD a_5890_n2160# 1.33454f
C186 pb a_6430_858# 0.0727f
C187 a_5890_n2160# p1 0.1948f
C188 VSS p2 0.81881f
C189 a_5620_858# p2 0.22002f
C190 a_5890_n8196# VSS 0.89634f
C191 a_6700_858# a_6430_858# 0.30437f
C192 a_6700_6894# VSS 0.88828f
C193 a_5620_n5178# a_5350_n5178# 0.30437f
C194 VDD a_6160_n5178# 1.33509f
C195 a_5620_6894# VSS 0.89585f
C196 a_6160_n5178# p1 0.37132f
C197 a_5350_6894# VSS 0.89587f
C198 VDD a_6430_858# 1.37061f
C199 a_6430_858# p1 0.11493f
C200 VSS a_5350_n8196# 0.89634f
C201 VSS a_6160_858# 0.01457f
C202 a_4810_858# a_5080_858# 0.30437f
C203 a_5350_3876# pt 0.07966f
C204 VDD a_4810_3876# 1.50688f
C205 pb a_5620_3876# 0.32442f
C206 pb a_5620_n5178# 0.28809f
C207 VSS a_4810_n5178# 0.68809f
C208 a_5890_858# p2 0.26245f
C209 VSS a_5080_6894# 0.89601f
C210 a_6430_3876# VSS 0.02101f
C211 a_5350_858# VSS 0.01334f
C212 a_5350_858# a_5620_858# 0.30437f
C213 VSS a_6700_n5178# 0.7044f
C214 VDD a_5620_3876# 1.33134f
C215 VDD a_5620_n5178# 1.33357f
C216 p1 a_5620_3876# 0.05737f
C217 a_5620_n5178# p1 0.13154f
C218 a_5890_858# a_6160_858# 0.30437f
C219 a_6430_n8196# a_6160_n8196# 0.30437f
C220 VDD a_5620_n8196# 1.33134f
C221 a_6160_n2160# pb 0.02932f
C222 a_5350_3876# p2 0.0478f
C223 VDD a_5350_n5178# 1.33743f
C224 a_5350_n5178# p1 0.16844f
C225 pb sub 0.86122f
C226 p2 sub 0.43759f
C227 p1 sub 0.9432f
C228 pt sub 0.15628f
C229 VSS sub 1.45202f
C230 VDD sub 11.1738f
C231 VDD.t0 sub 0.10177p
C232 VDD.n0 sub 16.0122f
C233 VDD.n1 sub 5.38387f
C234 VDD.n2 sub 0.24919f
C235 VDD.n3 sub 0.14985f
C236 VDD.n4 sub 0.17016f
C237 VDD.n5 sub 2.65769f
C238 VDD.n6 sub 0.14879f
C239 VDD.n7 sub 5.77487f
C240 VDD.n8 sub 0.12677f
C241 VDD.n9 sub 1.8364f
.ends
