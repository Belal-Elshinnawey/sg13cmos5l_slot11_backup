* PEX produced on Sun Nov  8 01:03:32 PM CET 2026 using /foss/tools/sak/sak-pex.sh with m=3 and s=1 (extresist threshold=10000 mOhm, minres=1000 mOhm, mindelay=1 ps)
* NGSPICE file created from resistor_network_pex.ext - technology: ihp-sg13cmos5l

.subckt resistor_network_pex pt VSS VDD p1 p2 pb
X0 VSS VSS VDD.t0 rhigh l=13.42u w=0.5u
X1 VSS VSS VDD.t0 rhigh l=13.42u w=0.5u
X2 p1 resistor_leg_3.p1 VDD.t0 rhigh l=13.42u w=0.5u
X3 resistor_leg_1.p2 pb VDD.t0 rhigh l=13.42u w=0.5u
X4 p1 resistor_leg_1.pt VDD.t0 rhigh l=13.42u w=0.5u
X5 resistor_leg_0.p2 pb VDD.t0 rhigh l=13.42u w=0.5u
X6 VSS VSS VDD.t0 rhigh l=13.42u w=0.5u
X7 VSS VSS VDD.t0 rhigh l=13.42u w=0.5u
X8 VSS VSS VDD.t0 rhigh l=13.42u w=0.5u
X9 resistor_leg_2.p1 pt VDD.t0 rhigh l=13.42u w=0.5u
X10 VSS VSS VDD.t0 rhigh l=13.42u w=0.5u
X11 resistor_leg_1.p2 p2 VDD.t0 rhigh l=13.42u w=0.5u
X12 resistor_leg_0.p2 p2 VDD.t0 rhigh l=13.42u w=0.5u
X13 VSS VSS VDD.t0 rhigh l=13.42u w=0.5u
X14 resistor_leg_2.p1 pt VDD.t0 rhigh l=13.42u w=0.5u
X15 VSS VSS VDD.t0 rhigh l=13.42u w=0.5u
X16 p1 resistor_leg_1.pt VDD.t0 rhigh l=13.42u w=0.5u
X17 VSS VSS VDD.t0 rhigh l=13.42u w=0.5u
X18 resistor_leg_1.p2 pb VDD.t0 rhigh l=13.42u w=0.5u
X19 VSS VSS VDD.t0 rhigh l=13.42u w=0.5u
X20 VSS VSS VDD.t0 rhigh l=13.42u w=0.5u
X21 resistor_leg_0.pt p2 VDD.t0 rhigh l=13.42u w=0.5u
X22 VSS VSS VDD.t0 rhigh l=13.42u w=0.5u
X23 resistor_leg_2.p1 pt VDD.t0 rhigh l=13.42u w=0.5u
X24 p2 resistor_leg_0.pt VDD.t0 rhigh l=13.42u w=0.5u
X25 VSS VSS VDD.t0 rhigh l=13.42u w=0.5u
X26 VSS VSS VDD.t0 rhigh l=13.42u w=0.5u
X27 VSS VSS VDD.t0 rhigh l=13.42u w=0.5u
X28 pt resistor_leg_2.p1 VDD.t0 rhigh l=13.42u w=0.5u
X29 VSS VSS VDD.t0 rhigh l=13.42u w=0.5u
X30 resistor_leg_3.p1 p1 VDD.t0 rhigh l=13.42u w=0.5u
X31 VSS VSS VDD.t0 rhigh l=13.42u w=0.5u
X32 resistor_leg_2.p1 pt VDD.t0 rhigh l=13.42u w=0.5u
X33 VSS VSS VDD.t0 rhigh l=13.42u w=0.5u
X34 p2 resistor_leg_1.p2 VDD.t0 rhigh l=13.42u w=0.5u
X35 VSS VSS VDD.t0 rhigh l=13.42u w=0.5u
X36 resistor_leg_1.pt p1 VDD.t0 rhigh l=13.42u w=0.5u
X37 VSS VSS VDD.t0 rhigh l=13.42u w=0.5u
X38 resistor_leg_0.pt p2 VDD.t0 rhigh l=13.42u w=0.5u
X39 resistor_leg_0.pt p1 VDD.t0 rhigh l=13.42u w=0.5u
X40 VSS VSS VDD.t0 rhigh l=13.42u w=0.5u
X41 VSS VSS VDD.t0 rhigh l=13.42u w=0.5u
X42 VSS VSS VDD.t0 rhigh l=13.42u w=0.5u
X43 VSS VSS VDD.t0 rhigh l=13.42u w=0.5u
X44 p2 resistor_leg_0.pt VDD.t0 rhigh l=13.42u w=0.5u
X45 pt resistor_leg_2.p1 VDD.t0 rhigh l=13.42u w=0.5u
X46 VSS VSS VDD.t0 rhigh l=13.42u w=0.5u
X47 VSS VSS VDD.t0 rhigh l=13.42u w=0.5u
X48 resistor_leg_3.p1 p1 VDD.t0 rhigh l=13.42u w=0.5u
X49 VSS VSS VDD.t0 rhigh l=13.42u w=0.5u
X50 VSS VSS VDD.t0 rhigh l=13.42u w=0.5u
X51 VSS VSS VDD.t0 rhigh l=13.42u w=0.5u
X52 p2 resistor_leg_1.p2 VDD.t0 rhigh l=13.42u w=0.5u
X53 VSS VSS VDD.t0 rhigh l=13.42u w=0.5u
X54 VSS VSS VDD.t0 rhigh l=13.42u w=0.5u
X55 VSS VSS VDD.t0 rhigh l=13.42u w=0.5u
X56 resistor_leg_1.pt p1 VDD.t0 rhigh l=13.42u w=0.5u
X57 p2 resistor_leg_1.pt VDD.t0 rhigh l=13.42u w=0.5u
X58 resistor_leg_0.pt p1 VDD.t0 rhigh l=13.42u w=0.5u
X59 resistor_leg_0.pt p2 VDD.t0 rhigh l=13.42u w=0.5u
X60 p1 resistor_leg_0.pt VDD.t0 rhigh l=13.42u w=0.5u
X61 VSS VSS VDD.t0 rhigh l=13.42u w=0.5u
X62 resistor_leg_0.p2 p2 VDD.t0 rhigh l=13.42u w=0.5u
X63 VSS VSS VDD.t0 rhigh l=13.42u w=0.5u
X64 VSS VSS VDD.t0 rhigh l=13.42u w=0.5u
X65 VSS VSS VDD.t0 rhigh l=13.42u w=0.5u
X66 resistor_leg_1.pt p2 VDD.t0 rhigh l=13.42u w=0.5u
X67 p1 resistor_leg_0.pt VDD.t0 rhigh l=13.42u w=0.5u
X68 VSS VSS VDD.t0 rhigh l=13.42u w=0.5u
X69 VSS VSS VDD.t0 rhigh l=13.42u w=0.5u
X70 resistor_leg_0.p2 p2 VDD.t0 rhigh l=13.42u w=0.5u
X71 VSS VSS VDD.t0 rhigh l=13.42u w=0.5u
X72 resistor_leg_0.pt p1 VDD.t0 rhigh l=13.42u w=0.5u
X73 VSS VSS VDD.t0 rhigh l=13.42u w=0.5u
X74 resistor_leg_0.pt p2 VDD.t0 rhigh l=13.42u w=0.5u
X75 p1 resistor_leg_0.pt VDD.t0 rhigh l=13.42u w=0.5u
X76 p2 resistor_leg_1.pt VDD.t0 rhigh l=13.42u w=0.5u
X77 p2 resistor_leg_0.p2 VDD.t0 rhigh l=13.42u w=0.5u
X78 resistor_leg_3.p1 pt VDD.t0 rhigh l=13.42u w=0.5u
X79 VSS VSS VDD.t0 rhigh l=13.42u w=0.5u
X80 p1 resistor_leg_0.pt VDD.t0 rhigh l=13.42u w=0.5u
X81 VSS VSS VDD.t0 rhigh l=13.42u w=0.5u
X82 resistor_leg_3.p1 pt VDD.t0 rhigh l=13.42u w=0.5u
X83 VSS VSS VDD.t0 rhigh l=13.42u w=0.5u
X84 p2 resistor_leg_1.pt VDD.t0 rhigh l=13.42u w=0.5u
X85 VSS VSS VDD.t0 rhigh l=13.42u w=0.5u
X86 p2 resistor_leg_1.p2 VDD.t0 rhigh l=13.42u w=0.5u
X87 resistor_leg_1.pt p2 VDD.t0 rhigh l=13.42u w=0.5u
X88 resistor_leg_0.pt p1 VDD.t0 rhigh l=13.42u w=0.5u
X89 VSS VSS VDD.t0 rhigh l=13.42u w=0.5u
X90 resistor_leg_2.p1 p1 VDD.t0 rhigh l=13.42u w=0.5u
X91 VSS VSS VDD.t0 rhigh l=13.42u w=0.5u
X92 pb resistor_leg_0.p2 VDD.t0 rhigh l=13.42u w=0.5u
X93 VSS VSS VDD.t0 rhigh l=13.42u w=0.5u
X94 p2 resistor_leg_0.p2 VDD.t0 rhigh l=13.42u w=0.5u
X95 pt resistor_leg_3.p1 VDD.t0 rhigh l=13.42u w=0.5u
X96 VSS VSS VDD.t0 rhigh l=13.42u w=0.5u
X97 VSS VSS VDD.t0 rhigh l=13.42u w=0.5u
X98 VSS VSS VDD.t0 rhigh l=13.42u w=0.5u
X99 resistor_leg_1.pt p1 VDD.t0 rhigh l=13.42u w=0.5u
X100 p2 resistor_leg_1.pt VDD.t0 rhigh l=13.42u w=0.5u
X101 pt resistor_leg_3.p1 VDD.t0 rhigh l=13.42u w=0.5u
X102 VSS VSS VDD.t0 rhigh l=13.42u w=0.5u
X103 VSS VSS VDD.t0 rhigh l=13.42u w=0.5u
X104 VSS VSS VDD.t0 rhigh l=13.42u w=0.5u
X105 p2 resistor_leg_1.p2 VDD.t0 rhigh l=13.42u w=0.5u
X106 p2 resistor_leg_0.p2 VDD.t0 rhigh l=13.42u w=0.5u
X107 resistor_leg_2.p1 p1 VDD.t0 rhigh l=13.42u w=0.5u
X108 pb resistor_leg_1.p2 VDD.t0 rhigh l=13.42u w=0.5u
X109 VSS VSS VDD.t0 rhigh l=13.42u w=0.5u
X110 pb resistor_leg_0.p2 VDD.t0 rhigh l=13.42u w=0.5u
X111 VSS VSS VDD.t0 rhigh l=13.42u w=0.5u
X112 pt resistor_leg_2.p1 VDD.t0 rhigh l=13.42u w=0.5u
X113 VSS VSS VDD.t0 rhigh l=13.42u w=0.5u
X114 resistor_leg_1.pt p1 VDD.t0 rhigh l=13.42u w=0.5u
X115 VSS VSS VDD.t0 rhigh l=13.42u w=0.5u
X116 p1 resistor_leg_1.pt VDD.t0 rhigh l=13.42u w=0.5u
X117 VSS VSS VDD.t0 rhigh l=13.42u w=0.5u
X118 VSS VSS VDD.t0 rhigh l=13.42u w=0.5u
X119 p1 resistor_leg_2.p1 VDD.t0 rhigh l=13.42u w=0.5u
X120 VSS VSS VDD.t0 rhigh l=13.42u w=0.5u
X121 VSS VSS VDD.t0 rhigh l=13.42u w=0.5u
X122 VSS VSS VDD.t0 rhigh l=13.42u w=0.5u
X123 VSS VSS VDD.t0 rhigh l=13.42u w=0.5u
X124 pb resistor_leg_1.p2 VDD.t0 rhigh l=13.42u w=0.5u
X125 VSS VSS VDD.t0 rhigh l=13.42u w=0.5u
X126 p2 resistor_leg_0.pt VDD.t0 rhigh l=13.42u w=0.5u
X127 p2 resistor_leg_0.p2 VDD.t0 rhigh l=13.42u w=0.5u
X128 VSS VSS VDD.t0 rhigh l=13.42u w=0.5u
X129 VSS VSS VDD.t0 rhigh l=13.42u w=0.5u
X130 VSS VSS VDD.t0 rhigh l=13.42u w=0.5u
X131 pt resistor_leg_2.p1 VDD.t0 rhigh l=13.42u w=0.5u
X132 p2 resistor_leg_0.pt VDD.t0 rhigh l=13.42u w=0.5u
X133 p1 resistor_leg_2.p1 VDD.t0 rhigh l=13.42u w=0.5u
X134 p1 resistor_leg_1.pt VDD.t0 rhigh l=13.42u w=0.5u
X135 VSS VSS VDD.t0 rhigh l=13.42u w=0.5u
X136 VSS VSS VDD.t0 rhigh l=13.42u w=0.5u
X137 p1 resistor_leg_2.p1 VDD.t0 rhigh l=13.42u w=0.5u
X138 pb resistor_leg_0.p2 VDD.t0 rhigh l=13.42u w=0.5u
X139 VSS VSS VDD.t0 rhigh l=13.42u w=0.5u
X140 resistor_leg_2.p1 p1 VDD.t0 rhigh l=13.42u w=0.5u
X141 VSS VSS VDD.t0 rhigh l=13.42u w=0.5u
X142 resistor_leg_0.p2 pb VDD.t0 rhigh l=13.42u w=0.5u
X143 VSS VSS VDD.t0 rhigh l=13.42u w=0.5u
X144 pt resistor_leg_3.p1 VDD.t0 rhigh l=13.42u w=0.5u
X145 pb resistor_leg_1.p2 VDD.t0 rhigh l=13.42u w=0.5u
X146 VSS VSS VDD.t0 rhigh l=13.42u w=0.5u
X147 VSS VSS VDD.t0 rhigh l=13.42u w=0.5u
X148 VSS VSS VDD.t0 rhigh l=13.42u w=0.5u
X149 p1 resistor_leg_2.p1 VDD.t0 rhigh l=13.42u w=0.5u
X150 VSS VSS VDD.t0 rhigh l=13.42u w=0.5u
X151 VSS VSS VDD.t0 rhigh l=13.42u w=0.5u
X152 resistor_leg_1.p2 pb VDD.t0 rhigh l=13.42u w=0.5u
X153 p1 resistor_leg_3.p1 VDD.t0 rhigh l=13.42u w=0.5u
X154 pb resistor_leg_0.p2 VDD.t0 rhigh l=13.42u w=0.5u
X155 VSS VSS VDD.t0 rhigh l=13.42u w=0.5u
X156 VSS VSS VDD.t0 rhigh l=13.42u w=0.5u
X157 resistor_leg_2.p1 p1 VDD.t0 rhigh l=13.42u w=0.5u
X158 resistor_leg_0.p2 pb VDD.t0 rhigh l=13.42u w=0.5u
X159 resistor_leg_0.p2 pb VDD.t0 rhigh l=13.42u w=0.5u
X160 VSS VSS VDD.t0 rhigh l=13.42u w=0.5u
X161 pt resistor_leg_3.p1 VDD.t0 rhigh l=13.42u w=0.5u
X162 pb resistor_leg_1.p2 VDD.t0 rhigh l=13.42u w=0.5u
X163 VSS VSS VDD.t0 rhigh l=13.42u w=0.5u
X164 resistor_leg_3.p1 pt VDD.t0 rhigh l=13.42u w=0.5u
X165 VSS VSS VDD.t0 rhigh l=13.42u w=0.5u
X166 resistor_leg_1.p2 p2 VDD.t0 rhigh l=13.42u w=0.5u
X167 p1 resistor_leg_3.p1 VDD.t0 rhigh l=13.42u w=0.5u
X168 resistor_leg_1.pt p2 VDD.t0 rhigh l=13.42u w=0.5u
X169 resistor_leg_1.p2 pb VDD.t0 rhigh l=13.42u w=0.5u
X170 resistor_leg_3.p1 p1 VDD.t0 rhigh l=13.42u w=0.5u
X171 VSS VSS VDD.t0 rhigh l=13.42u w=0.5u
X172 VSS VSS VDD.t0 rhigh l=13.42u w=0.5u
X173 VSS VSS VDD.t0 rhigh l=13.42u w=0.5u
X174 VSS VSS VDD.t0 rhigh l=13.42u w=0.5u
X175 VSS VSS VDD.t0 rhigh l=13.42u w=0.5u
X176 resistor_leg_3.p1 pt VDD.t0 rhigh l=13.42u w=0.5u
X177 VSS VSS VDD.t0 rhigh l=13.42u w=0.5u
X178 resistor_leg_1.p2 p2 VDD.t0 rhigh l=13.42u w=0.5u
X179 VSS VSS VDD.t0 rhigh l=13.42u w=0.5u
X180 VSS VSS VDD.t0 rhigh l=13.42u w=0.5u
X181 resistor_leg_3.p1 p1 VDD.t0 rhigh l=13.42u w=0.5u
X182 VSS VSS VDD.t0 rhigh l=13.42u w=0.5u
X183 VSS VSS VDD.t0 rhigh l=13.42u w=0.5u
X184 resistor_leg_1.pt p2 VDD.t0 rhigh l=13.42u w=0.5u
X185 VSS VSS VDD.t0 rhigh l=13.42u w=0.5u
X186 VSS VSS VDD.t0 rhigh l=13.42u w=0.5u
X187 p1 resistor_leg_3.p1 VDD.t0 rhigh l=13.42u w=0.5u
X188 VSS VSS VDD.t0 rhigh l=13.42u w=0.5u
X189 VSS VSS VDD.t0 rhigh l=13.42u w=0.5u
X190 resistor_leg_1.p2 p2 VDD.t0 rhigh l=13.42u w=0.5u
X191 resistor_leg_0.p2 p2 VDD.t0 rhigh l=13.42u w=0.5u
R0 VDD VDD.n1 0.285806
R1 VDD.n5 VDD.t0 0.0369816
R2 VDD.n13 VDD.n2 2.14022
R3 VDD.n6 VDD.t0 0.245155
R4 VDD.n11 VDD.n3 1.43493
R5 VDD.t0 VDD.n0 0.192868
R6 VDD.n4 VDD 2.05644
R7 VDD.n0 VDD.n7 1.35621
R8 VDD.n8 VDD.n5 1.45703
R9 VDD.n7 VDD.n6 1.00957
R10 VDD.n9 VDD.n3 1.36809
R11 VDD.n11 VDD.n2 1.2956
R12 VDD.n14 VDD.n4 1.21054
R13 VDD.n12 VDD.n11 0.7505
R14 VDD.n10 VDD.n9 0.7505
R15 VDD.n15 VDD.n14 0.7505
R16 VDD.t0 VDD.n1 0.0832303
R17 VDD.n8 VDD.n1 1.01514
R18 VDD.n10 VDD.n8 0.52762
R19 VDD.n6 VDD.n13 0.870885
R20 VDD.n15 VDD.n7 0.526916
R21 VDD.n12 VDD.n10 0.52674
R22 VDD.n14 VDD.n0 1.60854
R23 VDD.t0 VDD.n4 0.233452
R24 VDD.t0 VDD.n2 0.145816
R25 VDD.n13 VDD.n12 0.278228
R26 VDD VDD.n15 0.210996
R27 VDD.t0 VDD.n3 0.139995
R28 VDD.n5 VDD.n9 1.47144
C0 a_n3658_n524# VDD 1.33589f
C1 a_n5450_n3542# pb 0.14031f
C2 resistor_leg_3.p1 a_n5720_15094# 0.16894f
C3 a_n5990_n3542# VDD 1.34056f
C4 a_n5990_9058# VSS 0.89634f
C5 a_n3118_2494# resistor_leg_1.pt 0.1131f
C6 a_n5450_18112# pt 0.09693f
C7 a_n5990_n524# pb 0.12716f
C8 a_n2308_24148# VSS 0.89634f
C9 a_n2038_n9578# VSS 0.88869f
C10 a_n5450_9058# VSS 0.89634f
C11 a_n4910_24142# VDD 1.55014f
C12 resistor_leg_1.p2 resistor_leg_1.pt 2.03515f
C13 a_n2308_2494# VSS 0.06503f
C14 a_n2038_2494# VSS 0.7044f
C15 a_n5450_12076# pt 0.07966f
C16 a_n6530_12076# a_n6800_12076# 0.30437f
C17 a_n2848_21130# a_n2578_21130# 0.30437f
C18 a_n6530_n524# resistor_leg_0.p2 0.12223f
C19 a_n4910_n524# VDD 1.5724f
C20 a_n2308_18112# VDD 1.36025f
C21 resistor_leg_3.p1 a_n5450_18112# 0.28205f
C22 a_n5990_15094# a_n6260_15094# 0.30437f
C23 a_n3928_24142# VSS 0.87802f
C24 a_n5450_24148# VSS 0.89634f
C25 resistor_leg_3.p1 a_n5450_12076# 0.19648f
C26 a_n3118_9058# VDD 1.33134f
C27 p1 a_n2848_15094# 0.26245f
C28 a_n3118_2494# p2 0.13154f
C29 resistor_leg_1.pt a_n2848_15094# 0.06919f
C30 a_n3928_n3542# VDD 1.5724f
C31 a_n6260_18112# VSS 0.01227f
C32 a_n2308_12076# p1 0.13689f
C33 a_n5720_n9578# VSS 0.89634f
C34 resistor_leg_1.p2 p2 8.39869f
C35 a_n2308_n6560# VDD 1.34592f
C36 a_n5450_n6560# a_n5180_n6560# 0.30437f
C37 a_n6530_18112# VSS 0.06219f
C38 a_n2308_12076# resistor_leg_1.pt 0.37645f
C39 a_n3118_2494# VDD 1.33357f
C40 a_n2848_n6560# pb 0.08925f
C41 resistor_leg_0.pt a_n6530_n3542# 0.13568f
C42 a_n6530_21130# a_n6260_21130# 0.30437f
C43 a_n3658_n524# resistor_leg_1.p2 0.13538f
C44 a_n2038_24148# VDD 1.49271f
C45 a_n3928_12076# VDD 1.5724f
C46 resistor_leg_1.p2 VDD 6.42909f
C47 a_n5720_2494# a_n5990_2494# 0.30437f
C48 a_n3388_18112# VSS 0.01077f
C49 a_n6530_2494# a_n6800_2494# 0.30437f
C50 a_n3658_12076# VSS 0.08249f
C51 a_n2848_2494# a_n2578_2494# 0.30437f
C52 a_n5720_n3542# pb 0.06469f
C53 a_n3388_12076# pt 0.07966f
C54 a_n3118_n6560# resistor_leg_1.pt 0.05194f
C55 p2 a_n5720_n524# 0.22844f
C56 a_n5180_n524# p2 0.02314f
C57 a_n3928_9058# VDD 1.55873f
C58 a_n5180_n6560# a_n4910_n6560# 0.30437f
C59 a_n2308_9058# a_n2038_9058# 0.30437f
C60 a_n5720_2494# a_n5450_2494# 0.30437f
C61 a_n3658_15094# VSS 0.04789f
C62 a_n5720_n524# VDD 1.33196f
C63 a_n6260_9058# a_n6530_9058# 0.30437f
C64 resistor_leg_2.p1 a_n2308_21130# 0.02874f
C65 resistor_leg_2.p1 a_n3388_12076# 0.19648f
C66 a_n5180_n524# VDD 1.33589f
C67 a_n2308_5512# VSS 0.89634f
C68 a_n2848_15094# VDD 1.34056f
C69 a_n2038_5512# VSS 0.88869f
C70 a_n5720_5512# VDD 1.33134f
C71 a_n3928_2494# VDD 1.5724f
C72 a_n3388_n524# VSS 0.01077f
C73 a_n5180_n9578# VDD 1.33134f
C74 a_n2308_12076# VDD 1.34592f
C75 a_n6800_n9578# VSS 0.88869f
C76 resistor_leg_1.p2 a_n2308_n6560# 0.13689f
C77 a_n5450_n9578# VDD 1.33134f
C78 a_n5180_15094# VSS 0.04789f
C79 a_n6800_21130# VSS 0.7044f
C80 a_n3118_n6560# p2 0.05737f
C81 a_n4910_n524# a_n5180_n524# 0.30437f
C82 a_n3118_2494# resistor_leg_1.p2 0.05204f
C83 resistor_leg_0.pt resistor_leg_0.p2 2.03515f
C84 a_n3928_n9578# a_n4910_n9578# 0.07769f
C85 a_n5990_n9578# VSS 0.89634f
C86 resistor_leg_0.pt a_n6530_15094# 0.0727f
C87 a_n6530_24148# a_n6800_24148# 0.30437f
C88 a_n3118_n6560# VDD 1.33134f
C89 a_n6260_n524# a_n5990_n524# 0.30437f
C90 a_n6260_21130# p1 0.12949f
C91 resistor_leg_0.pt a_n6800_12076# 0.01655f
C92 a_n6260_2494# p2 0.37132f
C93 a_n5180_n6560# VSS 0.08249f
C94 a_n3928_n9578# VSS 0.87734f
C95 a_n6530_n3542# p2 0.11493f
C96 pt a_n2848_18112# 0.05102f
C97 a_n6260_2494# VDD 1.33509f
C98 a_n3388_n6560# a_n3658_n6560# 0.30437f
C99 a_n2308_n3542# resistor_leg_1.pt 0.13568f
C100 a_n6530_n3542# VDD 1.37061f
C101 a_n5180_12076# VSS 0.08249f
C102 a_n6530_n9578# a_n6260_n9578# 0.30437f
C103 a_n6800_n3542# VDD 1.50711f
C104 resistor_leg_2.p1 a_n2848_18112# 0.1948f
C105 a_n6800_5512# VDD 1.50711f
C106 pb a_n5990_n6560# 0.08925f
C107 p1 a_n6530_15094# 0.0179f
C108 a_n2848_12076# a_n3118_12076# 0.30437f
C109 a_n3658_5512# a_n3928_5506# 0.30369f
C110 pt a_n5450_21130# 0.12531f
C111 a_n2308_n3542# a_n2038_n3542# 0.30437f
C112 a_n6800_n6560# VSS 0.7044f
C113 a_n5450_n3542# VSS 0.01334f
C114 a_n2848_5512# a_n2578_5512# 0.30437f
C115 a_n3118_n9578# VSS 0.89634f
C116 a_n3388_15094# VSS 0.01334f
C117 a_n5720_2494# pb 0.28809f
C118 a_n6530_24148# VSS 0.89634f
C119 a_n2308_n3542# p2 0.11493f
C120 a_n3118_n6560# resistor_leg_1.p2 0.12153f
C121 a_n6260_21130# VDD 1.33509f
C122 a_n3388_12076# a_n3658_12076# 0.30437f
C123 resistor_leg_3.p1 a_n5450_21130# 0.16844f
C124 a_n5180_24148# VDD 1.33134f
C125 a_n5990_24148# VDD 1.33134f
C126 pt a_n2578_15094# 0.08551f
C127 resistor_leg_0.pt a_n5450_15094# 0.14031f
C128 a_n4910_24142# a_n5180_24148# 0.30369f
C129 a_n6530_21130# resistor_leg_3.p1 0.02874f
C130 a_n2308_n3542# VDD 1.37061f
C131 resistor_leg_0.p2 p2 8.39869f
C132 a_n4910_5506# VDD 1.552f
C133 a_n6530_2494# p2 0.02874f
C134 resistor_leg_0.pt pt 0.62374f
C135 a_n6530_n6560# a_n6800_n6560# 0.30437f
C136 resistor_leg_2.p1 a_n2578_15094# 0.07826f
C137 a_n5180_5512# VDD 1.33134f
C138 a_n5990_9058# a_n6260_9058# 0.30437f
C139 resistor_leg_0.p2 VDD 6.42909f
C140 a_n5180_n9578# a_n5450_n9578# 0.30437f
C141 a_n5180_12076# a_n5450_12076# 0.30437f
C142 resistor_leg_0.p2 a_n5990_n3542# 0.26245f
C143 a_n6530_2494# VDD 1.33867f
C144 a_n6530_15094# VDD 1.37061f
C145 a_n6260_5512# VSS 0.89634f
C146 a_n2578_2494# VSS 0.01154f
C147 a_n3118_24148# VSS 0.89634f
C148 resistor_leg_0.pt resistor_leg_3.p1 2.6753f
C149 a_n6800_12076# VDD 1.50711f
C150 a_n3388_24148# VDD 1.33134f
C151 a_n5990_5512# VSS 0.89634f
C152 a_n6530_9058# VDD 1.33134f
C153 a_n3658_18112# pt 0.0825f
C154 a_n5450_15094# p1 0.13619f
C155 a_n2038_15094# VDD 1.50711f
C156 pt p1 4.25492f
C157 resistor_leg_2.p1 a_n3658_18112# 0.02314f
C158 a_n3928_15094# VSS 0.69305f
C159 a_n3388_5512# VSS 0.89634f
C160 pt resistor_leg_1.pt 0.62374f
C161 resistor_leg_1.p2 a_n2308_n3542# 0.0179f
C162 a_n2038_9058# VDD 1.50711f
C163 a_n3658_5512# VSS 0.89702f
C164 a_n6800_n524# VSS 0.7044f
C165 a_n3658_n6560# resistor_leg_1.pt 0.21859f
C166 resistor_leg_2.p1 p1 8.66854f
C167 a_n3118_n3542# pb 0.06469f
C168 a_n2578_n6560# p2 0.09812f
C169 resistor_leg_3.p1 p1 8.66624f
C170 a_n2578_18112# VSS 0.01227f
C171 resistor_leg_2.p1 resistor_leg_1.pt 2.6752f
C172 a_n2308_n524# a_n2038_n524# 0.30437f
C173 a_n3388_n3542# resistor_leg_1.pt 0.02531f
C174 a_n4910_21130# a_n5180_21130# 0.30437f
C175 a_n3388_2494# a_n3658_2494# 0.30437f
C176 a_n5990_12076# pt 0.04603f
C177 a_n3388_n9578# VDD 1.33134f
C178 a_n2578_n6560# VDD 1.33984f
C179 a_n2578_n9578# VSS 0.89634f
C180 a_n5180_18112# pt 0.0825f
C181 a_n5720_21130# a_n5990_21130# 0.30437f
C182 a_n5990_n9578# a_n6260_n9578# 0.30437f
C183 a_n5450_15094# VDD 1.33361f
C184 resistor_leg_0.p2 a_n5720_n524# 0.2364f
C185 a_n2848_n524# a_n3118_n524# 0.30437f
C186 resistor_leg_0.pt a_n6260_18112# 0.02932f
C187 a_n2848_n524# a_n2578_n524# 0.30437f
C188 a_n2848_5512# VSS 0.89634f
C189 p2 a_n3658_n6560# 0.04257f
C190 a_n5990_12076# resistor_leg_3.p1 0.35346f
C191 a_n5180_n524# resistor_leg_0.p2 0.13538f
C192 a_n4910_n3542# VSS 0.69305f
C193 pt VDD 10.7213f
C194 resistor_leg_0.pt a_n6530_18112# 0.05228f
C195 resistor_leg_3.p1 a_n5180_18112# 0.02314f
C196 a_n6530_n3542# a_n6800_n3542# 0.30437f
C197 a_n5180_n3542# VSS 0.04789f
C198 p2 a_n3388_n3542# 0.16171f
C199 a_n3658_n6560# VDD 1.34046f
C200 a_n2578_9058# a_n2848_9058# 0.30437f
C201 resistor_leg_2.p1 VDD 6.76042f
C202 a_n2578_9058# VSS 0.89634f
C203 a_n5990_15094# a_n5720_15094# 0.30437f
C204 a_n3388_n3542# VDD 1.33361f
C205 resistor_leg_3.p1 VDD 6.76042f
C206 a_n2578_24148# VSS 0.89634f
C207 a_n6530_21130# a_n6800_21130# 0.30437f
C208 a_n2578_n6560# a_n2308_n6560# 0.30437f
C209 a_n3388_5512# a_n3118_5512# 0.30437f
C210 a_n2308_n9578# VSS 0.89634f
C211 a_n6530_n9578# VDD 1.33134f
C212 a_n4910_12076# VSS 0.69305f
C213 a_n6260_18112# p1 0.1294f
C214 a_n2848_12076# a_n2578_12076# 0.30437f
C215 a_n2578_n6560# resistor_leg_1.p2 0.34222f
C216 a_n3388_n524# a_n3118_n524# 0.30437f
C217 a_n3118_n9578# a_n2848_n9578# 0.30437f
C218 resistor_leg_2.p1 a_n2308_18112# 0.17395f
C219 a_n3388_18112# a_n3658_18112# 0.30437f
C220 a_n5720_9058# VDD 1.33134f
C221 a_n6530_18112# p1 0.12223f
C222 a_n2308_2494# p2 0.02874f
C223 a_n5990_9058# VDD 1.33134f
C224 a_n2848_n524# resistor_leg_1.pt 0.05102f
C225 a_n2038_n524# VSS 0.7044f
C226 a_n6260_n6560# a_n5990_n6560# 0.30437f
C227 a_n6260_2494# resistor_leg_0.p2 0.12431f
C228 p1 a_n3118_21130# 0.05817f
C229 a_n2038_n9578# VDD 1.49746f
C230 a_n2308_24148# VDD 1.33134f
C231 a_n4910_9058# a_n5180_9058# 0.30437f
C232 a_n2848_24148# a_n3118_24148# 0.30437f
C233 a_n5450_9058# VDD 1.33134f
C234 a_n6260_2494# a_n6530_2494# 0.30437f
C235 resistor_leg_1.pt a_n3118_21130# 0.28809f
C236 a_n2308_2494# VDD 1.33867f
C237 a_n3388_18112# p1 0.09078f
C238 a_n2038_2494# VDD 1.50711f
C239 a_n5720_24148# VSS 0.89634f
C240 a_n6260_24148# VSS 0.89634f
C241 a_n6530_n3542# resistor_leg_0.p2 0.0179f
C242 a_n6800_9058# VSS 0.88869f
C243 a_n3388_18112# resistor_leg_1.pt 0.06142f
C244 a_n2038_21130# VSS 0.7044f
C245 a_n3658_12076# resistor_leg_1.pt 0.01183f
C246 a_n3928_n524# VSS 0.69305f
C247 a_n2038_18112# VSS 0.7044f
C248 a_n6260_15094# VSS 0.01457f
C249 a_n2848_5512# a_n3118_5512# 0.30437f
C250 a_n3658_15094# p1 0.1983f
C251 a_n3928_24142# VDD 1.55014f
C252 a_n3658_n9578# VSS 0.89634f
C253 a_n5450_n6560# pb 0.04774f
C254 a_n5450_24148# VDD 1.33134f
C255 resistor_leg_1.p2 a_n3388_n3542# 0.13619f
C256 a_n5450_18112# a_n5720_18112# 0.30437f
C257 pb a_n2308_n524# 0.05228f
C258 resistor_leg_0.pt a_n5180_n6560# 0.21859f
C259 a_n3928_24142# a_n4910_24142# 0.07769f
C260 a_n2848_n524# p2 0.1948f
C261 a_n6260_18112# VDD 1.34725f
C262 pt a_n2848_15094# 0.06804f
C263 a_n5720_n9578# VDD 1.33134f
C264 a_n3388_n524# resistor_leg_1.pt 0.09693f
C265 a_n6530_18112# VDD 1.36025f
C266 a_n6530_5512# VSS 0.89634f
C267 a_n3658_21130# a_n3928_21130# 0.30437f
C268 p1 a_n5180_15094# 0.1983f
C269 a_n2848_n524# VDD 1.33454f
C270 resistor_leg_0.pt a_n5180_12076# 0.01183f
C271 a_n4910_5506# a_n5180_5512# 0.30369f
C272 a_n3658_21130# VDD 1.33622f
C273 a_n3118_21130# VDD 1.33357f
C274 resistor_leg_2.p1 a_n2848_15094# 0.15772f
C275 a_n2308_24148# a_n2038_24148# 0.30437f
C276 a_n3388_18112# VDD 1.33134f
C277 a_n6530_n524# a_n6800_n524# 0.30437f
C278 a_n3658_12076# VDD 1.34046f
C279 a_n6260_n524# pb 0.02932f
C280 resistor_leg_1.p2 a_n2308_2494# 0.3271f
C281 resistor_leg_0.pt a_n5450_n3542# 0.02531f
C282 resistor_leg_0.pt a_n5990_18112# 0.12716f
C283 a_n6530_2494# resistor_leg_0.p2 0.3271f
C284 pb a_n5450_n524# 0.06142f
C285 a_n4910_15094# a_n5180_15094# 0.30437f
C286 resistor_leg_0.pt a_n5990_n524# 0.05102f
C287 a_n3658_15094# VDD 1.33487f
C288 a_n3388_n524# p2 0.28205f
C289 a_n3658_24148# VSS 0.89702f
C290 a_n2308_5512# VDD 1.33134f
C291 a_n2038_5512# VDD 1.50711f
C292 a_n3388_n524# a_n3658_n524# 0.30437f
C293 a_n3388_n524# VDD 1.33134f
C294 a_n5720_n6560# a_n5990_n6560# 0.30437f
C295 a_n3658_n3542# VSS 0.04789f
C296 a_n6800_n9578# VDD 1.49746f
C297 a_n2848_n9578# a_n2578_n9578# 0.30437f
C298 a_n5180_15094# VDD 1.33487f
C299 a_n2578_18112# a_n2848_18112# 0.30437f
C300 a_n6800_21130# VDD 1.50711f
C301 a_n2848_21130# p1 0.05369f
C302 a_n2848_24148# a_n2578_24148# 0.30437f
C303 resistor_leg_1.p2 a_n2848_n524# 0.23663f
C304 a_n6260_n3542# pb 0.14996f
C305 a_n5990_18112# p1 0.23663f
C306 a_n5990_n9578# VDD 1.33134f
C307 pb VSS 2.60539f
C308 p1 a_n3388_15094# 0.13619f
C309 a_n6800_18112# VSS 0.7044f
C310 a_n5180_n6560# p2 0.04257f
C311 resistor_leg_1.pt a_n3388_15094# 0.14031f
C312 a_n3658_12076# a_n3928_12076# 0.30437f
C313 a_n2038_21130# a_n2308_21130# 0.30437f
C314 a_n3118_18112# a_n2848_18112# 0.30437f
C315 a_n5180_n6560# VDD 1.34046f
C316 a_n3928_n9578# VDD 1.55687f
C317 pb a_n6260_n6560# 0.11372f
C318 resistor_leg_0.pt a_n5720_n3542# 0.08403f
C319 a_n2578_21130# VSS 0.01154f
C320 a_n4910_9058# VSS 0.87734f
C321 a_n2308_9058# a_n2578_9058# 0.30437f
C322 a_n3388_21130# p1 0.269f
C323 a_n5180_12076# VDD 1.34046f
C324 a_n5180_9058# VSS 0.89634f
C325 a_n2578_n3542# pb 0.14996f
C326 a_n5450_n9578# a_n5720_n9578# 0.30437f
C327 a_n6530_n6560# pb 0.38267f
C328 a_n5450_n3542# p2 0.16171f
C329 a_n6260_21130# resistor_leg_3.p1 0.37132f
C330 a_n3388_n524# resistor_leg_1.p2 0.09078f
C331 a_n2038_12076# VSS 0.7044f
C332 a_n2578_5512# VSS 0.89634f
C333 a_n5990_n524# p2 0.1948f
C334 a_n2848_21130# VDD 1.33134f
C335 a_n6800_n6560# VDD 1.50711f
C336 pt a_n6530_15094# 0.13568f
C337 a_n5990_18112# VDD 1.33454f
C338 a_n5450_n3542# VDD 1.33361f
C339 a_n3118_n9578# VDD 1.33134f
C340 a_n3118_12076# a_n3388_12076# 0.30437f
C341 a_n2848_n6560# resistor_leg_1.pt 0.04603f
C342 a_n5990_n524# VDD 1.33454f
C343 a_n3388_15094# VDD 1.33361f
C344 a_n6530_24148# VDD 1.33134f
C345 a_n3388_9058# VSS 0.89634f
C346 pb a_n2038_n6560# 0.01655f
C347 resistor_leg_3.p1 a_n6530_15094# 0.11493f
C348 a_n4910_21130# VSS 0.69305f
C349 a_n6800_15094# VSS 0.7044f
C350 a_n3928_5506# VSS 0.87802f
C351 resistor_leg_0.pt a_n5990_15094# 0.06919f
C352 a_n2308_15094# VSS 0.05629f
C353 a_n4910_18112# VSS 0.69305f
C354 a_n5450_n6560# VSS 0.02038f
C355 a_n3388_21130# VDD 1.33743f
C356 a_n2578_2494# p2 0.37132f
C357 resistor_leg_0.pt a_n5180_n3542# 0.09503f
C358 a_n2308_n524# VSS 0.06219f
C359 a_n2848_n6560# p2 0.35346f
C360 a_n2578_18112# p1 0.1294f
C361 a_n6260_5512# VDD 1.33134f
C362 a_n2578_2494# VDD 1.33509f
C363 a_n5450_24148# a_n5180_24148# 0.30437f
C364 a_n3928_15094# a_n4910_15094# 0.07769f
C365 a_n2578_18112# resistor_leg_1.pt 0.02932f
C366 a_n3118_24148# VDD 1.33134f
C367 a_n2848_n6560# VDD 1.33651f
C368 a_n5720_n3542# p2 0.16894f
C369 a_n5990_5512# VDD 1.33134f
C370 a_n4910_n6560# a_n3928_n6560# 0.07769f
C371 a_n5180_21130# a_n5450_21130# 0.30437f
C372 a_n6800_24148# VSS 0.88869f
C373 a_n4910_2494# VSS 0.69305f
C374 resistor_leg_0.pt a_n5720_18112# 0.06101f
C375 resistor_leg_0.pt a_n5990_n6560# 0.04603f
C376 a_n4910_n6560# VSS 0.69305f
C377 a_n5720_21130# a_n5450_21130# 0.30437f
C378 a_n5720_n6560# pb 0.32442f
C379 a_n5990_15094# p1 0.26245f
C380 a_n3118_18112# p1 0.2364f
C381 a_n5720_n3542# VDD 1.33276f
C382 a_n6260_n524# VSS 0.01227f
C383 a_n5450_15094# pt 0.02531f
C384 a_n5720_n3542# a_n5990_n3542# 0.30437f
C385 a_n3118_18112# resistor_leg_1.pt 0.06101f
C386 a_n3118_15094# p1 0.22002f
C387 a_n5450_n524# VSS 0.01077f
C388 a_n3928_15094# VDD 1.5724f
C389 resistor_leg_0.pt a_n5720_2494# 0.1131f
C390 a_n3118_15094# resistor_leg_1.pt 0.06469f
C391 a_n3388_5512# VDD 1.33134f
C392 a_n6800_n524# VDD 1.50711f
C393 resistor_leg_0.pt a_n5990_2494# 0.12211f
C394 a_n3658_5512# VDD 1.33134f
C395 a_n2578_21130# a_n2308_21130# 0.30437f
C396 a_n5990_n524# a_n5720_n524# 0.30437f
C397 a_n5450_15094# resistor_leg_3.p1 0.16171f
C398 a_n4910_n9578# VSS 0.87734f
C399 a_n2578_18112# VDD 1.34725f
C400 a_n5180_2494# a_n5450_2494# 0.30437f
C401 resistor_leg_2.p1 pt 5.15287f
C402 resistor_leg_3.p1 pt 5.15291f
C403 resistor_leg_0.pt a_n5720_21130# 0.28809f
C404 a_n6530_n524# pb 0.05228f
C405 resistor_leg_1.p2 a_n2578_2494# 0.12431f
C406 a_n5720_18112# p1 0.2364f
C407 resistor_leg_0.pt a_n5450_2494# 0.13682f
C408 resistor_leg_0.pt a_n6260_15094# 0.14996f
C409 a_n2848_9058# VSS 0.89634f
C410 a_n2578_n9578# VDD 1.33134f
C411 a_n2848_n6560# resistor_leg_1.p2 0.09085f
C412 a_n3928_n6560# VSS 0.69305f
C413 a_n6260_n3542# VSS 0.01457f
C414 a_n5450_5512# VSS 0.89634f
C415 a_n5990_15094# VDD 1.34056f
C416 a_n2578_18112# a_n2308_18112# 0.30437f
C417 a_n3118_18112# VDD 1.33196f
C418 a_n5180_n3542# p2 0.10496f
C419 resistor_leg_2.p1 resistor_leg_3.p1 0.16611f
C420 a_n2848_5512# VDD 1.33134f
C421 a_n4910_n3542# VDD 1.5724f
C422 pb a_n3388_n6560# 0.04774f
C423 a_n3118_15094# VDD 1.33276f
C424 a_n5720_12076# a_n5450_12076# 0.30437f
C425 a_n5180_n3542# VDD 1.33487f
C426 a_n5720_21130# p1 0.05815f
C427 a_n2578_9058# VDD 1.33134f
C428 a_n5720_n6560# a_n5450_n6560# 0.30437f
C429 a_n6260_15094# p1 0.14836f
C430 p2 a_n5990_n6560# 0.35346f
C431 a_n2578_24148# VDD 1.33134f
C432 a_n5720_5512# a_n5990_5512# 0.30437f
C433 a_n2578_n3542# VSS 0.01457f
C434 a_n6530_n6560# VSS 0.02101f
C435 a_n2308_n9578# VDD 1.33134f
C436 a_n5990_n6560# VDD 1.33651f
C437 a_n5720_18112# VDD 1.33196f
C438 a_n4910_12076# VDD 1.5724f
C439 a_n5720_2494# p2 0.13154f
C440 a_n2848_n3542# a_n3118_n3542# 0.30437f
C441 a_n2848_12076# p1 0.09085f
C442 a_n5450_18112# VSS 0.01077f
C443 a_n5990_2494# p2 0.41099f
C444 a_n4910_n3542# a_n3928_n3542# 0.07769f
C445 a_n5720_9058# a_n5990_9058# 0.30437f
C446 a_n2848_12076# resistor_leg_1.pt 0.08253f
C447 a_n6530_n6560# a_n6260_n6560# 0.30437f
C448 a_n6260_18112# pt 0.04651f
C449 a_n3118_12076# p1 0.12153f
C450 a_n5720_2494# VDD 1.33357f
C451 a_n3118_n6560# a_n2848_n6560# 0.30437f
C452 a_n5450_12076# VSS 0.02038f
C453 a_n5720_9058# a_n5450_9058# 0.30437f
C454 a_n6530_12076# a_n6260_12076# 0.30437f
C455 a_n2038_n524# VDD 1.50711f
C456 a_n3118_12076# resistor_leg_1.pt 0.32442f
C457 a_n5990_2494# VDD 1.33134f
C458 a_n2038_n6560# VSS 0.7044f
C459 a_n3658_21130# pt 0.24797f
C460 a_n6260_24148# VDD 1.33134f
C461 a_n5720_24148# VDD 1.33134f
C462 pt a_n3118_21130# 0.11113f
C463 a_n6800_9058# VDD 1.50711f
C464 p2 a_n5450_2494# 0.16844f
C465 a_n3118_n524# pb 0.06101f
C466 a_n3658_n524# a_n3928_n524# 0.30437f
C467 pb a_n2578_n524# 0.02932f
C468 a_n2038_21130# VDD 1.50711f
C469 a_n3388_18112# pt 0.09693f
C470 a_n3928_n524# VDD 1.5724f
C471 a_n6260_18112# resistor_leg_3.p1 0.29404f
C472 a_n2848_n3542# pb 0.06919f
C473 a_n3118_5512# VSS 0.89634f
C474 a_n5180_21130# VDD 1.33622f
C475 resistor_leg_0.pt pb 0.67953f
C476 a_n2038_18112# VDD 1.50711f
C477 a_n2308_2494# a_n2038_2494# 0.30437f
C478 a_n3658_12076# pt 0.21859f
C479 a_n3388_2494# resistor_leg_1.pt 0.13682f
C480 resistor_leg_3.p1 a_n6530_18112# 0.17395f
C481 a_n5720_21130# VDD 1.33357f
C482 a_n5450_2494# VDD 1.33743f
C483 a_n6260_15094# VDD 1.34951f
C484 a_n3658_21130# resistor_leg_2.p1 0.31682f
C485 a_n3388_9058# a_n3658_9058# 0.30437f
C486 resistor_leg_2.p1 a_n3118_21130# 0.13154f
C487 a_n5450_n3542# resistor_leg_0.p2 0.13619f
C488 a_n3658_n9578# VDD 1.33134f
C489 a_n3388_18112# resistor_leg_2.p1 0.28205f
C490 a_n5990_n524# resistor_leg_0.p2 0.23663f
C491 a_n3118_n3542# resistor_leg_1.pt 0.08403f
C492 resistor_leg_2.p1 a_n3658_12076# 0.04257f
C493 a_n3658_15094# pt 0.09503f
C494 a_n4910_n524# a_n3928_n524# 0.07769f
C495 a_n2308_18112# a_n2038_18112# 0.30437f
C496 a_n4910_12076# a_n3928_12076# 0.07769f
C497 a_n3118_15094# a_n2848_15094# 0.30437f
C498 a_n5450_15094# a_n5180_15094# 0.30437f
C499 a_n2848_12076# VDD 1.33651f
C500 a_n6530_5512# VDD 1.33134f
C501 a_n6530_n524# a_n6260_n524# 0.30437f
C502 a_n3658_n3542# resistor_leg_1.pt 0.09503f
C503 a_n3118_12076# VDD 1.33134f
C504 a_n3658_15094# resistor_leg_2.p1 0.1023f
C505 a_n2308_21130# VSS 0.06503f
C506 a_n3388_12076# VSS 0.02038f
C507 a_n3388_2494# p2 0.16844f
C508 pt a_n5180_15094# 0.09503f
C509 a_n4910_18112# a_n3928_18112# 0.07769f
C510 pb resistor_leg_1.pt 0.67953f
C511 a_n3388_2494# VDD 1.33743f
C512 a_n3118_n3542# p2 0.16894f
C513 a_n6530_12076# VSS 0.02101f
C514 a_n2848_24148# VSS 0.89634f
C515 resistor_leg_3.p1 a_n5180_15094# 0.1023f
C516 a_n3658_24148# VDD 1.33134f
C517 a_n2308_15094# a_n2578_15094# 0.30437f
C518 a_n2578_21130# p1 0.12949f
C519 a_n3118_n3542# VDD 1.33276f
C520 a_n6800_n9578# a_n6530_n9578# 0.30437f
C521 a_n2848_2494# resistor_leg_1.pt 0.12211f
C522 p2 a_n3658_n3542# 0.10496f
C523 a_n3658_2494# resistor_leg_1.pt 0.25598f
C524 a_n6260_18112# a_n6530_18112# 0.30437f
C525 a_n3388_24148# a_n3118_24148# 0.30437f
C526 a_n6530_n524# VSS 0.06219f
C527 a_n5720_n3542# resistor_leg_0.p2 0.22002f
C528 a_n3118_n9578# a_n3388_n9578# 0.30437f
C529 a_n2578_n524# a_n2308_n524# 0.30437f
C530 a_n5180_12076# pt 0.21859f
C531 a_n3658_n3542# VDD 1.33487f
C532 resistor_leg_0.pt a_n5450_n6560# 0.07966f
C533 p2 pb 5.5096f
C534 a_n6260_n9578# VSS 0.89634f
C535 a_n2038_12076# resistor_leg_1.pt 0.01655f
C536 a_n2848_n9578# VSS 0.89634f
C537 a_n3658_n524# pb 0.19811f
C538 a_n2848_21130# pt 0.12211f
C539 a_n2308_9058# VSS 0.89634f
C540 pb VDD 13.8358f
C541 a_n5990_n3542# pb 0.06919f
C542 resistor_leg_0.pt a_n6260_12076# 0.10801f
C543 a_n6800_18112# VDD 1.50711f
C544 a_n5990_18112# pt 0.05102f
C545 a_n3388_n6560# VSS 0.02038f
C546 a_n5180_12076# resistor_leg_3.p1 0.04257f
C547 a_n3118_2494# a_n3388_2494# 0.30437f
C548 a_n2848_2494# p2 0.41099f
C549 pt a_n3388_15094# 0.02531f
C550 a_n3658_2494# p2 0.31682f
C551 a_n5180_2494# a_n4910_2494# 0.30437f
C552 resistor_leg_1.p2 a_n3388_2494# 0.26261f
C553 a_n2848_21130# resistor_leg_2.p1 0.41099f
C554 a_n3658_9058# VSS 0.89634f
C555 a_n2848_2494# VDD 1.33134f
C556 a_n6800_2494# VSS 0.7044f
C557 a_n5990_18112# resistor_leg_3.p1 0.1948f
C558 a_n2578_21130# VDD 1.33509f
C559 a_n3658_2494# VDD 1.33622f
C560 a_n5990_21130# p1 0.05369f
C561 a_n4910_9058# VDD 1.55873f
C562 a_n2308_15094# p1 0.0179f
C563 resistor_leg_0.pt a_n6260_n524# 0.04651f
C564 resistor_leg_2.p1 a_n3388_15094# 0.16171f
C565 a_n6260_9058# VSS 0.89634f
C566 resistor_leg_0.pt a_n5720_12076# 0.32442f
C567 resistor_leg_0.pt a_n5450_n524# 0.09693f
C568 a_n3118_n3542# resistor_leg_1.p2 0.22002f
C569 a_n3928_n3542# a_n3658_n3542# 0.30437f
C570 a_n5990_2494# a_n6260_2494# 0.30437f
C571 a_n2308_15094# resistor_leg_1.pt 0.0727f
C572 a_n3928_18112# VSS 0.69305f
C573 a_n5180_9058# VDD 1.33134f
C574 a_n2578_n6560# a_n2848_n6560# 0.30437f
C575 a_n3388_21130# pt 0.12531f
C576 a_n6530_21130# VSS 0.06503f
C577 a_n2038_12076# VDD 1.50711f
C578 a_n6260_12076# p1 0.34222f
C579 a_n5720_n9578# a_n5990_n9578# 0.30437f
C580 a_n2578_5512# VDD 1.33134f
C581 resistor_leg_1.p2 a_n3658_n3542# 0.1983f
C582 pb a_n2308_n6560# 0.38267f
C583 a_n5180_n3542# resistor_leg_0.p2 0.1983f
C584 a_n3118_2494# pb 0.28809f
C585 resistor_leg_2.p1 a_n3388_21130# 0.16844f
C586 a_n2578_15094# VSS 0.01457f
C587 p1 a_n2578_12076# 0.34222f
C588 resistor_leg_1.p2 pb 2.74865f
C589 a_n3388_9058# VDD 1.33134f
C590 a_n4910_18112# a_n5180_18112# 0.30437f
C591 a_n2578_12076# resistor_leg_1.pt 0.10801f
C592 a_n4910_21130# a_n3928_21130# 0.07769f
C593 a_n2308_5512# a_n2038_5512# 0.30437f
C594 resistor_leg_0.pt a_n6260_n3542# 0.08551f
C595 a_n2578_n524# VSS 0.01227f
C596 a_n5450_n6560# p2 0.19648f
C597 a_n5720_12076# p1 0.12153f
C598 a_n4910_21130# VDD 1.5724f
C599 resistor_leg_0.pt VSS 4.84502f
C600 a_n6260_12076# a_n5990_12076# 0.30437f
C601 a_n3118_2494# a_n2848_2494# 0.30437f
C602 resistor_leg_0.p2 a_n5990_n6560# 0.09085f
C603 a_n6800_15094# VDD 1.50711f
C604 p2 a_n2308_n524# 0.17395f
C605 a_n3928_5506# VDD 1.552f
C606 a_n6260_24148# a_n5990_24148# 0.30437f
C607 a_n5720_24148# a_n5990_24148# 0.30437f
C608 a_n5990_21130# VDD 1.33134f
C609 a_n4910_18112# VDD 1.5724f
C610 a_n2308_15094# VDD 1.37061f
C611 resistor_leg_1.p2 a_n2848_2494# 0.05369f
C612 a_n5450_n6560# VDD 1.33532f
C613 pb a_n5720_n524# 0.06101f
C614 a_n2308_n524# VDD 1.36025f
C615 a_n5180_n524# pb 0.19811f
C616 a_n5720_2494# resistor_leg_0.p2 0.05204f
C617 a_n6530_5512# a_n6800_5512# 0.30437f
C618 a_n3118_9058# a_n3388_9058# 0.30437f
C619 a_n5990_18112# a_n6260_18112# 0.30437f
C620 a_n5990_2494# resistor_leg_0.p2 0.05369f
C621 a_n6260_12076# VDD 1.33984f
C622 resistor_leg_0.pt a_n5720_15094# 0.06469f
C623 a_n3658_18112# VSS 0.04173f
C624 a_n5720_12076# a_n5990_12076# 0.30437f
C625 a_n2578_18112# pt 0.04651f
C626 a_n2848_21130# a_n3118_21130# 0.30437f
C627 a_n4910_9058# a_n3928_9058# 0.07769f
C628 a_n2848_n3542# a_n2578_n3542# 0.30437f
C629 a_n2578_2494# a_n2308_2494# 0.30437f
C630 a_n6260_n524# p2 0.29404f
C631 a_n6800_24148# VDD 1.49271f
C632 a_n2578_12076# VDD 1.33984f
C633 p2 a_n5450_n524# 0.28205f
C634 resistor_leg_0.p2 a_n5450_2494# 0.26261f
C635 p1 VSS 3.30835f
C636 a_n4910_2494# VDD 1.5724f
C637 a_n4910_n6560# VDD 1.5724f
C638 a_n2578_18112# resistor_leg_2.p1 0.29404f
C639 a_n6530_9058# a_n6800_9058# 0.30437f
C640 resistor_leg_1.pt VSS 4.84502f
C641 a_n3118_n6560# pb 0.32442f
C642 a_n6260_n524# VDD 1.34725f
C643 a_n6260_15094# a_n6530_15094# 0.30437f
C644 a_n3928_2494# a_n3658_2494# 0.30437f
C645 resistor_leg_0.pt a_n5450_18112# 0.06142f
C646 a_n5720_12076# VDD 1.33134f
C647 a_n5990_15094# pt 0.06804f
C648 a_n5450_n524# VDD 1.33134f
C649 a_n3118_18112# pt 0.04982f
C650 resistor_leg_0.pt a_n5450_12076# 0.04774f
C651 a_n3118_15094# pt 0.08403f
C652 a_n4910_15094# VSS 0.69305f
C653 a_n3658_21130# a_n3388_21130# 0.30437f
C654 a_n3658_15094# a_n3388_15094# 0.30437f
C655 a_n2308_12076# a_n2038_12076# 0.30437f
C656 p1 a_n5720_15094# 0.22002f
C657 a_n2038_n3542# VSS 0.7044f
C658 a_n3388_21130# a_n3118_21130# 0.30437f
C659 resistor_leg_2.p1 a_n3118_18112# 0.22844f
C660 a_n4910_n9578# VDD 1.55687f
C661 a_n5990_15094# resistor_leg_3.p1 0.15772f
C662 resistor_leg_1.p2 a_n2308_n524# 0.12223f
C663 a_n6530_n3542# pb 0.0727f
C664 p2 a_n6260_n3542# 0.07826f
C665 a_n5180_18112# VSS 0.04173f
C666 resistor_leg_2.p1 a_n3118_15094# 0.16894f
C667 a_n2578_n3542# resistor_leg_1.pt 0.08551f
C668 p2 VSS 1.54006f
C669 a_n2848_9058# VDD 1.33134f
C670 a_n3928_n6560# VDD 1.5724f
C671 a_n6260_n3542# VDD 1.34951f
C672 a_n5450_5512# VDD 1.33134f
C673 a_n3928_21130# VSS 0.69305f
C674 pt a_n5720_18112# 0.04982f
C675 a_n5450_18112# p1 0.09078f
C676 a_n5990_n3542# a_n6260_n3542# 0.30437f
C677 a_n3658_n524# VSS 0.04173f
C678 VDD VSS 0.19283p
C679 a_n5450_12076# p1 0.0478f
C680 p2 a_n6260_n6560# 0.09812f
C681 a_n4910_24142# VSS 0.87802f
C682 resistor_leg_3.p1 a_n5720_18112# 0.22844f
C683 a_n3658_n9578# a_n3388_n9578# 0.30437f
C684 a_n4910_n524# VSS 0.69305f
C685 a_n6260_n6560# VDD 1.33984f
C686 resistor_leg_0.pt a_n5720_n6560# 0.05194f
C687 a_n2308_18112# VSS 0.06219f
C688 a_n3388_24148# a_n3658_24148# 0.30437f
C689 a_n2308_n3542# pb 0.0727f
C690 p2 a_n2578_n3542# 0.07826f
C691 a_n3118_9058# a_n2848_9058# 0.30437f
C692 a_n5720_15094# VDD 1.33276f
C693 a_n5180_18112# a_n5450_18112# 0.30437f
C694 pt a_n5180_21130# 0.24797f
C695 a_n3118_9058# VSS 0.89634f
C696 a_n6530_n6560# VDD 1.34592f
C697 a_n2578_n3542# VDD 1.34951f
C698 resistor_leg_0.pt a_n6530_12076# 0.37645f
C699 pt a_n6260_15094# 0.08551f
C700 a_n5720_21130# pt 0.11113f
C701 resistor_leg_0.p2 pb 2.74865f
C702 a_n2308_24148# a_n2578_24148# 0.30437f
C703 a_n6530_2494# pb 0.03874f
C704 a_n5450_n524# a_n5720_n524# 0.30437f
C705 a_n3928_n3542# VSS 0.69305f
C706 a_n3928_2494# a_n4910_2494# 0.07769f
C707 a_n2308_12076# a_n2578_12076# 0.30437f
C708 a_n3658_15094# a_n3928_15094# 0.30437f
C709 a_n2038_n9578# a_n2308_n9578# 0.30437f
C710 a_n2308_n6560# VSS 0.02101f
C711 a_n5180_n524# a_n5450_n524# 0.30437f
C712 a_n5450_18112# VDD 1.33134f
C713 resistor_leg_3.p1 a_n5180_21130# 0.31682f
C714 resistor_leg_3.p1 a_n5720_21130# 0.13154f
C715 resistor_leg_3.p1 a_n6260_15094# 0.07826f
C716 a_n5450_12076# VDD 1.33532f
C717 resistor_leg_1.p2 VSS 0.81993f
C718 a_n2038_24148# VSS 0.88869f
C719 a_n2848_12076# pt 0.04603f
C720 a_n3928_12076# VSS 0.69305f
C721 a_n3388_12076# p1 0.0478f
C722 a_n2308_21130# p1 0.33801f
C723 a_n2308_21130# resistor_leg_1.pt 0.03874f
C724 a_n3118_12076# pt 0.05194f
C725 a_n2038_n6560# VDD 1.50711f
C726 a_n3388_12076# resistor_leg_1.pt 0.04774f
C727 a_n3388_18112# a_n3118_18112# 0.30437f
C728 resistor_leg_2.p1 a_n2848_12076# 0.35346f
C729 a_n5180_n9578# a_n4910_n9578# 0.30437f
C730 a_n3928_9058# VSS 0.87734f
C731 a_n6530_12076# p1 0.13689f
C732 a_n3118_5512# VDD 1.33134f
C733 resistor_leg_2.p1 a_n3118_12076# 0.05737f
C734 a_n5180_n524# VSS 0.04173f
C735 a_n5450_5512# a_n5720_5512# 0.30437f
C736 a_n6260_21130# a_n5990_21130# 0.30437f
C737 resistor_leg_1.p2 a_n2578_n3542# 0.14836f
C738 a_n5720_5512# VSS 0.89634f
C739 a_n3928_2494# VSS 0.69305f
C740 a_n5180_n9578# VSS 0.89634f
C741 a_n5720_24148# a_n5450_24148# 0.30437f
C742 a_n2308_12076# VSS 0.02101f
C743 a_n4910_5506# a_n3928_5506# 0.07769f
C744 a_n5720_n6560# p2 0.05737f
C745 a_n2578_n6560# pb 0.11372f
C746 a_n5450_n9578# VSS 0.89634f
C747 a_n2308_n6560# a_n2038_n6560# 0.30437f
C748 a_n3388_12076# VDD 1.33532f
C749 a_n2308_21130# VDD 1.33867f
C750 a_n5720_n6560# VDD 1.33134f
C751 a_n6800_15094# a_n6530_15094# 0.30437f
C752 a_n5450_n3542# a_n5720_n3542# 0.30437f
C753 a_n3118_n3542# a_n3388_n3542# 0.30437f
C754 resistor_leg_0.pt a_n6530_21130# 0.03874f
C755 a_n5450_n6560# resistor_leg_0.p2 0.0478f
C756 a_n3388_n6560# resistor_leg_1.pt 0.07966f
C757 p1 a_n2848_18112# 0.23663f
C758 a_n6530_12076# VDD 1.34592f
C759 a_n3388_n3542# a_n3658_n3542# 0.30437f
C760 resistor_leg_1.pt a_n2848_18112# 0.12716f
C761 a_n2848_24148# VDD 1.33134f
C762 a_n3658_18112# a_n3928_18112# 0.30437f
C763 pb a_n3658_n6560# 0.01183f
C764 a_n6530_n3542# a_n6260_n3542# 0.30437f
C765 a_n6260_2494# VSS 0.01154f
C766 a_n6530_n524# p2 0.17395f
C767 resistor_leg_0.pt a_n5180_2494# 0.25598f
C768 a_n6530_n3542# VSS 0.05629f
C769 pb a_n3388_n3542# 0.14031f
C770 a_n6260_5512# a_n5990_5512# 0.30437f
C771 a_n2308_15094# a_n2038_15094# 0.30437f
C772 p1 a_n5450_21130# 0.26899f
C773 a_n6800_n3542# VSS 0.7044f
C774 a_n6530_n524# VDD 1.36025f
C775 a_n6260_n524# resistor_leg_0.p2 0.1294f
C776 a_n6800_5512# VSS 0.88869f
C777 a_n6530_21130# p1 0.33801f
C778 resistor_leg_0.p2 a_n5450_n524# 0.09078f
C779 a_n6260_n9578# VDD 1.33134f
C780 p2 a_n3388_n6560# 0.19648f
C781 a_n2848_n9578# VDD 1.33134f
C782 resistor_leg_2.p1 a_n2578_21130# 0.37132f
C783 a_n3928_24142# a_n3658_24148# 0.30369f
C784 a_n2308_9058# VDD 1.33134f
C785 p1 a_n2578_15094# 0.14836f
C786 a_n3388_n6560# VDD 1.33532f
C787 a_n6260_21130# VSS 0.01154f
C788 resistor_leg_1.pt a_n2578_15094# 0.14996f
C789 a_n5180_24148# VSS 0.89702f
C790 a_n5990_24148# VSS 0.89634f
C791 a_n5180_n3542# a_n5450_n3542# 0.30437f
C792 a_n3118_15094# a_n3388_15094# 0.30437f
C793 a_n2848_18112# VDD 1.33454f
C794 a_n2308_2494# pb 0.03874f
C795 a_n3118_n524# resistor_leg_1.pt 0.04982f
C796 a_n2308_n3542# VSS 0.05629f
C797 a_n5180_12076# a_n4910_12076# 0.30437f
C798 a_n2578_n524# resistor_leg_1.pt 0.04651f
C799 resistor_leg_0.pt p1 2.69694f
C800 a_n3658_9058# VDD 1.33134f
C801 a_n4910_5506# VSS 0.87802f
C802 a_n2848_n3542# resistor_leg_1.pt 0.06804f
C803 a_n5180_5512# a_n5450_5512# 0.30437f
C804 resistor_leg_0.pt resistor_leg_1.pt 0.19416f
C805 a_n6800_2494# VDD 1.50711f
C806 resistor_leg_0.p2 a_n6260_n3542# 0.14836f
C807 a_n5180_5512# VSS 0.89702f
C808 a_n6260_9058# VDD 1.33134f
C809 a_n3928_18112# VDD 1.5724f
C810 resistor_leg_0.p2 VSS 0.81993f
C811 a_n5450_21130# VDD 1.33743f
C812 a_n5990_21130# pt 0.12211f
C813 a_n5990_18112# a_n5720_18112# 0.30437f
C814 a_n2308_15094# pt 0.13568f
C815 a_n6530_2494# VSS 0.06503f
C816 a_n6530_15094# VSS 0.05629f
C817 a_n5180_9058# a_n5450_9058# 0.30437f
C818 a_n6530_21130# VDD 1.33867f
C819 a_n3388_5512# a_n3658_5512# 0.30437f
C820 a_n3658_18112# p1 0.13538f
C821 a_n3658_n9578# a_n3928_n9578# 0.30437f
C822 a_n3388_24148# VSS 0.89634f
C823 a_n3658_18112# resistor_leg_1.pt 0.19811f
C824 resistor_leg_0.pt a_n5990_12076# 0.08253f
C825 a_n6800_12076# VSS 0.7044f
C826 a_n6530_9058# VSS 0.89634f
C827 resistor_leg_2.p1 a_n2308_15094# 0.11493f
C828 resistor_leg_0.p2 a_n6260_n6560# 0.34222f
C829 a_n2308_n3542# a_n2578_n3542# 0.30437f
C830 a_n5180_2494# p2 0.31682f
C831 p2 a_n3118_n524# 0.22844f
C832 a_n6530_18112# a_n6800_18112# 0.30437f
C833 a_n2848_n524# pb 0.12716f
C834 resistor_leg_0.pt a_n5180_18112# 0.19811f
C835 resistor_leg_3.p1 a_n5990_21130# 0.41099f
C836 p2 a_n2578_n524# 0.29404f
C837 a_n2578_15094# VDD 1.34951f
C838 a_n2848_n3542# p2 0.15772f
C839 resistor_leg_0.pt p2 5.21799f
C840 resistor_leg_1.p2 a_n3388_n6560# 0.0478f
C841 a_n2038_15094# VSS 0.7044f
C842 a_n3118_n524# VDD 1.33196f
C843 p1 resistor_leg_1.pt 2.69712f
C844 a_n5180_2494# VDD 1.33622f
C845 a_n2578_n524# VDD 1.34725f
C846 resistor_leg_0.p2 a_n6530_n6560# 0.13689f
C847 a_n6530_24148# a_n6260_24148# 0.30437f
C848 a_n2848_n3542# VDD 1.34056f
C849 a_n6260_12076# resistor_leg_3.p1 0.09812f
C850 resistor_leg_0.pt VDD 15.8132f
C851 resistor_leg_0.pt a_n5990_n3542# 0.06804f
C852 a_n2038_9058# VSS 0.88869f
C853 a_n5720_12076# pt 0.05194f
C854 resistor_leg_2.p1 a_n2578_12076# 0.09812f
C855 a_n5990_12076# p1 0.09085f
C856 a_n5180_18112# p1 0.13538f
C857 a_n3658_9058# a_n3928_9058# 0.30437f
C858 a_n3388_n524# pb 0.06142f
C859 a_n5720_12076# resistor_leg_3.p1 0.05737f
C860 a_n3658_18112# VDD 1.33589f
C861 a_n3388_n9578# VSS 0.89634f
C862 p2 resistor_leg_1.pt 5.21799f
C863 a_n5450_15094# VSS 0.01334f
C864 p1 VDD 16.0763f
C865 a_n3658_n524# resistor_leg_1.pt 0.0825f
C866 resistor_leg_1.pt VDD 15.8132f
C867 pt VSS 1.18053f
C868 resistor_leg_1.p2 a_n3118_n524# 0.2364f
C869 a_n3658_n6560# a_n3928_n6560# 0.30437f
C870 a_n3118_n6560# a_n3388_n6560# 0.30437f
C871 resistor_leg_1.p2 a_n2578_n524# 0.1294f
C872 a_n2848_n3542# resistor_leg_1.p2 0.26245f
C873 a_n2308_5512# a_n2578_5512# 0.30437f
C874 a_n3658_n6560# VSS 0.08249f
C875 a_n5180_n6560# pb 0.01183f
C876 a_n4910_n3542# a_n5180_n3542# 0.30437f
C877 a_n5450_15094# a_n5720_15094# 0.30437f
C878 a_n2308_18112# p1 0.12223f
C879 a_n4910_15094# VDD 1.5724f
C880 resistor_leg_2.p1 VSS 0.76591f
C881 a_n2038_n3542# VDD 1.50711f
C882 a_n3388_n3542# VSS 0.01334f
C883 a_n2308_n9578# a_n2578_n9578# 0.30437f
C884 a_n2308_18112# resistor_leg_1.pt 0.05228f
C885 resistor_leg_3.p1 VSS 0.76591f
C886 a_n5990_12076# VDD 1.33651f
C887 a_n6530_5512# a_n6260_5512# 0.30437f
C888 a_n2848_15094# a_n2578_15094# 0.30437f
C889 pt a_n5720_15094# 0.08403f
C890 a_n5720_n6560# resistor_leg_0.p2 0.12153f
C891 a_n5180_18112# VDD 1.33589f
C892 a_n3658_n524# p2 0.02314f
C893 a_n6530_n9578# VSS 0.89634f
C894 p2 VDD 15.0248f
C895 a_n5990_n3542# p2 0.15772f
C896 resistor_leg_0.pt a_n5720_n524# 0.04982f
C897 resistor_leg_0.pt a_n5180_n524# 0.0825f
C898 a_n3928_21130# VDD 1.5724f
C899 a_n6800_n6560# pb 0.01655f
C900 a_n5720_9058# VSS 0.89634f
C901 p2 sub 0.5056f
C902 pb sub 2.62202f
C903 pt sub 0.18184f
C904 p1 sub 1.33348f
C905 VSS sub 3.15908f
C906 VDD sub 33.4059f
C907 resistor_leg_1.p2 sub 0.41081f
C908 resistor_leg_0.p2 sub 0.41081f
C909 resistor_leg_1.pt sub 1.85955f
C910 resistor_leg_2.p1 sub 0.2288f
C911 resistor_leg_3.p1 sub 0.2288f
C912 resistor_leg_0.pt sub 1.85965f
C913 VDD.n0 sub 0.24304f
C914 VDD.n1 sub 17.7682f
C915 VDD.n2 sub 0.18885f
C916 VDD.n3 sub 0.17886f
C917 VDD.n4 sub 0.16038f
C918 VDD.t0 sub 0.51259p
C919 VDD.n5 sub 0.25449f
C920 VDD.n6 sub 6.06233f
C921 VDD.n7 sub 4.77774f
C922 VDD.n8 sub 5.03274f
C923 VDD.n9 sub 0.15698f
C924 VDD.n10 sub 2.76734f
C925 VDD.n11 sub 0.14251f
C926 VDD.n12 sub 2.11215f
C927 VDD.n13 sub 4.11442f
C928 VDD.n14 sub 0.15415f
C929 VDD.n15 sub 1.93598f
.ends
