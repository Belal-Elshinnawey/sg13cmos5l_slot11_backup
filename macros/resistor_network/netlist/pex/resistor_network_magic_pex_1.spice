* PEX produced on Sun Nov  8 06:58:46 AM CET 2026 using /foss/tools/sak/sak-pex.sh with m=1 and s=1
* NGSPICE file created from resistor_network_pex.ext - technology: ihp-sg13cmos5l

.subckt resistor_network_pex pt VSS VDD p1 p2 pb
X0 p1 pt VDD rhigh l=13.42u w=0.5u
X1 VSS VSS VDD rhigh l=13.42u w=0.5u
X2 p2 pb VDD rhigh l=13.42u w=0.5u
X3 p2 p1 VDD rhigh l=13.42u w=0.5u
X4 VSS VSS VDD rhigh l=13.42u w=0.5u
X5 VSS VSS VDD rhigh l=13.42u w=0.5u
X6 VSS VSS VDD rhigh l=13.42u w=0.5u
X7 VSS VSS VDD rhigh l=13.42u w=0.5u
X8 VSS VSS VDD rhigh l=13.42u w=0.5u
X9 p2 p1 VDD rhigh l=13.42u w=0.5u
X10 pt p1 VDD rhigh l=13.42u w=0.5u
X11 p2 p1 VDD rhigh l=13.42u w=0.5u
X12 pt p1 VDD rhigh l=13.42u w=0.5u
X13 VSS VSS VDD rhigh l=13.42u w=0.5u
X14 pb p2 VDD rhigh l=13.42u w=0.5u
X15 VSS VSS VDD rhigh l=13.42u w=0.5u
X16 pt p1 VDD rhigh l=13.42u w=0.5u
X17 pb p2 VDD rhigh l=13.42u w=0.5u
X18 VSS VSS VDD rhigh l=13.42u w=0.5u
X19 p2 pb VDD rhigh l=13.42u w=0.5u
X20 p2 p1 VDD rhigh l=13.42u w=0.5u
X21 VSS VSS VDD rhigh l=13.42u w=0.5u
X22 VSS VSS VDD rhigh l=13.42u w=0.5u
X23 VSS VSS VDD rhigh l=13.42u w=0.5u
X24 p2 pb VDD rhigh l=13.42u w=0.5u
X25 VSS VSS VDD rhigh l=13.42u w=0.5u
X26 p1 p2 VDD rhigh l=13.42u w=0.5u
X27 VSS VSS VDD rhigh l=13.42u w=0.5u
X28 VSS VSS VDD rhigh l=13.42u w=0.5u
X29 VSS VSS VDD rhigh l=13.42u w=0.5u
X30 pt p1 VDD rhigh l=13.42u w=0.5u
X31 VSS VSS VDD rhigh l=13.42u w=0.5u
X32 VSS VSS VDD rhigh l=13.42u w=0.5u
X33 p1 pt VDD rhigh l=13.42u w=0.5u
X34 p1 p2 VDD rhigh l=13.42u w=0.5u
X35 pb p2 VDD rhigh l=13.42u w=0.5u
X36 VSS VSS VDD rhigh l=13.42u w=0.5u
X37 p1 pt VDD rhigh l=13.42u w=0.5u
X38 VSS VSS VDD rhigh l=13.42u w=0.5u
X39 VSS VSS VDD rhigh l=13.42u w=0.5u
X40 p1 p2 VDD rhigh l=13.42u w=0.5u
X41 pb p2 VDD rhigh l=13.42u w=0.5u
X42 p1 p2 VDD rhigh l=13.42u w=0.5u
X43 VSS VSS VDD rhigh l=13.42u w=0.5u
X44 VSS VSS VDD rhigh l=13.42u w=0.5u
X45 p2 pb VDD rhigh l=13.42u w=0.5u
X46 VSS VSS VDD rhigh l=13.42u w=0.5u
X47 p1 pt VDD rhigh l=13.42u w=0.5u
C0 pb sub 16.9573f
C1 p2 sub 32.34281f
C2 p1 sub 34.21981f
C3 pt sub 16.56952f
C4 VSS sub 72.49983f
C5 VDD sub 29.688f
.ends
