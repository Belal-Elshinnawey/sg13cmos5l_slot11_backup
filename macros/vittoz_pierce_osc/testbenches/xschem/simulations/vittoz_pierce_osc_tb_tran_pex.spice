** sch_path: /foss/designs/sg13cmos5l_slot3_backup/macros/vittoz_pierce_osc/testbenches/xschem/vittoz_pierce_osc_tb_tran_pex.sch
**.subckt vittoz_pierce_osc_tb_tran_pex
x1 XOUT AVDD AVDD XIN EG_IBIAS AOUT GND vittoz_pierce_osc_pex
X2 XIN XOUT crystal_model_p_res f=12Meg Cm=20f Rm=15 C0=4p icLm=0m
C1 XIN GND 11p
C2 XOUT GND 11p
VAVDD AVDD GND {AVDD}
.save i(vavdd)
IBIAS GND EG_IBIAS {IBIAS}
**** begin user architecture code

.include ../../../netlist/pex/vittoz_pierce_osc_magic_pex_3.spice
.param AVDD=3.3
.csparam AVDD=AVDD
.param IBIAS=1u
.csparam IBIAS=IBIAS
.temp 27
.options klu method=gear reltol=1e-3 abstol=1e-12 gmin=1e-12
.control

save v(xin) v(xout) v(aout) i(vavdd)

* Operating Point Analysis
op
remzerovec
write vittoz_pierce_osc_tb_tran_pex.raw
set appendwrite

* Transient Analysis: oscillator startup through steady-state (crystal-driven)
iplot xin xout aout
tran 1n 10m uic
write vittoz_pierce_osc_tb_tran_pex.raw

* Plotting
plot xin xout aout
plot i(vavdd)

* Write Data
unset appendwrite
set wr_vecnames
set wr_singlescale
wrdata ../plot_simulations/data/vittoz_pierce_osc_tb_tran_pex.txt v(xin) v(xout) v(aout) i(vavdd)

*quit
.endc

.lib cornerMOSlv.lib mos_tt
.lib cornerMOShv.lib mos_tt
.lib cornerRES.lib res_typ
.lib cornerCAP.lib cap_typ
.lib cornerDIO.lib dio_tt

**** end user architecture code
**.ends

* expanding   symbol:  crystal_model_p_res.sym # of pins=2
** sym_path: /foss/designs/sg13cmos5l_slot3_backup/macros/vittoz_pierce_osc/testbenches/xschem/crystal_model_p_res.sym
** sch_path: /foss/designs/sg13cmos5l_slot3_backup/macros/vittoz_pierce_osc/testbenches/xschem/crystal_model_p_res.sch
.subckt crystal_model_p_res XIN XOUT  f=12Meg Cm=20f Rm=15 C0=4p icLm=0m
*.iopin XIN
*.iopin XOUT
X1 XIN XOUT crystal_model Lm=(1/Cm+1/C0)/(4*pi^2*f^2) Cm=Cm Rm=Rm C0=C0 icLm=icLm
**** begin user architecture code
.param pi=4*atan(1)
**** end user architecture code
.ends

* expanding   symbol:  crystal_model.sym # of pins=2
** sym_path: /foss/designs/sg13cmos5l_slot3_backup/macros/vittoz_pierce_osc/testbenches/xschem/crystal_model.sym
** sch_path: /foss/designs/sg13cmos5l_slot3_backup/macros/vittoz_pierce_osc/testbenches/xschem/crystal_model.sch
.subckt crystal_model XIN XOUT  Lm=8.8m Cm=20f Rm=15 C0=4p icLm=0m
*.iopin XIN
*.iopin XOUT
Cm net1 net2 C=Cm
Lm XIN net1 L=Lm ic=icLm
Rm net2 XOUT R=Rm
C0 XIN XOUT C=C0
.ends

.end
