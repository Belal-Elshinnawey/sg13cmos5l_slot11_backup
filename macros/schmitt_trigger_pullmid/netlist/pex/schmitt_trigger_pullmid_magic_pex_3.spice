* PEX produced on Thu Oct 29 09:03:37 PM CET 2026 using /foss/tools/sak/sak-pex.sh with m=3 and s=1 (extresist threshold=10000 mOhm, minres=1000 mOhm, mindelay=1 ps)
* NGSPICE file created from schmitt_trigger_pullmid_pex.ext - technology: ihp-sg13cmos5l

.subckt schmitt_trigger_pullmid_pex SG_DVDD AIN DOUT VSS
X0 DLT AIN DOUT VSS.t2 sg13_lv_nmos ad=0.34p pd=2.68u as=0.34p ps=2.68u w=1u l=0.3u
X1 DHT AIN SG_DVDD SG_DVDD sg13_lv_pmos ad=0.34p pd=2.68u as=0.34p ps=2.68u w=1u l=0.3u
X2 SG_DVDD DOUT DLT VSS.t1 sg13_lv_nmos ad=0.34p pd=2.68u as=0.34p ps=2.68u w=1u l=0.3u
X3 MID SG_DVDD VSS.t4 rhigh l=34.12u w=0.5u
X4 DLT AIN VSS.t3 VSS.t2 sg13_lv_nmos ad=0.34p pd=2.68u as=0.34p ps=2.68u w=1u l=0.3u
X5 MID VSS VSS.t4 rhigh l=34.12u w=0.5u
X6 VSS.t0 DOUT DHT SG_DVDD sg13_lv_pmos ad=0.34p pd=2.68u as=0.34p ps=2.68u w=1u l=0.3u
X7 DHT AIN DOUT SG_DVDD sg13_lv_pmos ad=0.34p pd=2.68u as=0.34p ps=2.68u w=1u l=0.3u
X8 AIN MID VSS.t6 rhigh l=0.27172m w=0.5u
R0 VSS.n211 VSS.n0 296.928
R1 VSS.n240 VSS.n119 235.27
R2 VSS.n158 VSS.n157 177.325
R3 VSS.t1 VSS.n0 116.421
R4 VSS.n160 VSS.n159 73.002
R5 VSS.n184 VSS.n182 65.3851
R6 VSS.n159 VSS.t6 65.3098
R7 VSS.n34 VSS.t4 51.9236
R8 VSS.n178 VSS.n129 22.3699
R9 VSS.n175 VSS.n130 22.3699
R10 VSS.n132 VSS.n131 22.3699
R11 VSS.n170 VSS.n133 22.3699
R12 VSS.n162 VSS.n161 22.3699
R13 VSS.n163 VSS.n162 22.3699
R14 VSS.n164 VSS.n163 22.3699
R15 VSS.n165 VSS.n164 22.3699
R16 VSS.n166 VSS.n165 22.3699
R17 VSS.n167 VSS.n166 22.3699
R18 VSS.n168 VSS.n167 22.3699
R19 VSS.n169 VSS.n168 22.3699
R20 VSS.n171 VSS.n169 22.3699
R21 VSS.n171 VSS.n170 22.3699
R22 VSS.n133 VSS.n132 22.3699
R23 VSS.n172 VSS.n131 22.3699
R24 VSS.n173 VSS.n172 22.3699
R25 VSS.n174 VSS.n173 22.3699
R26 VSS.n176 VSS.n174 22.3699
R27 VSS.n176 VSS.n175 22.3699
R28 VSS.n177 VSS.n130 22.3699
R29 VSS.n179 VSS.n177 22.3699
R30 VSS.n179 VSS.n178 22.3699
R31 VSS.n180 VSS.n129 22.3699
R32 VSS.n181 VSS.n180 22.3699
R33 VSS.n183 VSS.n181 22.3699
R34 VSS.n243 VSS.n242 17.0005
R35 VSS.n185 VSS.n184 17.0005
R36 VSS.n185 VSS.n160 17.0005
R37 VSS.n182 VSS.n99 17.0005
R38 VSS.n266 VSS.n46 17.0005
R39 VSS.n266 VSS.n51 17.0005
R40 VSS.n266 VSS.n47 17.0005
R41 VSS.n267 VSS.n266 17.0005
R42 VSS.n266 VSS.n45 17.0005
R43 VSS.n269 VSS.n40 17.0005
R44 VSS.n269 VSS.n28 17.0005
R45 VSS.n269 VSS.n42 17.0005
R46 VSS.n266 VSS.n48 17.0005
R47 VSS.n269 VSS.n36 17.0005
R48 VSS.n269 VSS.n30 17.0005
R49 VSS.n269 VSS.n35 17.0005
R50 VSS.n269 VSS.n31 17.0005
R51 VSS.n269 VSS.n34 17.0005
R52 VSS.n266 VSS.n34 17.0005
R53 VSS.n266 VSS.n31 17.0005
R54 VSS.n266 VSS.n96 17.0005
R55 VSS.n266 VSS.n26 17.0005
R56 VSS.n272 VSS.n22 17.0005
R57 VSS.n210 VSS.n201 17.0005
R58 VSS.n213 VSS.n188 17.0005
R59 VSS.t6 VSS.n158 15.3049
R60 VSS.n209 VSS.n191 15.172
R61 VSS.n212 VSS.n192 15.172
R62 VSS.n192 VSS.n190 14.6989
R63 VSS.n205 VSS.n191 14.6989
R64 VSS.n90 VSS.n23 13.6502
R65 VSS.t4 VSS.n31 13.462
R66 VSS.n182 VSS.n125 12.0478
R67 VSS.n240 VSS.n125 12.0478
R68 VSS.n184 VSS.n183 11.1852
R69 VSS.n28 VSS.n25 11.1852
R70 VSS.n50 VSS.n40 11.1852
R71 VSS.n268 VSS.n267 11.1852
R72 VSS.n41 VSS.n14 11.1852
R73 VSS.n46 VSS.n27 11.1852
R74 VSS.n271 VSS.n270 11.1852
R75 VSS.n96 VSS.n29 11.1852
R76 VSS.n95 VSS.n30 11.1852
R77 VSS.n97 VSS.n36 11.1852
R78 VSS.n95 VSS.n35 11.1852
R79 VSS.n29 VSS.n18 11.1852
R80 VSS.n97 VSS.n18 11.1852
R81 VSS.n270 VSS.n26 11.1852
R82 VSS.n271 VSS.n25 11.1852
R83 VSS.n51 VSS.n27 11.1852
R84 VSS.n50 VSS.n14 11.1852
R85 VSS.n47 VSS.n41 11.1852
R86 VSS.n268 VSS.n45 11.1852
R87 VSS.n161 VSS.n160 11.1852
R88 VSS.n112 VSS.t3 9.18007
R89 VSS.n241 VSS.n240 8.501
R90 VSS.n240 VSS.n124 8.501
R91 VSS.n240 VSS.n126 8.501
R92 VSS.n240 VSS.n123 8.501
R93 VSS.n240 VSS.n122 8.501
R94 VSS.n240 VSS.n121 8.501
R95 VSS.n240 VSS.n234 8.501
R96 VSS.n240 VSS.n235 8.501
R97 VSS.n240 VSS.n236 8.501
R98 VSS.n240 VSS.n237 8.501
R99 VSS.n240 VSS.n238 8.501
R100 VSS.n225 VSS.n216 8.501
R101 VSS.n157 VSS.n43 8.501
R102 VSS.n157 VSS.n135 8.501
R103 VSS.n157 VSS.n136 8.501
R104 VSS.n157 VSS.n137 8.501
R105 VSS.n157 VSS.n138 8.501
R106 VSS.n157 VSS.n139 8.501
R107 VSS.n157 VSS.n134 8.501
R108 VSS.n157 VSS.n156 8.501
R109 VSS.n90 VSS.n52 8.501
R110 VSS.n91 VSS.n90 8.501
R111 VSS.n90 VSS.n55 8.501
R112 VSS.n90 VSS.n56 8.501
R113 VSS.n90 VSS.n58 8.501
R114 VSS.n90 VSS.n21 8.501
R115 VSS.n90 VSS.n70 8.501
R116 VSS.n90 VSS.n71 8.501
R117 VSS.n90 VSS.n72 8.501
R118 VSS.n90 VSS.n73 8.501
R119 VSS.n90 VSS.n9 8.501
R120 VSS.n272 VSS.n271 8.5005
R121 VSS.n272 VSS.n14 8.5005
R122 VSS.n272 VSS.n18 8.5005
R123 VSS.n242 VSS.n117 8.47018
R124 VSS.n127 VSS.n118 8.45995
R125 VSS.n244 VSS.n114 8.44296
R126 VSS.n245 VSS.n113 8.44296
R127 VSS.n228 VSS.n185 8.44296
R128 VSS.n248 VSS.n110 8.44296
R129 VSS.n249 VSS.n109 8.44296
R130 VSS.n250 VSS.n108 8.44296
R131 VSS.n251 VSS.n107 8.44296
R132 VSS.n252 VSS.n106 8.44296
R133 VSS.n253 VSS.n105 8.44296
R134 VSS.n254 VSS.n104 8.44296
R135 VSS.n256 VSS.n102 8.44296
R136 VSS.n257 VSS.n101 8.44296
R137 VSS.n147 VSS.n146 8.44296
R138 VSS.n148 VSS.n145 8.44296
R139 VSS.n149 VSS.n144 8.44296
R140 VSS.n150 VSS.n143 8.44296
R141 VSS.n151 VSS.n142 8.44296
R142 VSS.n152 VSS.n141 8.44296
R143 VSS.n153 VSS.n140 8.44296
R144 VSS.n93 VSS.n92 8.44296
R145 VSS.n54 VSS.n53 8.44296
R146 VSS.n64 VSS.n63 8.44296
R147 VSS.n66 VSS.n61 8.44296
R148 VSS.n60 VSS.n59 8.44296
R149 VSS.n269 VSS.n33 8.44296
R150 VSS.n82 VSS.n81 8.44296
R151 VSS.n83 VSS.n80 8.44296
R152 VSS.n84 VSS.n79 8.44296
R153 VSS.n85 VSS.n78 8.44296
R154 VSS.n76 VSS.n75 8.44296
R155 VSS.n193 VSS.n4 8.44399
R156 VSS.n45 VSS.n11 7.79582
R157 VSS.n205 VSS.t2 7.3497
R158 VSS.t2 VSS.n190 7.3497
R159 VSS.n34 VSS.n23 6.82532
R160 VSS.n267 VSS.n13 6.74703
R161 VSS.n40 VSS.n15 6.74703
R162 VSS.n28 VSS.n16 6.74703
R163 VSS.n26 VSS.n24 6.74703
R164 VSS.n96 VSS.n19 6.74703
R165 VSS.n35 VSS.n20 6.74703
R166 VSS.n31 VSS.n20 6.74703
R167 VSS.n30 VSS.n19 6.74703
R168 VSS.n36 VSS.n24 6.74703
R169 VSS.n46 VSS.n16 6.74703
R170 VSS.n51 VSS.n15 6.74703
R171 VSS.n47 VSS.n13 6.74703
R172 VSS.n240 VSS.n116 5.66778
R173 VSS.n240 VSS.n231 5.66778
R174 VSS.n240 VSS.n233 5.66778
R175 VSS.n240 VSS.n120 5.66778
R176 VSS.n157 VSS.n49 5.66778
R177 VSS.n90 VSS.n57 5.66778
R178 VSS.n90 VSS.n69 5.66778
R179 VSS.n90 VSS.n32 5.66778
R180 VSS.n90 VSS.n74 5.66778
R181 VSS.n90 VSS.n89 5.66778
R182 VSS.n211 VSS.n4 3.40138
R183 VSS.n240 VSS.n232 5.66767
R184 VSS.n230 VSS.n229 5.56542
R185 VSS.n255 VSS.n103 5.56542
R186 VSS.n155 VSS.n154 5.56542
R187 VSS.n65 VSS.n62 5.56542
R188 VSS.n68 VSS.n67 5.56542
R189 VSS.n86 VSS.n77 5.56542
R190 VSS.n88 VSS.n87 5.56542
R191 VSS.n100 VSS.n5 4.5005
R192 VSS.n276 VSS.n275 4.5005
R193 VSS.n240 VSS.n239 4.251
R194 VSS.n220 VSS.n99 4.14072
R195 VSS.n247 VSS.n111 4.12607
R196 VSS.n213 VSS.n119 3.4005
R197 VSS.n210 VSS.n208 3.22159
R198 VSS.n210 VSS.n204 3.22142
R199 VSS.n198 VSS.n2 3.22124
R200 VSS.n214 VSS.n213 3.22124
R201 VSS.n213 VSS.n189 3.22124
R202 VSS.n212 VSS.n211 3.1297
R203 VSS.n209 VSS.n119 3.1297
R204 VSS.n185 VSS.n181 2.90889
R205 VSS.n185 VSS.n129 2.90889
R206 VSS.n185 VSS.n179 2.90889
R207 VSS.n185 VSS.n130 2.90889
R208 VSS.n185 VSS.n176 2.90889
R209 VSS.n185 VSS.n173 2.90889
R210 VSS.n185 VSS.n131 2.90889
R211 VSS.n185 VSS.n133 2.90889
R212 VSS.n185 VSS.n171 2.90889
R213 VSS.n185 VSS.n168 2.90889
R214 VSS.n185 VSS.n166 2.90889
R215 VSS.n185 VSS.n164 2.90889
R216 VSS.n185 VSS.n162 2.90889
R217 VSS.n183 VSS.n99 2.90889
R218 VSS.n180 VSS.n99 2.90889
R219 VSS.n178 VSS.n99 2.90889
R220 VSS.n177 VSS.n99 2.90889
R221 VSS.n175 VSS.n99 2.90889
R222 VSS.n174 VSS.n99 2.90889
R223 VSS.n172 VSS.n99 2.90889
R224 VSS.n132 VSS.n99 2.90889
R225 VSS.n170 VSS.n99 2.90889
R226 VSS.n169 VSS.n99 2.90889
R227 VSS.n167 VSS.n99 2.90889
R228 VSS.n165 VSS.n99 2.90889
R229 VSS.n163 VSS.n99 2.90889
R230 VSS.n161 VSS.n99 2.90889
R231 VSS.n266 VSS.n50 2.90889
R232 VSS.n269 VSS.n268 2.90889
R233 VSS.n269 VSS.n41 2.90889
R234 VSS.n269 VSS.n27 2.90889
R235 VSS.n270 VSS.n269 2.90889
R236 VSS.n269 VSS.n29 2.90889
R237 VSS.n266 VSS.n95 2.90889
R238 VSS.n266 VSS.n97 2.90889
R239 VSS.n266 VSS.n25 2.90889
R240 VSS.n2 VSS.n196 2.58401
R241 VSS.n259 VSS.n100 2.48783
R242 VSS.n185 VSS.n125 2.4776
R243 VSS.n258 VSS.n257 2.29843
R244 VSS.n210 VSS.t0 2.28126
R245 VSS.n2 VSS.n1 2.13249
R246 VSS.n261 VSS.n260 2.05831
R247 VSS.n224 VSS.n223 2.04367
R248 VSS.n227 VSS.n226 2.03271
R249 VSS.n226 VSS.n225 1.93451
R250 VSS.n225 VSS.n224 1.91764
R251 VSS.n266 VSS.n265 1.8487
R252 VSS.n269 VSS.n44 1.8487
R253 VSS.n272 VSS.n17 1.8487
R254 VSS.n259 VSS.n258 1.76292
R255 VSS.n223 VSS.n222 1.76118
R256 VSS.n261 VSS.n98 1.75669
R257 VSS.n10 VSS.n8 1.73433
R258 VSS.n217 VSS.n10 1.73378
R259 VSS.n219 VSS.n98 1.71284
R260 VSS.n260 VSS.n259 1.71112
R261 VSS.n222 VSS.n221 1.70839
R262 VSS.n269 VSS.n39 1.59848
R263 VSS.n273 VSS.n272 1.59759
R264 VSS.n272 VSS.n12 1.59759
R265 VSS.n94 VSS.n93 1.57737
R266 VSS.n76 VSS.n7 1.53505
R267 VSS.n264 VSS.n263 1.5339
R268 VSS.n213 VSS.n186 1.53114
R269 VSS.n266 VSS.n94 1.35542
R270 VSS.n272 VSS.n7 1.32671
R271 VSS.n276 VSS.n5 1.2589
R272 VSS.n215 VSS.n186 1.2426
R273 VSS.n39 VSS.n38 1.21019
R274 VSS.n273 VSS.n8 1.20776
R275 VSS.n217 VSS.n12 1.20776
R276 VSS.n197 VSS.n1 1.19138
R277 VSS.n197 VSS.n196 1.13436
R278 VSS.n265 VSS.n262 1.13264
R279 VSS.n37 VSS.n17 1.13264
R280 VSS.n218 VSS.n44 1.12974
R281 VSS.n272 VSS.n23 1.11839
R282 VSS.n274 VSS.n7 1.05289
R283 VSS.n199 VSS.n1 1.0264
R284 VSS.n194 VSS.n186 0.99964
R285 VSS.t3 VSS.n5 0.92626
R286 VSS.n196 VSS.n195 0.89902
R287 VSS.n272 VSS.n13 0.877984
R288 VSS.n272 VSS.n15 0.877984
R289 VSS.n272 VSS.n16 0.877984
R290 VSS.n272 VSS.n24 0.877984
R291 VSS.n272 VSS.n19 0.877984
R292 VSS.n272 VSS.n20 0.877984
R293 VSS.t0 VSS.n193 0.868949
R294 VSS.n264 VSS.n94 0.826421
R295 VSS.n263 VSS.n44 0.823269
R296 VSS.n157 VSS.n11 0.821507
R297 VSS.n265 VSS.n264 0.820362
R298 VSS.n17 VSS.n6 0.820362
R299 VSS.n275 VSS.n6 0.752028
R300 VSS.n275 VSS.n274 0.752028
R301 VSS.n225 VSS.n100 0.752028
R302 VSS.n207 VSS.n204 0.750366
R303 VSS.n202 VSS.n189 0.750048
R304 VSS.n189 VSS.n187 0.750029
R305 VSS.n204 VSS.n203 0.749723
R306 VSS.n12 VSS.n6 0.711767
R307 VSS.n274 VSS.n273 0.711767
R308 VSS.n263 VSS.n39 0.709644
R309 VSS.n87 VSS.n86 0.697396
R310 VSS.n208 VSS.n207 0.681944
R311 VSS.n215 VSS.n214 0.681298
R312 VSS.n198 VSS.n195 0.681298
R313 VSS.n199 VSS.n198 0.681279
R314 VSS.n214 VSS.n187 0.681279
R315 VSS.n248 VSS.n247 0.672587
R316 VSS.n208 VSS.n206 0.649735
R317 VSS.n207 VSS.n115 0.633
R318 VSS.n262 VSS.n261 0.633
R319 VSS.n219 VSS.n218 0.633
R320 VSS.n223 VSS.n8 0.633
R321 VSS.n221 VSS.n217 0.633
R322 VSS.n187 VSS.n128 0.633
R323 VSS.n227 VSS.n215 0.633
R324 VSS.n195 VSS.n194 0.633
R325 VSS.n200 VSS.n199 0.633
R326 VSS.n87 VSS.n76 0.582572
R327 VSS.n67 VSS.n60 0.582572
R328 VSS.n66 VSS.n65 0.582572
R329 VSS.n256 VSS.n255 0.582572
R330 VSS.n154 VSS.n153 0.582227
R331 VSS.n86 VSS.n85 0.582227
R332 VSS.n67 VSS.n66 0.582227
R333 VSS.n65 VSS.n64 0.582227
R334 VSS.n229 VSS.n228 0.582227
R335 VSS.n255 VSS.n254 0.582227
R336 VSS.n210 VSS.n192 0.576648
R337 VSS.n210 VSS.n205 0.576648
R338 VSS.n213 VSS.n190 0.576648
R339 VSS.n213 VSS.n191 0.576648
R340 VSS.n218 VSS.n217 0.523
R341 VSS.n38 VSS.n37 0.523
R342 VSS.n207 VSS.n187 0.523
R343 VSS.n203 VSS.n202 0.523
R344 VSS.n245 VSS.n244 0.467404
R345 VSS.n148 VSS.n147 0.467404
R346 VSS.n149 VSS.n148 0.467404
R347 VSS.n150 VSS.n149 0.467404
R348 VSS.n151 VSS.n150 0.467404
R349 VSS.n152 VSS.n151 0.467404
R350 VSS.n153 VSS.n152 0.467404
R351 VSS.n85 VSS.n84 0.467404
R352 VSS.n84 VSS.n83 0.467404
R353 VSS.n83 VSS.n82 0.467404
R354 VSS.n60 VSS.n33 0.467404
R355 VSS.n64 VSS.n53 0.467404
R356 VSS.n93 VSS.n53 0.467404
R357 VSS.n249 VSS.n248 0.467404
R358 VSS.n250 VSS.n249 0.467404
R359 VSS.n251 VSS.n250 0.467404
R360 VSS.n252 VSS.n251 0.467404
R361 VSS.n253 VSS.n252 0.467404
R362 VSS.n254 VSS.n253 0.467404
R363 VSS.n257 VSS.n256 0.467404
R364 VSS.n154 VSS.n48 0.465996
R365 VSS.n222 VSS.n99 0.437294
R366 VSS.n99 VSS.n98 0.437095
R367 VSS.n272 VSS.n10 0.436547
R368 VSS.n229 VSS.n128 0.424746
R369 VSS.n206 VSS.t0 0.403138
R370 VSS.n127 VSS.n117 0.379002
R371 VSS.n228 VSS.n227 0.378327
R372 VSS.n38 VSS.n33 0.354264
R373 VSS.n244 VSS.n243 0.350827
R374 VSS.n147 VSS.n42 0.350827
R375 VSS.n82 VSS.n22 0.350827
R376 VSS.n246 VSS.n245 0.337077
R377 VSS VSS.n276 0.32786
R378 VSS.n247 VSS.n246 0.274452
R379 VSS.n221 VSS.n220 0.2585
R380 VSS.n220 VSS.n219 0.2585
R381 VSS.n218 VSS.n42 0.237688
R382 VSS.n262 VSS.n48 0.237688
R383 VSS.n37 VSS.n22 0.237688
R384 VSS.n246 VSS.n112 0.236584
R385 VSS.n243 VSS.n115 0.23425
R386 VSS.n203 VSS.n201 0.227375
R387 VSS.n202 VSS.n188 0.227375
R388 VSS.n263 VSS.n6 0.2029
R389 VSS.n210 VSS.n209 0.194785
R390 VSS.n213 VSS.n212 0.194785
R391 VSS.n226 VSS.n185 0.154253
R392 VSS.n224 VSS.n99 0.152539
R393 VSS.n200 VSS.n193 0.144577
R394 VSS.n260 VSS.n99 0.13571
R395 VSS.n201 VSS.n200 0.09675
R396 VSS.n194 VSS.n188 0.09675
R397 VSS.n258 VSS.n99 0.0931878
R398 VSS.n128 VSS.n127 0.0831016
R399 VSS.n206 VSS.n112 0.0812339
R400 VSS.n272 VSS.n11 0.06816
R401 VSS.n117 VSS.n115 0.0626506
R402 VSS.n2 VSS.n0 0.0144612
R403 VSS.n3 VSS.t1 7.92592
R404 VSS.n158 VSS.n99 0.00494263
R405 VSS.n239 VSS.n101 0.00175
R406 VSS.n231 VSS.n118 0.00166667
R407 VSS.n116 VSS.n114 0.00166667
R408 VSS.n233 VSS.n110 0.00166667
R409 VSS.n120 VSS.n102 0.00166667
R410 VSS.n266 VSS.n49 0.00166667
R411 VSS.n59 VSS.n32 0.00166667
R412 VSS.n69 VSS.n59 0.00166667
R413 VSS.n61 VSS.n57 0.00166667
R414 VSS.n89 VSS.n75 0.00166667
R415 VSS.n88 VSS.n74 0.00166667
R416 VSS.n4 VSS.n210 0.00213335
R417 VSS.n242 VSS.n116 0.00133332
R418 VSS.n231 VSS.n230 0.00133332
R419 VSS.n233 VSS.n111 0.00133332
R420 VSS.n120 VSS.n103 0.00133332
R421 VSS.n155 VSS.n49 0.00133332
R422 VSS.n62 VSS.n57 0.00133332
R423 VSS.n69 VSS.n68 0.00133332
R424 VSS.n269 VSS.n32 0.00133332
R425 VSS.n77 VSS.n74 0.00133332
R426 VSS.n89 VSS.n88 0.00133332
R427 VSS.n239 VSS.n99 0.00124998
R428 VSS.n159 VSS.n99 0.00100001
R429 VSS.n242 VSS.n241 0.001
R430 VSS.n124 VSS.n114 0.001
R431 VSS.n232 VSS.n113 0.001
R432 VSS.n230 VSS.n126 0.001
R433 VSS.n123 VSS.n110 0.001
R434 VSS.n122 VSS.n109 0.001
R435 VSS.n121 VSS.n108 0.001
R436 VSS.n234 VSS.n106 0.001
R437 VSS.n235 VSS.n105 0.001
R438 VSS.n236 VSS.n104 0.001
R439 VSS.n237 VSS.n103 0.001
R440 VSS.n238 VSS.n102 0.001
R441 VSS.n185 VSS.n126 0.001
R442 VSS.n241 VSS.n118 0.001
R443 VSS.n124 VSS.n113 0.001
R444 VSS.n232 VSS.n111 0.001
R445 VSS.n123 VSS.n109 0.001
R446 VSS.n122 VSS.n108 0.001
R447 VSS.n121 VSS.n107 0.001
R448 VSS.n234 VSS.n107 0.001
R449 VSS.n235 VSS.n106 0.001
R450 VSS.n236 VSS.n105 0.001
R451 VSS.n237 VSS.n104 0.001
R452 VSS.n238 VSS.n101 0.001
R453 VSS.n216 VSS.n99 0.001
R454 VSS.n216 VSS.n185 0.001
R455 VSS.n146 VSS.n43 0.001
R456 VSS.n146 VSS.n135 0.001
R457 VSS.n144 VSS.n136 0.001
R458 VSS.n143 VSS.n137 0.001
R459 VSS.n142 VSS.n138 0.001
R460 VSS.n141 VSS.n139 0.001
R461 VSS.n141 VSS.n134 0.001
R462 VSS.n156 VSS.n155 0.001
R463 VSS.n269 VSS.n43 0.001
R464 VSS.n145 VSS.n135 0.001
R465 VSS.n145 VSS.n136 0.001
R466 VSS.n144 VSS.n137 0.001
R467 VSS.n143 VSS.n138 0.001
R468 VSS.n142 VSS.n139 0.001
R469 VSS.n140 VSS.n134 0.001
R470 VSS.n156 VSS.n140 0.001
R471 VSS.n266 VSS.n52 0.001
R472 VSS.n91 VSS.n54 0.001
R473 VSS.n55 VSS.n54 0.001
R474 VSS.n63 VSS.n56 0.001
R475 VSS.n61 VSS.n58 0.001
R476 VSS.n68 VSS.n58 0.001
R477 VSS.n62 VSS.n56 0.001
R478 VSS.n63 VSS.n55 0.001
R479 VSS.n92 VSS.n91 0.001
R480 VSS.n92 VSS.n52 0.001
R481 VSS.n81 VSS.n21 0.001
R482 VSS.n81 VSS.n70 0.001
R483 VSS.n80 VSS.n71 0.001
R484 VSS.n79 VSS.n72 0.001
R485 VSS.n78 VSS.n73 0.001
R486 VSS.n272 VSS.n9 0.001
R487 VSS.n75 VSS.n9 0.001
R488 VSS.n77 VSS.n73 0.001
R489 VSS.n78 VSS.n72 0.001
R490 VSS.n79 VSS.n71 0.001
R491 VSS.n80 VSS.n70 0.001
R492 VSS.n272 VSS.n21 0.001
R493 VSS.n3 VSS.n2 0.00100012
R494 VSS.n3 VSS.n197 8.44484
C0 SG_DVDD DOUT 1.76309f
C1 a_204_290# MID 0.04518f
C2 a_1692_290# a_204_1868# 0.03399f
C3 a_204_290# SG_DVDD 0.01778f
C4 a_1692_290# DOUT 0.03715f
C5 SG_DVDD MID 0.05391f
C6 SG_DVDD AIN 2.38422f
C7 DLT DOUT 0.39017f
C8 a_204_290# a_1692_290# 0.06223f
C9 a_1692_290# MID 0.4981f
C10 a_1692_290# AIN 0.21242f
C11 SG_DVDD a_1692_290# 1.01873f
C12 DLT AIN 0.6076f
C13 DHT DOUT 0.38223f
C14 DLT SG_DVDD 0.13045f
C15 DHT AIN 0.60744f
C16 SG_DVDD DHT 0.45788f
C17 a_204_290# a_204_1868# 0.02676f
C18 a_204_1868# MID 0.03532f
C19 AIN DOUT 0.90299f
C20 SG_DVDD a_204_1868# 0.29901f
C21 AIN VSS 13.73395f
C22 SG_DVDD VSS 2.88603p
C23 DLT VSS 4.50457f
C24 DHT VSS 0.23507f
C25 MID VSS 19.72004f
.ends
