** sch_path: /foss/designs/sg13cmos5l_slot3_backup/macros/schmitt_trigger_pullmid/schematic/xschem/schmitt_trigger_pullmid.sch
.subckt schmitt_trigger_pullmid SG_DVDD AIN DOUT VSS
*.PININFO SG_DVDD:B VSS:B AIN:I DOUT:O
XR1 SG_DVDD MID VSS rhigh w=0.5e-6 l=3.412e-05 m=1 b=0 mm_ok=1
XR2 MID VSS VSS rhigh w=0.5e-6 l=3.412e-05 m=1 b=0 mm_ok=1
XR3 AIN MID VSS rhigh w=0.5e-6 l=2.7172e-04 m=1 b=0 mm_ok=1
XM4 DOUT AIN DLT VSS sg13_lv_nmos w=1u l=0.3u ng=1 m=1 mm_ok=1
XM5 DHT AIN SG_DVDD SG_DVDD sg13_lv_pmos w=1u l=0.3u ng=1 m=1 mm_ok=1
XM3 DOUT AIN DHT SG_DVDD sg13_lv_pmos w=1u l=0.3u ng=1 m=1 mm_ok=1
XM7 VSS DOUT DHT SG_DVDD sg13_lv_pmos w=1u l=0.3u ng=1 m=1 mm_ok=1
XM6 DLT AIN VSS VSS sg13_lv_nmos w=1u l=0.3u ng=1 m=1 mm_ok=1
XM8 SG_DVDD DOUT DLT VSS sg13_lv_nmos w=1u l=0.3u ng=1 m=1 mm_ok=1
.ends
