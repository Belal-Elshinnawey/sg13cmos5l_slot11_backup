** sch_path: /foss/designs/sg13cmos5l_slot3_backup/macros/schmitt_trigger_pullmid/testbenches/xschem/schmitt_trigger_pullmid_tb_dc_pex.sch
**.subckt schmitt_trigger_pullmid_tb_dc_pex
x1 DVDD AIN DOUT GND schmitt_trigger_pullmid_pex
VAIN AIN GND PWL(0 0 4u 0 6u 1.2 10u 1.2)
VDVDD DVDD GND {DVDD}
**** begin user architecture code

.include ../../../netlist/pex/schmitt_trigger_pullmid_magic_pex_3.spice
.param DVDD=1.2
.csparam DVDD=DVDD
.temp 27
.options savecurrents klu method=gear reltol=1e-3 abstol=1e-12 gmin=1e-12
.control

save all

tran 100p 10u
write schmitt_trigger_pullmid_tb_dc_pex.raw

plot ain dout

unset appendwrite
set wr_vecnames
set wr_singlescale
wrdata ../plot_simulations/data/schmitt_trigger_pullmid_tb_dc_pex.txt v(ain) v(dout)

*quit
.endc

.lib cornerMOSlv.lib mos_tt
.lib cornerMOShv.lib mos_tt
.lib cornerRES.lib res_typ
.lib cornerCAP.lib cap_typ
.lib cornerDIO.lib dio_tt

**** end user architecture code
**.ends
.end
