** sch_path: /foss/designs/sg13cmos5l_slot3_backup/macros/schmitt_trigger_pullmid/schematic/xschem/schmitt_trigger_pullmid.sch
**.subckt schmitt_trigger_pullmid SG_DVDD AIN DOUT VSS
*.iopin SG_DVDD
*.iopin VSS
*.ipin AIN
*.opin DOUT
Vmeas6 AIN net1 0
.save i(vmeas6)
XR1 SG_DVDD MID VSS rhigh w=0.5e-6 l=3.1e-5 m=1 b=0 mm_ok=1
XR2 MID VSS VSS rhigh w=0.5e-6 l=3.1e-5 m=1 b=0 mm_ok=1
XR3 net1 MID VSS rhigh w=0.5e-6 l=2.5e-4 m=1 b=0 mm_ok=1
XC4 VSS SG_DVDD cap_cmomf w=30.0e-6 l=75.0e-6 mmin=1 mmax=4 subblock=0 m=1 mm_ok=1
XM4 DOUT net1 DLT VSS sg13_lv_nmos w=1u l=0.3u ng=1 m=1 mm_ok=1
XM5 DHT net1 SG_DVDD SG_DVDD sg13_lv_pmos w=1u l=0.3u ng=1 m=1 mm_ok=1
XM3 DOUT net1 DHT SG_DVDD sg13_lv_pmos w=1u l=0.3u ng=1 m=1 mm_ok=1
XM7 VSS DOUT DHT SG_DVDD sg13_lv_pmos w=1u l=0.3u ng=1 m=1 mm_ok=1
XM6 DLT net1 VSS VSS sg13_lv_nmos w=1u l=0.3u ng=1 m=1 mm_ok=1
XM8 SG_DVDD DOUT DLT VSS sg13_lv_nmos w=1u l=0.3u ng=1 m=1 mm_ok=1
**.ends
.end
