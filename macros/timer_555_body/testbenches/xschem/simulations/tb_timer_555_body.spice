** sch_path: /foss/designs/sg13cmos5l_slot3_backup/macros/timer_555_body/testbenches/xschem/tb_timer_555_body.sch
**.subckt tb_timer_555_body
v_avdd avdd_net GND dc 3.3
v_avdd1v2 avdd1v2_net GND dc 1.2
i_bias0 GND ibias0_net dc 4e-6
i_bias1 GND ibias1_net dc 4e-6
R1 avdd_net cap_net 10k
C1 cap_net GND 1n
x1 cap_net ff_q_net net1 cap_net ibias0_net cap_net avdd_net ff_qn_net avdd1v2_net GND ibias1_net timer_555_body
**** begin user architecture code

.lib $PDK_ROOT/$PDK/libs.tech/ngspice/models/cornerMOShv.lib mos_tt
.lib $PDK_ROOT/$PDK/libs.tech/ngspice/models/cornerMOSlv.lib mos_tt
.lib $PDK_ROOT/$PDK/libs.tech/ngspice/models/cornerRES.lib res_typ
.include $PDK_ROOT/$PDK/libs.ref/sg13cmos5l_stdcell/spice/sg13cmos5l_stdcell.spice

.op
.tran 10n 200u
.control
  run
  wrdata /foss/designs/sg13cmos5l_slot3_backup/macros/timer_555_body/testbenches/xschem/simulations/trace.txt v(cap_net) v(x1.p1_net) v(x1.vctrl) v(x1.set_b) v(x1.reset_b) v(x1.net1) v(x1.net2) v(x1.ff_q)
.endc

**** end user architecture code
**.ends

* expanding   symbol:  timer_555_body.sym # of pins=11
** sym_path: /foss/designs/sg13cmos5l_slot3_backup/macros/timer_555_body/schematic/xschem/timer_555_body.sym
** sch_path: /foss/designs/sg13cmos5l_slot3_backup/macros/timer_555_body/schematic/xschem/timer_555_body.sch
.subckt timer_555_body disch ff_q vctrl threshold ibias0 trigger AVDD ff_qn AVDD1V2 AVSS ibias1
*.iopin ff_q
*.iopin ff_qn
*.iopin ibias0
*.iopin ibias1
*.iopin vctrl
*.iopin disch
*.iopin AVDD
*.iopin AVDD1V2
*.iopin AVSS
*.iopin threshold
*.iopin trigger
x1 p1_net threshold ibias0 set_b AVDD AVSS AVDD1V2 comparator_slice
x2 trigger vctrl ibias1 reset_b AVDD AVSS AVDD1V2 comparator_slice
x4 AVDD AVSS AVDD p1_net vctrl AVSS resistor_network
x3 AVDD net2 ff_q AVSS AVDD1V2 level_up_shifter W_P_HV=3.0u L_P_HV=0.50u W_N_HV=10.0u L_N_HV=0.50u W_P_LV=1.0u L_P_LV=0.13u
+ W_N_LV=1.0u L_N_LV=0.13u
x5 AVDD net1 ff_qn AVSS AVDD1V2 level_up_shifter W_P_HV=3.0u L_P_HV=0.50u W_N_HV=10.0u L_N_HV=0.50u W_P_LV=1.0u L_P_LV=0.13u
+ W_N_LV=1.0u L_N_LV=0.13u
XMdisch disch ff_q AVSS AVSS sg13_hv_nmos w=20u l=1u ng=10 m=1 mm_ok=1
x6 net2 set_b net1 AVDD1V2 AVSS sg13cmos5l_nand2_2
x7 net1 reset_b net2 AVDD1V2 AVSS sg13cmos5l_nand2_2
.ends

* expanding   symbol:  comparator_slice.sym # of pins=7
** sym_path: /foss/designs/sg13cmos5l_slot3_backup/macros/comparator/schematic/xschem/comparator_slice.sym
** sch_path: /foss/designs/sg13cmos5l_slot3_backup/macros/comparator/schematic/xschem/comparator_slice.sch
.subckt comparator_slice inp inn ibias out AVDD AVSS AVDD1V2
*.iopin inp
*.iopin inn
*.iopin ibias
*.iopin AVDD
*.iopin AVSS
*.iopin out
*.iopin AVDD1V2
xM3[15] n1 n1 AVDD AVDD p1_4
xM3[14] n1 n1 AVDD AVDD p1_4
xM3[13] n1 n1 AVDD AVDD p1_4
xM3[12] n1 n1 AVDD AVDD p1_4
xM3[11] n1 n1 AVDD AVDD p1_4
xM3[10] n1 n1 AVDD AVDD p1_4
xM3[9] n1 n1 AVDD AVDD p1_4
xM3[8] n1 n1 AVDD AVDD p1_4
xM3[7] n1 n1 AVDD AVDD p1_4
xM3[6] n1 n1 AVDD AVDD p1_4
xM3[5] n1 n1 AVDD AVDD p1_4
xM3[4] n1 n1 AVDD AVDD p1_4
xM3[3] n1 n1 AVDD AVDD p1_4
xM3[2] n1 n1 AVDD AVDD p1_4
xM3[1] n1 n1 AVDD AVDD p1_4
xM3[0] n1 n1 AVDD AVDD p1_4
xM4[15] outx n1 AVDD AVDD p1_4
xM4[14] outx n1 AVDD AVDD p1_4
xM4[13] outx n1 AVDD AVDD p1_4
xM4[12] outx n1 AVDD AVDD p1_4
xM4[11] outx n1 AVDD AVDD p1_4
xM4[10] outx n1 AVDD AVDD p1_4
xM4[9] outx n1 AVDD AVDD p1_4
xM4[8] outx n1 AVDD AVDD p1_4
xM4[7] outx n1 AVDD AVDD p1_4
xM4[6] outx n1 AVDD AVDD p1_4
xM4[5] outx n1 AVDD AVDD p1_4
xM4[4] outx n1 AVDD AVDD p1_4
xM4[3] outx n1 AVDD AVDD p1_4
xM4[2] outx n1 AVDD AVDD p1_4
xM4[1] outx n1 AVDD AVDD p1_4
xM4[0] outx n1 AVDD AVDD p1_4
xM1[15] n1 inp tail AVSS n1_4
xM1[14] n1 inp tail AVSS n1_4
xM1[13] n1 inp tail AVSS n1_4
xM1[12] n1 inp tail AVSS n1_4
xM1[11] n1 inp tail AVSS n1_4
xM1[10] n1 inp tail AVSS n1_4
xM1[9] n1 inp tail AVSS n1_4
xM1[8] n1 inp tail AVSS n1_4
xM1[7] n1 inp tail AVSS n1_4
xM1[6] n1 inp tail AVSS n1_4
xM1[5] n1 inp tail AVSS n1_4
xM1[4] n1 inp tail AVSS n1_4
xM1[3] n1 inp tail AVSS n1_4
xM1[2] n1 inp tail AVSS n1_4
xM1[1] n1 inp tail AVSS n1_4
xM1[0] n1 inp tail AVSS n1_4
xM2[15] outx inn tail AVSS n1_4
xM2[14] outx inn tail AVSS n1_4
xM2[13] outx inn tail AVSS n1_4
xM2[12] outx inn tail AVSS n1_4
xM2[11] outx inn tail AVSS n1_4
xM2[10] outx inn tail AVSS n1_4
xM2[9] outx inn tail AVSS n1_4
xM2[8] outx inn tail AVSS n1_4
xM2[7] outx inn tail AVSS n1_4
xM2[6] outx inn tail AVSS n1_4
xM2[5] outx inn tail AVSS n1_4
xM2[4] outx inn tail AVSS n1_4
xM2[3] outx inn tail AVSS n1_4
xM2[2] outx inn tail AVSS n1_4
xM2[1] outx inn tail AVSS n1_4
xM2[0] outx inn tail AVSS n1_4
xM5[15] tail ibias AVSS AVSS n1_4
xM5[14] tail ibias AVSS AVSS n1_4
xM5[13] tail ibias AVSS AVSS n1_4
xM5[12] tail ibias AVSS AVSS n1_4
xM5[11] tail ibias AVSS AVSS n1_4
xM5[10] tail ibias AVSS AVSS n1_4
xM5[9] tail ibias AVSS AVSS n1_4
xM5[8] tail ibias AVSS AVSS n1_4
xM5[7] tail ibias AVSS AVSS n1_4
xM5[6] tail ibias AVSS AVSS n1_4
xM5[5] tail ibias AVSS AVSS n1_4
xM5[4] tail ibias AVSS AVSS n1_4
xM5[3] tail ibias AVSS AVSS n1_4
xM5[2] tail ibias AVSS AVSS n1_4
xM5[1] tail ibias AVSS AVSS n1_4
xM5[0] tail ibias AVSS AVSS n1_4
xMref[15] ibias ibias AVSS AVSS n1_4
xMref[14] ibias ibias AVSS AVSS n1_4
xMref[13] ibias ibias AVSS AVSS n1_4
xMref[12] ibias ibias AVSS AVSS n1_4
xMref[11] ibias ibias AVSS AVSS n1_4
xMref[10] ibias ibias AVSS AVSS n1_4
xMref[9] ibias ibias AVSS AVSS n1_4
xMref[8] ibias ibias AVSS AVSS n1_4
xMref[7] ibias ibias AVSS AVSS n1_4
xMref[6] ibias ibias AVSS AVSS n1_4
xMref[5] ibias ibias AVSS AVSS n1_4
xMref[4] ibias ibias AVSS AVSS n1_4
xMref[3] ibias ibias AVSS AVSS n1_4
xMref[2] ibias ibias AVSS AVSS n1_4
xMref[1] ibias ibias AVSS AVSS n1_4
xMref[0] ibias ibias AVSS AVSS n1_4
xMinvp outhv outx AVDD AVDD p1_4
xMinvn outhv outx AVSS AVSS n1_4
xMinvp2 out outhv AVDD1V2 AVDD1V2 p1_4
xMinvn2 out outhv AVSS AVSS n1_4
.ends

* expanding   symbol:  resistor_network.sym # of pins=6
** sym_path: /foss/designs/sg13cmos5l_slot3_backup/macros/resistor_network/schematic/xschem/resistor_network.sym
** sch_path: /foss/designs/sg13cmos5l_slot3_backup/macros/resistor_network/schematic/xschem/resistor_network.sch
.subckt resistor_network pt VSS VDD p1 p2 pb
*.iopin pt
*.iopin VDD
*.iopin VSS
*.iopin p1
*.iopin p2
*.iopin pb
xA pt VSS VDD a_p1 p1 n_ab resistor_leg
xB n_ab VSS VDD p2 b_p2 pb resistor_leg
xC pt VSS VDD c_p1 p1 n_cd resistor_leg
xD n_cd VSS VDD p2 d_p2 pb resistor_leg
.ends

* expanding   symbol:  /foss/designs/sg13cmos5l_slot3_backup/macros/level_shifter/schematic/xschem/level_up_shifter.sym # of
*+ pins=5
** sym_path: /foss/designs/sg13cmos5l_slot3_backup/macros/level_shifter/schematic/xschem/level_up_shifter.sym
** sch_path: /foss/designs/sg13cmos5l_slot3_backup/macros/level_shifter/schematic/xschem/level_up_shifter.sch
.subckt level_up_shifter VDD2 A B VSS VDD1  W_P_HV=3.0u L_P_HV=0.50u W_N_HV=10.0u L_N_HV=0.50u W_P_LV=1.0u L_P_LV=0.13u
+ W_N_LV=1.0u L_N_LV=0.13u
*.iopin VSS
*.iopin VDD2
*.opin B
*.ipin A
*.iopin VDD1
XM1 net1 AB VSS VSS sg13_hv_nmos w=10u l=0.5u ng=1 m=1 mm_ok=1
XM4 T net1 VDD2 VDD2 sg13_hv_pmos w=1u l=0.5u ng=1 m=1 mm_ok=1
XM3 net1 T VDD2 VDD2 sg13_hv_pmos w=1u l=0.5u ng=1 m=1 mm_ok=1
XM2 T AM VSS VSS sg13_hv_nmos w=10u l=0.5u ng=1 m=1 mm_ok=1
XM5 B T VDD2 VDD2 sg13_hv_pmos w=3u l=0.5u ng=1 m=1 mm_ok=1
XM6 B T VSS VSS sg13_hv_nmos w=1u l=0.5u ng=1 m=1 mm_ok=1
XM7 VSS VSS VSS VSS sg13_hv_nmos w=1u l=0.5u ng=1 m=1 mm_ok=1
XM8 VDD2 VDD2 VDD2 VDD2 sg13_hv_pmos w=3u l=0.5u ng=1 m=1 mm_ok=1
XM9 VDD1 VDD1 VDD1 VDD1 sg13_lv_pmos w=1u l=0.13u ng=1 m=1 mm_ok=1
XM12 AB A VDD1 VDD1 sg13_lv_pmos w=1u l=0.13u ng=1 m=1 mm_ok=1
XM10 VSS VSS VSS VSS sg13_lv_nmos w=1u l=0.13u ng=1 m=1 mm_ok=1
XM11 VDD1 VDD1 VDD1 VDD1 sg13_lv_pmos w=1u l=0.13u ng=1 m=1 mm_ok=1
XM14 AM AB VDD1 VDD1 sg13_lv_pmos w=1u l=0.13u ng=1 m=1 mm_ok=1
XM15 VSS VSS VSS VSS sg13_lv_nmos w=1u l=0.13u ng=1 m=1 mm_ok=1
XM17 AB A VSS VSS sg13_lv_nmos w=1u l=0.13u ng=1 m=1 mm_ok=1
XM13 AM AB VSS VSS sg13_lv_nmos w=1u l=0.13u ng=1 m=1 mm_ok=1
XM16 AB AB AB VSS sg13_lv_nmos w=1u l=0.13u ng=1 m=1 mm_ok=1
XM18 AB AB AB VDD1 sg13_lv_pmos w=1u l=0.13u ng=1 m=1 mm_ok=1
XM19 AM AM AM VDD1 sg13_lv_pmos w=1u l=0.13u ng=1 m=1 mm_ok=1
XM20 AM AM AM VSS sg13_lv_nmos w=1u l=0.13u ng=1 m=1 mm_ok=1
XM21 B B B VDD2 sg13_hv_pmos w=3u l=0.5u ng=1 m=1 mm_ok=1
XM22 B B B VSS sg13_hv_nmos w=1u l=0.5u ng=1 m=1 mm_ok=1
.ends

* expanding   symbol:  p1_4.sym # of pins=4
** sym_path: /foss/designs/sg13cmos5l_slot3_backup/macros/comparator/schematic/xschem/p1_4.sym
** sch_path: /foss/designs/sg13cmos5l_slot3_backup/macros/comparator/schematic/xschem/p1_4.sch
.subckt p1_4 D G S B
*.iopin D
*.iopin G
*.iopin S
*.iopin B
xp1 D G S B p1_2
xp2 D G S B p1_2
.ends

* expanding   symbol:  n1_4.sym # of pins=4
** sym_path: /foss/designs/sg13cmos5l_slot3_backup/macros/comparator/schematic/xschem/n1_4.sym
** sch_path: /foss/designs/sg13cmos5l_slot3_backup/macros/comparator/schematic/xschem/n1_4.sch
.subckt n1_4 D G S B
*.iopin D
*.iopin G
*.iopin S
*.iopin B
xp1 D G S B n1_2
xp2 D G S B n1_2
.ends

* expanding   symbol:  resistor_leg.sym # of pins=6
** sym_path: /foss/designs/sg13cmos5l_slot3_backup/macros/resistor_network/schematic/xschem/resistor_leg.sym
** sch_path: /foss/designs/sg13cmos5l_slot3_backup/macros/resistor_network/schematic/xschem/resistor_leg.sch
.subckt resistor_leg pt VSS VDD p1 p2 pb
*.iopin pt
*.iopin pb
*.iopin p2
*.iopin p1
*.iopin VDD
*.iopin VSS
XR1 pt p1 VDD rhigh w=0.5e-6 l=13.42e-6 m=8 b=0 mm_ok=1
XR2 p1 p2 VDD rhigh w=0.5e-6 l=13.42e-6 m=8 b=0 mm_ok=1
XR3 p2 pb VDD rhigh w=0.5e-6 l=13.42e-6 m=8 b=0 mm_ok=1
XRdummy VSS VSS VDD rhigh w=0.5e-6 l=13.42e-6 m=24 b=0 mm_ok=1
.ends

* expanding   symbol:  p1_2.sym # of pins=4
** sym_path: /foss/designs/sg13cmos5l_slot3_backup/macros/comparator/schematic/xschem/p1_2.sym
** sch_path: /foss/designs/sg13cmos5l_slot3_backup/macros/comparator/schematic/xschem/p1_2.sch
.subckt p1_2 D G S B
*.iopin G
*.iopin D
*.iopin S
*.iopin B
XMbot D G X B sg13_hv_pmos w=2.5e-6 l=1e-6 ng=1 m=1 mm_ok=1
XMtop X G S B sg13_hv_pmos w=2.5e-6 l=1e-6 ng=1 m=1 mm_ok=1
.ends

* expanding   symbol:  n1_2.sym # of pins=4
** sym_path: /foss/designs/sg13cmos5l_slot3_backup/macros/comparator/schematic/xschem/n1_2.sym
** sch_path: /foss/designs/sg13cmos5l_slot3_backup/macros/comparator/schematic/xschem/n1_2.sch
.subckt n1_2 D G S B
*.iopin G
*.iopin D
*.iopin S
*.iopin B
XMbot D G X B sg13_hv_nmos w=2.5e-6 l=1e-6 ng=1 m=1 mm_ok=1
XMtop X G S B sg13_hv_nmos w=2.5e-6 l=1e-6 ng=1 m=1 mm_ok=1
.ends

.GLOBAL GND
.end
