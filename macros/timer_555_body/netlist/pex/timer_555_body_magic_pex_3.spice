* PEX produced on Mon Nov  9 05:09:39 AM CET 2026 using /foss/tools/sak/sak-pex.sh with m=3 and s=1 (extresist threshold=10000 mOhm, minres=1000 mOhm, mindelay=1 ps)
* NGSPICE file created from timer_555_body_pex.ext - technology: ihp-sg13cmos5l

.subckt timer_555_body_pex set_b reset_b vctrl threshold ibias0 trigger AVDD
+ AVDD1V2 AVSS ibias1
X0 a_53873_39366# resistor_network_0.p1 comparator_slice_1.comparator_body_0.mref_m5_diff_0.tail.t24 AVSS.t139 sg13_hv_nmos ad=0.85p pd=5.68u as=0.85p ps=5.68u w=2.5u l=1u
X1 a_53873_35224# threshold.t13 comparator_slice_1.comparator_body_0.mref_m5_diff_0.tail.t41 AVSS.t23 sg13_hv_nmos ad=0.85p pd=5.68u as=0.85p ps=5.68u w=2.5u l=1u
X2 comparator_slice_0.comparator_body_0.mref_m5_diff_0.tail.t57 ibias0.t12 a_57666_14074# AVSS.t59 sg13_hv_nmos ad=0.85p pd=5.68u as=0.85p ps=5.68u w=2.5u l=1u
X3 a_50318_5264# comparator_slice_0.comparator_body_0.m3_m4_diff_0.n1.t90 comparator_slice_0.comparator_body_0.outx.t62 AVDD.t0 sg13_hv_pmos ad=0.85p pd=5.68u as=0.85p ps=5.68u w=2.5u l=1u
X4 AVSS.t0 AVSS.t0 AVDD.t3 rhigh l=13.42u w=0.5u
X5 resistor_network_0.pb resistor_network_0.resistor_leg_1.p2 AVDD.t3 rhigh l=13.42u w=0.5u
X6 comparator_slice_0.comparator_body_0.mref_m5_diff_0.tail.t36 ibias0.t32 a_57082_12648# AVSS.t89 sg13_hv_nmos ad=0.85p pd=5.68u as=0.85p ps=5.68u w=2.5u l=1u
X7 a_53289_45977# resistor_network_0.p1 comparator_slice_1.comparator_body_0.m3_m4_diff_0.n1.t78 AVSS.t137 sg13_hv_nmos ad=0.85p pd=5.68u as=0.85p ps=5.68u w=2.5u l=1u
X8 a_53289_43497# resistor_network_0.p1 comparator_slice_1.comparator_body_0.m3_m4_diff_0.n1.t70 AVSS.t137 sg13_hv_nmos ad=0.85p pd=5.68u as=0.85p ps=5.68u w=2.5u l=1u
X9 AVSS.t56 ibias0.t42 a_57666_22640# AVSS.t59 sg13_hv_nmos ad=0.85p pd=5.68u as=0.85p ps=5.68u w=2.5u l=1u
X10 ibias0.t29 ibias0.t28 a_57082_9078# AVSS.t102 sg13_hv_nmos ad=0.85p pd=5.68u as=0.85p ps=5.68u w=2.5u l=1u
X11 AVSS.t73 ibias0.t52 a_57666_17644# AVSS.t59 sg13_hv_nmos ad=0.85p pd=5.68u as=0.85p ps=5.68u w=2.5u l=1u
X12 a_56766_28641# ibias1.t46 ibias1.t47 AVSS.t57 sg13_hv_nmos ad=0.85p pd=5.68u as=0.85p ps=5.68u w=2.5u l=1u
X13 AVSS.t45 AVSS.t46 AVDD.t3 rhigh l=13.42u w=0.5u
X14 comparator_slice_0.comparator_body_0.m3_m4_diff_0.n1.t24 trigger.t6 a_54186_7784# AVSS.t30 sg13_hv_nmos ad=0.85p pd=5.68u as=0.85p ps=5.68u w=2.5u l=1u
X15 AVSS.t147 AVSS.t148 AVDD.t3 rhigh l=13.42u w=0.5u
X16 AVDD.t49 comparator_slice_1.comparator_body_0.m3_m4_diff_0.n1.t2 a_51218_47207# AVDD.t4 sg13_hv_pmos ad=0.85p pd=5.68u as=0.85p ps=5.68u w=2.5u l=1u
X17 AVDD.t23 comparator_slice_1.comparator_body_0.m3_m4_diff_0.n1.t40 a_51218_43637# AVDD.t4 sg13_hv_pmos ad=0.85p pd=5.68u as=0.85p ps=5.68u w=2.5u l=1u
X18 AVSS.t116 ibias0.t60 a_57666_6462# AVSS.t103 sg13_hv_nmos ad=0.85p pd=5.68u as=0.85p ps=5.68u w=2.5u l=1u
X19 comparator_slice_0.comparator_body_0.m3_m4_diff_0.n1.t35 comparator_slice_0.comparator_body_0.m3_m4_diff_0.n1.t34 a_51802_7644# AVDD.t0 sg13_hv_pmos ad=0.85p pd=5.68u as=0.85p ps=5.68u w=2.5u l=1u
X20 a_50902_35047# comparator_slice_1.comparator_body_0.m3_m4_diff_0.n1.t48 AVDD.t112 AVDD.t4 sg13_hv_pmos ad=0.85p pd=5.68u as=0.85p ps=5.68u w=2.5u l=1u
X21 resistor_network_0.resistor_leg_0.pt vctrl.t25 AVDD.t3 rhigh l=13.42u w=0.5u
X22 comparator_slice_1.comparator_body_0.m3_m4_diff_0.n1.t9 comparator_slice_1.comparator_body_0.m3_m4_diff_0.n1.t8 a_51802_31347# AVDD.t4 sg13_hv_pmos ad=0.85p pd=5.68u as=0.85p ps=5.68u w=2.5u l=1u
X23 a_53289_29834# resistor_network_0.p1 comparator_slice_1.comparator_body_0.m3_m4_diff_0.n1.t79 AVSS.t21 sg13_hv_nmos ad=0.85p pd=5.68u as=0.85p ps=5.68u w=2.5u l=1u
X24 a_53290_9435# vctrl.t41 comparator_slice_0.comparator_body_0.outx.t39 AVSS.t146 sg13_hv_nmos ad=0.85p pd=5.68u as=0.85p ps=5.68u w=2.5u l=1u
X25 a_53289_27354# resistor_network_0.p1 comparator_slice_1.comparator_body_0.m3_m4_diff_0.n1.t91 AVSS.t21 sg13_hv_nmos ad=0.85p pd=5.68u as=0.85p ps=5.68u w=2.5u l=1u
X26 a_50318_12534# comparator_slice_0.comparator_body_0.m3_m4_diff_0.n1.t38 comparator_slice_0.comparator_body_0.outx.t4 AVDD.t0 sg13_hv_pmos ad=0.85p pd=5.68u as=0.85p ps=5.68u w=2.5u l=1u
X27 comparator_slice_1.comparator_body_0.m3_m4_diff_0.n1.t93 resistor_network_0.p1 a_54186_45977# AVSS.t138 sg13_hv_nmos ad=0.85p pd=5.68u as=0.85p ps=5.68u w=2.5u l=1u
X28 comparator_slice_1.comparator_body_0.m3_m4_diff_0.n1.t90 resistor_network_0.p1 a_54186_43497# AVSS.t138 sg13_hv_nmos ad=0.85p pd=5.68u as=0.85p ps=5.68u w=2.5u l=1u
X29 a_56182_5272# ibias0.t38 comparator_slice_0.comparator_body_0.mref_m5_diff_0.tail.t47 AVSS.t91 sg13_hv_nmos ad=0.85p pd=5.68u as=0.85p ps=5.68u w=2.5u l=1u
X30 comparator_slice_1.comparator_body_0.m3_m4_diff_0.n1.t3 comparator_slice_1.comparator_body_0.m3_m4_diff_0.n1.t2 a_51218_47207# AVDD.t4 sg13_hv_pmos ad=0.85p pd=5.68u as=0.85p ps=5.68u w=2.5u l=1u
X31 a_56766_39823# ibias1.t8 AVSS.t194 AVSS.t189 sg13_hv_nmos ad=0.85p pd=5.68u as=0.85p ps=5.68u w=2.5u l=1u
X32 vctrl.t16 resistor_network_0.resistor_leg_1.pt AVDD.t3 rhigh l=13.42u w=0.5u
X33 a_50318_43637# comparator_slice_1.comparator_body_0.m3_m4_diff_0.n1.t28 comparator_slice_1.comparator_body_0.outx.t14 AVDD.t4 sg13_hv_pmos ad=0.85p pd=5.68u as=0.85p ps=5.68u w=2.5u l=1u
X34 comparator_slice_1.comparator_body_0.m3_m4_diff_0.n1.t27 comparator_slice_1.comparator_body_0.m3_m4_diff_0.n1.t26 a_51218_39937# AVDD.t4 sg13_hv_pmos ad=0.85p pd=5.68u as=0.85p ps=5.68u w=2.5u l=1u
X35 a_60444_13955# comparator_slice_0.comparator_body_0.outx.t67 a_60176_13955# AVSS.t131 sg13_hv_nmos ad=0.85p pd=5.68u as=0.85p ps=5.68u w=2.5u l=1u
X36 comparator_slice_0.comparator_body_0.m3_m4_diff_0.n1.t79 comparator_slice_0.comparator_body_0.m3_m4_diff_0.n1.t78 a_51218_13854# AVDD.t0 sg13_hv_pmos ad=0.85p pd=5.68u as=0.85p ps=5.68u w=2.5u l=1u
X37 a_50902_19934# comparator_slice_0.comparator_body_0.m3_m4_diff_0.n1.t42 AVDD.t122 AVDD.t0 sg13_hv_pmos ad=0.85p pd=5.68u as=0.85p ps=5.68u w=2.5u l=1u
X38 AVSS.t133 AVSS.t134 AVDD.t3 rhigh l=13.42u w=0.5u
X39 AVSS.t183 ibias1.t4 a_57666_42203# AVSS.t167 sg13_hv_nmos ad=0.85p pd=5.68u as=0.85p ps=5.68u w=2.5u l=1u
X40 AVSS.t11 AVSS.t11 AVDD.t3 rhigh l=13.42u w=0.5u
X41 AVSS.t202 ibias1.t30 a_57666_37207# AVSS.t59 sg13_hv_nmos ad=0.85p pd=5.68u as=0.85p ps=5.68u w=2.5u l=1u
X42 AVSS.t205 ibias1.t38 a_57666_33637# AVSS.t59 sg13_hv_nmos ad=0.85p pd=5.68u as=0.85p ps=5.68u w=2.5u l=1u
X43 comparator_slice_0.comparator_body_0.mref_m5_diff_0.tail.t1 trigger.t24 a_54772_20207# AVSS.t24 sg13_hv_nmos ad=0.85p pd=5.68u as=0.85p ps=5.68u w=2.5u l=1u
X44 AVSS.t15 AVSS.t15 AVDD.t3 rhigh l=13.42u w=0.5u
X45 a_56766_7652# ibias0.t0 ibias0.t1 AVSS.t93 sg13_hv_nmos ad=0.85p pd=5.68u as=0.85p ps=5.68u w=2.5u l=1u
X46 comparator_slice_1.comparator_body_0.m3_m4_diff_0.n1.t84 resistor_network_0.p1 a_54186_29834# AVSS.t22 sg13_hv_nmos ad=0.85p pd=5.68u as=0.85p ps=5.68u w=2.5u l=1u
X47 a_62934_39143# a_60176_37898# set_b AVDD1V2 sg13_hv_pmos ad=0.85p pd=5.68u as=0.85p ps=5.68u w=2.5u l=1u
X48 comparator_slice_1.comparator_body_0.m3_m4_diff_0.n1.t77 resistor_network_0.p1 a_54186_27354# AVSS.t22 sg13_hv_nmos ad=0.85p pd=5.68u as=0.85p ps=5.68u w=2.5u l=1u
X49 AVDD.t82 comparator_slice_0.comparator_body_0.m3_m4_diff_0.n1.t72 a_51802_21124# AVDD.t0 sg13_hv_pmos ad=0.85p pd=5.68u as=0.85p ps=5.68u w=2.5u l=1u
X50 AVDD.t71 comparator_slice_1.comparator_body_0.m3_m4_diff_0.n1.t26 a_51218_38747# AVDD.t4 sg13_hv_pmos ad=0.85p pd=5.68u as=0.85p ps=5.68u w=2.5u l=1u
X51 comparator_slice_1.comparator_body_0.mref_m5_diff_0.tail.t77 ibias1.t4 a_57666_42203# AVSS.t167 sg13_hv_nmos ad=0.85p pd=5.68u as=0.85p ps=5.68u w=2.5u l=1u
X52 a_62350_39143# a_60176_37898# AVDD1V2 AVDD1V2 sg13_hv_pmos ad=0.85p pd=5.68u as=0.85p ps=5.68u w=2.5u l=1u
X53 comparator_slice_1.comparator_body_0.mref_m5_diff_0.tail.t95 ibias1.t30 a_57666_37207# AVSS.t59 sg13_hv_nmos ad=0.85p pd=5.68u as=0.85p ps=5.68u w=2.5u l=1u
X54 vctrl.t18 resistor_network_0.resistor_leg_0.pt AVDD.t3 rhigh l=13.42u w=0.5u
X55 AVSS.t150 AVSS.t151 AVDD.t3 rhigh l=13.42u w=0.5u
X56 comparator_slice_0.comparator_body_0.m3_m4_diff_0.n1.t1 trigger.t24 a_54772_20207# AVSS.t24 sg13_hv_nmos ad=0.85p pd=5.68u as=0.85p ps=5.68u w=2.5u l=1u
X57 a_50902_16234# comparator_slice_0.comparator_body_0.m3_m4_diff_0.n1.t40 AVDD.t10 AVDD.t0 sg13_hv_pmos ad=0.85p pd=5.68u as=0.85p ps=5.68u w=2.5u l=1u
X58 a_53289_21447# trigger.t27 comparator_slice_0.comparator_body_0.m3_m4_diff_0.n1.t8 AVSS.t21 sg13_hv_nmos ad=0.85p pd=5.68u as=0.85p ps=5.68u w=2.5u l=1u
X59 AVDD.t90 comparator_slice_0.comparator_body_0.m3_m4_diff_0.n1.t80 a_51802_4074# AVDD.t0 sg13_hv_pmos ad=0.85p pd=5.68u as=0.85p ps=5.68u w=2.5u l=1u
X60 comparator_slice_0.comparator_body_0.outx.t16 comparator_slice_0.comparator_body_0.m3_m4_diff_0.n1.t72 a_51802_21124# AVDD.t0 sg13_hv_pmos ad=0.85p pd=5.68u as=0.85p ps=5.68u w=2.5u l=1u
X61 comparator_slice_1.comparator_body_0.outx.t53 threshold.t22 a_54186_41846# AVSS.t138 sg13_hv_nmos ad=0.85p pd=5.68u as=0.85p ps=5.68u w=2.5u l=1u
X62 comparator_slice_1.comparator_body_0.mref_m5_diff_0.tail.t11 resistor_network_0.p1 a_54772_28594# AVSS.t24 sg13_hv_nmos ad=0.85p pd=5.68u as=0.85p ps=5.68u w=2.5u l=1u
X63 a_50318_38747# comparator_slice_1.comparator_body_0.m3_m4_diff_0.n1.t46 comparator_slice_1.comparator_body_0.outx.t17 AVDD.t4 sg13_hv_pmos ad=0.85p pd=5.68u as=0.85p ps=5.68u w=2.5u l=1u
X64 vctrl.t19 resistor_network_0.resistor_leg_1.p2 AVDD.t3 rhigh l=13.42u w=0.5u
X65 comparator_slice_1.comparator_body_0.m3_m4_diff_0.n1.t21 comparator_slice_1.comparator_body_0.m3_m4_diff_0.n1.t20 a_51218_35047# AVDD.t4 sg13_hv_pmos ad=0.85p pd=5.68u as=0.85p ps=5.68u w=2.5u l=1u
X66 a_61058_39143# comparator_slice_1.comparator_body_0.outx.t66 AVDD.t76 AVDD.t76 sg13_hv_pmos ad=0.85p pd=5.68u as=0.85p ps=5.68u w=2.5u l=1u
X67 a_53873_33984# resistor_network_0.p1 comparator_slice_1.comparator_body_0.mref_m5_diff_0.tail.t9 AVSS.t23 sg13_hv_nmos ad=0.85p pd=5.68u as=0.85p ps=5.68u w=2.5u l=1u
X68 a_56766_11458# ibias0.t56 AVSS.t98 AVSS.t95 sg13_hv_nmos ad=0.85p pd=5.68u as=0.85p ps=5.68u w=2.5u l=1u
X69 a_53873_9435# trigger.t9 comparator_slice_0.comparator_body_0.mref_m5_diff_0.tail.t10 AVSS.t31 sg13_hv_nmos ad=0.85p pd=5.68u as=0.85p ps=5.68u w=2.5u l=1u
X70 a_53873_16057# vctrl.t51 comparator_slice_0.comparator_body_0.mref_m5_diff_0.tail.t76 AVSS.t23 sg13_hv_nmos ad=0.85p pd=5.68u as=0.85p ps=5.68u w=2.5u l=1u
X71 resistor_network_0.resistor_leg_3.p1 resistor_network_0.p1 AVDD.t3 rhigh l=13.42u w=0.5u
X72 a_56766_44819# ibias1.t2 comparator_slice_1.comparator_body_0.mref_m5_diff_0.tail.t82 AVSS.t165 sg13_hv_nmos ad=0.85p pd=5.68u as=0.85p ps=5.68u w=2.5u l=1u
X73 resistor_network_0.resistor_leg_1.pt vctrl.t11 AVDD.t3 rhigh l=13.42u w=0.5u
X74 AVDD.t2 comparator_slice_0.comparator_body_0.m3_m4_diff_0.n1.t36 a_51218_8964# AVDD.t0 sg13_hv_pmos ad=0.85p pd=5.68u as=0.85p ps=5.68u w=2.5u l=1u
X75 resistor_network_0.resistor_leg_2.p1 AVDD.t25 AVDD.t3 rhigh l=13.42u w=0.5u
X76 a_53290_36464# threshold.t15 comparator_slice_1.comparator_body_0.outx.t50 AVSS.t145 sg13_hv_nmos ad=0.85p pd=5.68u as=0.85p ps=5.68u w=2.5u l=1u
X77 a_50902_46017# comparator_slice_1.comparator_body_0.m3_m4_diff_0.n1.t34 AVDD.t36 AVDD.t4 sg13_hv_pmos ad=0.85p pd=5.68u as=0.85p ps=5.68u w=2.5u l=1u
X78 AVDD.t58 comparator_slice_1.comparator_body_0.m3_m4_diff_0.n1.t6 a_51802_42317# AVDD.t4 sg13_hv_pmos ad=0.85p pd=5.68u as=0.85p ps=5.68u w=2.5u l=1u
X79 comparator_slice_0.comparator_body_0.m3_m4_diff_0.n1.t0 trigger.t26 a_54186_21447# AVSS.t22 sg13_hv_nmos ad=0.85p pd=5.68u as=0.85p ps=5.68u w=2.5u l=1u
X80 a_62320_37326# a_60176_37898# set_b AVSS.t3 sg13_hv_nmos ad=0.85p pd=5.68u as=0.85p ps=5.68u w=2.5u l=1u
X81 a_56766_43629# ibias1.t2 AVSS.t175 AVSS.t165 sg13_hv_nmos ad=0.85p pd=5.68u as=0.85p ps=5.68u w=2.5u l=1u
X82 AVSS.t108 ibias0.t62 a_57666_9078# AVSS.t103 sg13_hv_nmos ad=0.85p pd=5.68u as=0.85p ps=5.68u w=2.5u l=1u
X83 comparator_slice_0.comparator_body_0.outx.t48 vctrl.t38 a_54772_7784# AVSS.t32 sg13_hv_nmos ad=0.85p pd=5.68u as=0.85p ps=5.68u w=2.5u l=1u
X84 a_50902_6454# comparator_slice_0.comparator_body_0.m3_m4_diff_0.n1.t54 AVDD.t86 AVDD.t0 sg13_hv_pmos ad=0.85p pd=5.68u as=0.85p ps=5.68u w=2.5u l=1u
X85 a_56182_33637# ibias1.t12 comparator_slice_1.comparator_body_0.mref_m5_diff_0.tail.t92 AVSS.t55 sg13_hv_nmos ad=0.85p pd=5.68u as=0.85p ps=5.68u w=2.5u l=1u
X86 a_56766_4082# ibias0.t58 AVSS.t121 AVSS.t93 sg13_hv_nmos ad=0.85p pd=5.68u as=0.85p ps=5.68u w=2.5u l=1u
X87 comparator_slice_0.comparator_body_0.outx.t3 comparator_slice_0.comparator_body_0.m3_m4_diff_0.n1.t70 a_51218_5264# AVDD.t0 sg13_hv_pmos ad=0.85p pd=5.68u as=0.85p ps=5.68u w=2.5u l=1u
X88 comparator_slice_0.comparator_body_0.outx.t10 comparator_slice_0.comparator_body_0.m3_m4_diff_0.n1.t92 a_51802_16234# AVDD.t0 sg13_hv_pmos ad=0.85p pd=5.68u as=0.85p ps=5.68u w=2.5u l=1u
X89 a_50902_46017# comparator_slice_1.comparator_body_0.m3_m4_diff_0.n1.t34 comparator_slice_1.comparator_body_0.m3_m4_diff_0.n1.t35 AVDD.t4 sg13_hv_pmos ad=0.85p pd=5.68u as=0.85p ps=5.68u w=2.5u l=1u
X90 comparator_slice_1.comparator_body_0.outx.t28 comparator_slice_1.comparator_body_0.m3_m4_diff_0.n1.t6 a_51802_42317# AVDD.t4 sg13_hv_pmos ad=0.85p pd=5.68u as=0.85p ps=5.68u w=2.5u l=1u
X91 AVSS.t12 AVSS.t13 AVDD.t3 rhigh l=13.42u w=0.5u
X92 a_62320_37326# a_60176_37898# AVSS.t159 AVSS.t3 sg13_hv_nmos ad=0.85p pd=5.68u as=0.85p ps=5.68u w=2.5u l=1u
X93 resistor_network_0.pb resistor_network_0.resistor_leg_1.p2 AVDD.t3 rhigh l=13.42u w=0.5u
X94 a_56766_22640# ibias0.t50 ibias0.t51 AVSS.t57 sg13_hv_nmos ad=0.85p pd=5.68u as=0.85p ps=5.68u w=2.5u l=1u
X95 comparator_slice_0.comparator_body_0.mref_m5_diff_0.tail.t21 trigger.t28 a_54772_22687# AVSS.t24 sg13_hv_nmos ad=0.85p pd=5.68u as=0.85p ps=5.68u w=2.5u l=1u
X96 AVSS.t235 AVSS.t236 AVDD.t3 rhigh l=13.42u w=0.5u
X97 a_56182_12648# ibias0.t44 AVSS.t88 AVSS.t87 sg13_hv_nmos ad=0.85p pd=5.68u as=0.85p ps=5.68u w=2.5u l=1u
X98 a_56766_17644# ibias0.t22 ibias0.t23 AVSS.t57 sg13_hv_nmos ad=0.85p pd=5.68u as=0.85p ps=5.68u w=2.5u l=1u
X99 a_50318_30157# comparator_slice_1.comparator_body_0.m3_m4_diff_0.n1.t38 AVDD.t29 AVDD.t4 sg13_hv_pmos ad=0.85p pd=5.68u as=0.85p ps=5.68u w=2.5u l=1u
X100 a_56182_46009# ibias1.t42 AVSS.t168 AVSS.t163 sg13_hv_nmos ad=0.85p pd=5.68u as=0.85p ps=5.68u w=2.5u l=1u
X101 a_61028_37326# comparator_slice_1.comparator_body_0.outx.t64 a_60176_37898# AVSS.t40 sg13_hv_nmos ad=0.85p pd=5.68u as=0.85p ps=5.68u w=2.5u l=1u
X102 comparator_slice_1.comparator_body_0.mref_m5_diff_0.tail.t69 ibias1.t58 a_57082_33637# AVSS.t53 sg13_hv_nmos ad=0.85p pd=5.68u as=0.85p ps=5.68u w=2.5u l=1u
X103 a_56766_31021# ibias1.t24 AVSS.t221 AVSS.t57 sg13_hv_nmos ad=0.85p pd=5.68u as=0.85p ps=5.68u w=2.5u l=1u
X104 comparator_slice_0.comparator_body_0.mref_m5_diff_0.tail.t54 ibias0.t16 a_57666_11458# AVSS.t103 sg13_hv_nmos ad=0.85p pd=5.68u as=0.85p ps=5.68u w=2.5u l=1u
X105 comparator_slice_0.comparator_body_0.mref_m5_diff_0.tail.t83 vctrl.t32 a_54186_4064# AVSS.t30 sg13_hv_nmos ad=0.85p pd=5.68u as=0.85p ps=5.68u w=2.5u l=1u
X106 comparator_slice_0.comparator_body_0.mref_m5_diff_0.tail.t75 vctrl.t36 a_54186_6544# AVSS.t30 sg13_hv_nmos ad=0.85p pd=5.68u as=0.85p ps=5.68u w=2.5u l=1u
X107 AVDD.t120 comparator_slice_0.comparator_body_0.m3_m4_diff_0.n1.t86 a_51802_12534# AVDD.t0 sg13_hv_pmos ad=0.85p pd=5.68u as=0.85p ps=5.68u w=2.5u l=1u
X108 AVDD.t52 comparator_slice_1.comparator_body_0.m3_m4_diff_0.n1.t60 a_51802_33857# AVDD.t4 sg13_hv_pmos ad=0.85p pd=5.68u as=0.85p ps=5.68u w=2.5u l=1u
X109 AVSS.t170 ibias1.t28 a_57082_46009# AVSS.t166 sg13_hv_nmos ad=0.85p pd=5.68u as=0.85p ps=5.68u w=2.5u l=1u
X110 a_56182_44819# ibias1.t32 AVSS.t172 AVSS.t163 sg13_hv_nmos ad=0.85p pd=5.68u as=0.85p ps=5.68u w=2.5u l=1u
X111 AVSS.t90 ibias0.t32 a_57082_12648# AVSS.t89 sg13_hv_nmos ad=0.85p pd=5.68u as=0.85p ps=5.68u w=2.5u l=1u
X112 AVDD.t62 comparator_slice_1.comparator_body_0.m3_m4_diff_0.n1.t32 a_51802_37427# AVDD.t4 sg13_hv_pmos ad=0.85p pd=5.68u as=0.85p ps=5.68u w=2.5u l=1u
X113 a_61028_37326# comparator_slice_1.comparator_body_0.outx.t64 AVSS.t41 AVSS.t40 sg13_hv_nmos ad=0.85p pd=5.68u as=0.85p ps=5.68u w=2.5u l=1u
X114 a_56766_31021# ibias1.t24 ibias1.t25 AVSS.t57 sg13_hv_nmos ad=0.85p pd=5.68u as=0.85p ps=5.68u w=2.5u l=1u
X115 resistor_network_0.resistor_leg_0.pt vctrl.t8 AVDD.t3 rhigh l=13.42u w=0.5u
X116 ibias0.t49 ibias0.t48 a_57082_6462# AVSS.t102 sg13_hv_nmos ad=0.85p pd=5.68u as=0.85p ps=5.68u w=2.5u l=1u
X117 a_53290_14817# vctrl.t49 comparator_slice_0.comparator_body_0.mref_m5_diff_0.tail.t68 AVSS.t145 sg13_hv_nmos ad=0.85p pd=5.68u as=0.85p ps=5.68u w=2.5u l=1u
X118 AVDD.t25 resistor_network_0.resistor_leg_2.p1 AVDD.t3 rhigh l=13.42u w=0.5u
X119 AVSS.t20 AVSS.t20 AVDD.t3 rhigh l=13.42u w=0.5u
X120 AVSS.t174 ibias1.t52 a_57082_44819# AVSS.t166 sg13_hv_nmos ad=0.85p pd=5.68u as=0.85p ps=5.68u w=2.5u l=1u
X121 comparator_slice_1.comparator_body_0.outx.t62 comparator_slice_1.comparator_body_0.m3_m4_diff_0.n1.t32 a_51802_37427# AVDD.t4 sg13_hv_pmos ad=0.85p pd=5.68u as=0.85p ps=5.68u w=2.5u l=1u
X122 a_50902_33857# comparator_slice_1.comparator_body_0.m3_m4_diff_0.n1.t48 comparator_slice_1.comparator_body_0.m3_m4_diff_0.n1.t49 AVDD.t4 sg13_hv_pmos ad=0.85p pd=5.68u as=0.85p ps=5.68u w=2.5u l=1u
X123 a_53873_36464# resistor_network_0.p1 comparator_slice_1.comparator_body_0.mref_m5_diff_0.tail.t1 AVSS.t23 sg13_hv_nmos ad=0.85p pd=5.68u as=0.85p ps=5.68u w=2.5u l=1u
X124 comparator_slice_1.comparator_body_0.outx.t8 comparator_slice_1.comparator_body_0.m3_m4_diff_0.n1.t18 a_51802_30157# AVDD.t4 sg13_hv_pmos ad=0.85p pd=5.68u as=0.85p ps=5.68u w=2.5u l=1u
X125 a_56182_32211# ibias1.t22 AVSS.t217 AVSS.t55 sg13_hv_nmos ad=0.85p pd=5.68u as=0.85p ps=5.68u w=2.5u l=1u
X126 a_53873_18537# vctrl.t55 comparator_slice_0.comparator_body_0.mref_m5_diff_0.tail.t74 AVSS.t23 sg13_hv_nmos ad=0.85p pd=5.68u as=0.85p ps=5.68u w=2.5u l=1u
X127 a_50318_11344# comparator_slice_0.comparator_body_0.m3_m4_diff_0.n1.t38 AVDD.t16 AVDD.t0 sg13_hv_pmos ad=0.85p pd=5.68u as=0.85p ps=5.68u w=2.5u l=1u
X128 resistor_network_0.resistor_leg_3.p1 resistor_network_0.p1 AVDD.t3 rhigh l=13.42u w=0.5u
X129 comparator_slice_0.comparator_body_0.mref_m5_diff_0.tail.t46 ibias0.t62 a_57666_9078# AVSS.t103 sg13_hv_nmos ad=0.85p pd=5.68u as=0.85p ps=5.68u w=2.5u l=1u
X130 AVSS.t204 ibias1.t34 a_57082_32211# AVSS.t53 sg13_hv_nmos ad=0.85p pd=5.68u as=0.85p ps=5.68u w=2.5u l=1u
X131 a_56766_14074# ibias0.t30 AVSS.t83 AVSS.t57 sg13_hv_nmos ad=0.85p pd=5.68u as=0.85p ps=5.68u w=2.5u l=1u
X132 a_56182_32211# ibias1.t22 ibias1.t23 AVSS.t55 sg13_hv_nmos ad=0.85p pd=5.68u as=0.85p ps=5.68u w=2.5u l=1u
X133 AVDD.t45 comparator_slice_1.comparator_body_0.m3_m4_diff_0.n1.t18 a_51802_28967# AVDD.t4 sg13_hv_pmos ad=0.85p pd=5.68u as=0.85p ps=5.68u w=2.5u l=1u
X134 ibias1.t11 ibias1.t10 a_57666_28641# AVSS.t59 sg13_hv_nmos ad=0.85p pd=5.68u as=0.85p ps=5.68u w=2.5u l=1u
X135 ibias1.t35 ibias1.t34 a_57082_32211# AVSS.t53 sg13_hv_nmos ad=0.85p pd=5.68u as=0.85p ps=5.68u w=2.5u l=1u
X136 a_50318_41127# comparator_slice_1.comparator_body_0.m3_m4_diff_0.n1.t52 AVDD.t5 AVDD.t4 sg13_hv_pmos ad=0.85p pd=5.68u as=0.85p ps=5.68u w=2.5u l=1u
X137 a_50902_28967# comparator_slice_1.comparator_body_0.m3_m4_diff_0.n1.t14 comparator_slice_1.comparator_body_0.m3_m4_diff_0.n1.t15 AVDD.t4 sg13_hv_pmos ad=0.85p pd=5.68u as=0.85p ps=5.68u w=2.5u l=1u
X138 a_53289_28594# threshold.t3 comparator_slice_1.comparator_body_0.outx.t41 AVSS.t21 sg13_hv_nmos ad=0.85p pd=5.68u as=0.85p ps=5.68u w=2.5u l=1u
X139 a_53290_14817# vctrl.t49 comparator_slice_0.comparator_body_0.outx.t25 AVSS.t145 sg13_hv_nmos ad=0.85p pd=5.68u as=0.85p ps=5.68u w=2.5u l=1u
X140 comparator_slice_0.comparator_body_0.outx.t27 vctrl.t56 a_54186_20207# AVSS.t22 sg13_hv_nmos ad=0.85p pd=5.68u as=0.85p ps=5.68u w=2.5u l=1u
X141 resistor_network_0.resistor_leg_1.p2 resistor_network_0.pb AVDD.t3 rhigh l=13.42u w=0.5u
X142 a_56182_20260# ibias0.t26 AVSS.t63 AVSS.t55 sg13_hv_nmos ad=0.85p pd=5.68u as=0.85p ps=5.68u w=2.5u l=1u
X143 a_53873_14817# trigger.t17 comparator_slice_0.comparator_body_0.m3_m4_diff_0.n1.t28 AVSS.t23 sg13_hv_nmos ad=0.85p pd=5.68u as=0.85p ps=5.68u w=2.5u l=1u
X144 a_56182_15264# ibias0.t46 AVSS.t79 AVSS.t55 sg13_hv_nmos ad=0.85p pd=5.68u as=0.85p ps=5.68u w=2.5u l=1u
X145 comparator_slice_0.comparator_body_0.m3_m4_diff_0.n1.t57 comparator_slice_0.comparator_body_0.m3_m4_diff_0.n1.t56 a_51802_19934# AVDD.t0 sg13_hv_pmos ad=0.85p pd=5.68u as=0.85p ps=5.68u w=2.5u l=1u
X146 AVSS.t6 AVSS.t6 AVDD.t3 rhigh l=13.42u w=0.5u
X147 resistor_network_0.resistor_leg_3.p1 resistor_network_0.p1 AVDD.t3 rhigh l=13.42u w=0.5u
X148 AVSS.t16 AVSS.t16 AVDD.t3 rhigh l=13.42u w=0.5u
X149 AVSS.t195 ibias1.t0 a_57666_39823# AVSS.t191 sg13_hv_nmos ad=0.85p pd=5.68u as=0.85p ps=5.68u w=2.5u l=1u
X150 comparator_slice_0.comparator_body_0.m3_m4_diff_0.n1.t33 comparator_slice_0.comparator_body_0.m3_m4_diff_0.n1.t32 a_51218_11344# AVDD.t0 sg13_hv_pmos ad=0.85p pd=5.68u as=0.85p ps=5.68u w=2.5u l=1u
X151 a_50318_15044# comparator_slice_0.comparator_body_0.m3_m4_diff_0.n1.t46 AVDD.t91 AVDD.t0 sg13_hv_pmos ad=0.85p pd=5.68u as=0.85p ps=5.68u w=2.5u l=1u
X152 a_50318_41127# comparator_slice_1.comparator_body_0.m3_m4_diff_0.n1.t52 comparator_slice_1.comparator_body_0.outx.t0 AVDD.t4 sg13_hv_pmos ad=0.85p pd=5.68u as=0.85p ps=5.68u w=2.5u l=1u
X153 comparator_slice_0.comparator_body_0.mref_m5_diff_0.tail.t70 vctrl.t56 a_54186_20207# AVSS.t22 sg13_hv_nmos ad=0.85p pd=5.68u as=0.85p ps=5.68u w=2.5u l=1u
X154 AVSS.t66 ibias0.t2 a_57082_20260# AVSS.t53 sg13_hv_nmos ad=0.85p pd=5.68u as=0.85p ps=5.68u w=2.5u l=1u
X155 AVSS.t81 ibias0.t10 a_57082_15264# AVSS.t53 sg13_hv_nmos ad=0.85p pd=5.68u as=0.85p ps=5.68u w=2.5u l=1u
X156 a_50902_8964# comparator_slice_0.comparator_body_0.m3_m4_diff_0.n1.t88 comparator_slice_0.comparator_body_0.outx.t2 AVDD.t0 sg13_hv_pmos ad=0.85p pd=5.68u as=0.85p ps=5.68u w=2.5u l=1u
X157 resistor_network_0.resistor_leg_0.pt resistor_network_0.p1 AVDD.t3 rhigh l=13.42u w=0.5u
X158 resistor_network_0.p1 resistor_network_0.resistor_leg_1.pt AVDD.t3 rhigh l=13.42u w=0.5u
X159 AVDD.t80 comparator_slice_0.comparator_body_0.m3_m4_diff_0.n1.t34 a_51802_6454# AVDD.t0 sg13_hv_pmos ad=0.85p pd=5.68u as=0.85p ps=5.68u w=2.5u l=1u
X160 AVDD.t119 comparator_slice_0.comparator_body_0.m3_m4_diff_0.n1.t56 a_51802_18744# AVDD.t0 sg13_hv_pmos ad=0.85p pd=5.68u as=0.85p ps=5.68u w=2.5u l=1u
X161 AVDD.t57 comparator_slice_1.comparator_body_0.m3_m4_diff_0.n1.t58 a_51802_44827# AVDD.t4 sg13_hv_pmos ad=0.85p pd=5.68u as=0.85p ps=5.68u w=2.5u l=1u
X162 comparator_slice_1.comparator_body_0.m3_m4_diff_0.n1.t80 resistor_network_0.p1 a_54772_39366# AVSS.t140 sg13_hv_nmos ad=0.85p pd=5.68u as=0.85p ps=5.68u w=2.5u l=1u
X163 comparator_slice_1.comparator_body_0.outx.t29 threshold.t8 a_54772_32744# AVSS.t24 sg13_hv_nmos ad=0.85p pd=5.68u as=0.85p ps=5.68u w=2.5u l=1u
X164 comparator_slice_1.comparator_body_0.outx.t34 threshold.t2 a_54186_28594# AVSS.t22 sg13_hv_nmos ad=0.85p pd=5.68u as=0.85p ps=5.68u w=2.5u l=1u
X165 comparator_slice_0.comparator_body_0.outx.t52 vctrl.t62 a_54772_23927# AVSS.t24 sg13_hv_nmos ad=0.85p pd=5.68u as=0.85p ps=5.68u w=2.5u l=1u
X166 comparator_slice_0.comparator_body_0.outx.t21 vctrl.t58 a_54772_21447# AVSS.t24 sg13_hv_nmos ad=0.85p pd=5.68u as=0.85p ps=5.68u w=2.5u l=1u
X167 a_56766_43629# ibias1.t2 ibias1.t3 AVSS.t165 sg13_hv_nmos ad=0.85p pd=5.68u as=0.85p ps=5.68u w=2.5u l=1u
X168 a_53289_22687# vctrl.t61 comparator_slice_0.comparator_body_0.outx.t51 AVSS.t21 sg13_hv_nmos ad=0.85p pd=5.68u as=0.85p ps=5.68u w=2.5u l=1u
X169 a_56766_38633# ibias1.t8 ibias1.t9 AVSS.t189 sg13_hv_nmos ad=0.85p pd=5.68u as=0.85p ps=5.68u w=2.5u l=1u
X170 AVSS.t241 AVSS.t242 AVDD.t3 rhigh l=13.42u w=0.5u
X171 a_53873_44737# resistor_network_0.p1 comparator_slice_1.comparator_body_0.m3_m4_diff_0.n1.t66 AVSS.t135 sg13_hv_nmos ad=0.85p pd=5.68u as=0.85p ps=5.68u w=2.5u l=1u
X172 a_53290_31074# threshold.t7 comparator_slice_1.comparator_body_0.outx.t46 AVSS.t145 sg13_hv_nmos ad=0.85p pd=5.68u as=0.85p ps=5.68u w=2.5u l=1u
X173 AVSS.t42 AVSS.t43 AVDD.t3 rhigh l=13.42u w=0.5u
X174 a_50902_18744# comparator_slice_0.comparator_body_0.m3_m4_diff_0.n1.t42 comparator_slice_0.comparator_body_0.outx.t58 AVDD.t0 sg13_hv_pmos ad=0.85p pd=5.68u as=0.85p ps=5.68u w=2.5u l=1u
X175 comparator_slice_0.comparator_body_0.m3_m4_diff_0.n1.t59 comparator_slice_0.comparator_body_0.m3_m4_diff_0.n1.t58 a_51802_15044# AVDD.t0 sg13_hv_pmos ad=0.85p pd=5.68u as=0.85p ps=5.68u w=2.5u l=1u
X176 AVSS.t16 AVSS.t16 AVDD.t3 rhigh l=13.42u w=0.5u
X177 a_50318_36237# comparator_slice_1.comparator_body_0.m3_m4_diff_0.n1.t4 comparator_slice_1.comparator_body_0.outx.t63 AVDD.t4 sg13_hv_pmos ad=0.85p pd=5.68u as=0.85p ps=5.68u w=2.5u l=1u
X178 comparator_slice_1.comparator_body_0.m3_m4_diff_0.n1.t55 comparator_slice_1.comparator_body_0.m3_m4_diff_0.n1.t54 a_51218_32537# AVDD.t4 sg13_hv_pmos ad=0.85p pd=5.68u as=0.85p ps=5.68u w=2.5u l=1u
X179 a_53873_10675# vctrl.t43 comparator_slice_0.comparator_body_0.mref_m5_diff_0.tail.t81 AVSS.t31 sg13_hv_nmos ad=0.85p pd=5.68u as=0.85p ps=5.68u w=2.5u l=1u
X180 a_53873_13155# vctrl.t47 comparator_slice_0.comparator_body_0.mref_m5_diff_0.tail.t67 AVSS.t23 sg13_hv_nmos ad=0.85p pd=5.68u as=0.85p ps=5.68u w=2.5u l=1u
X181 a_56766_6462# ibias0.t0 AVSS.t113 AVSS.t93 sg13_hv_nmos ad=0.85p pd=5.68u as=0.85p ps=5.68u w=2.5u l=1u
X182 a_53873_14817# trigger.t17 comparator_slice_0.comparator_body_0.mref_m5_diff_0.tail.t28 AVSS.t23 sg13_hv_nmos ad=0.85p pd=5.68u as=0.85p ps=5.68u w=2.5u l=1u
X183 a_53873_17297# trigger.t21 comparator_slice_0.comparator_body_0.mref_m5_diff_0.tail.t26 AVSS.t23 sg13_hv_nmos ad=0.85p pd=5.68u as=0.85p ps=5.68u w=2.5u l=1u
X184 AVSS.t101 ibias0.t16 a_57666_11458# AVSS.t96 sg13_hv_nmos ad=0.85p pd=5.68u as=0.85p ps=5.68u w=2.5u l=1u
X185 AVDD.t25 resistor_network_0.resistor_leg_2.p1 AVDD.t3 rhigh l=13.42u w=0.5u
X186 comparator_slice_1.comparator_body_0.mref_m5_diff_0.tail.t74 ibias1.t56 a_57666_44819# AVSS.t167 sg13_hv_nmos ad=0.85p pd=5.68u as=0.85p ps=5.68u w=2.5u l=1u
X187 AVDD.t61 comparator_slice_1.comparator_body_0.m3_m4_diff_0.n1.t42 a_51802_39937# AVDD.t4 sg13_hv_pmos ad=0.85p pd=5.68u as=0.85p ps=5.68u w=2.5u l=1u
X188 comparator_slice_0.comparator_body_0.outx.t41 vctrl.t60 a_54186_22687# AVSS.t22 sg13_hv_nmos ad=0.85p pd=5.68u as=0.85p ps=5.68u w=2.5u l=1u
X189 a_62350_12138# a_60176_13955# AVDD1V2 AVDD1V2 sg13_hv_pmos ad=0.85p pd=5.68u as=0.85p ps=5.68u w=2.5u l=1u
X190 a_50318_32537# comparator_slice_1.comparator_body_0.m3_m4_diff_0.n1.t30 AVDD.t17 AVDD.t4 sg13_hv_pmos ad=0.85p pd=5.68u as=0.85p ps=5.68u w=2.5u l=1u
X191 a_56766_29831# ibias1.t46 comparator_slice_1.comparator_body_0.mref_m5_diff_0.tail.t85 AVSS.t57 sg13_hv_nmos ad=0.85p pd=5.68u as=0.85p ps=5.68u w=2.5u l=1u
X192 comparator_slice_0.comparator_body_0.mref_m5_diff_0.tail.t59 ibias0.t20 a_57082_5272# AVSS.t102 sg13_hv_nmos ad=0.85p pd=5.68u as=0.85p ps=5.68u w=2.5u l=1u
X193 AVSS.t178 ibias1.t56 a_57666_43629# AVSS.t167 sg13_hv_nmos ad=0.85p pd=5.68u as=0.85p ps=5.68u w=2.5u l=1u
X194 comparator_slice_1.comparator_body_0.outx.t13 comparator_slice_1.comparator_body_0.m3_m4_diff_0.n1.t58 a_51802_44827# AVDD.t4 sg13_hv_pmos ad=0.85p pd=5.68u as=0.85p ps=5.68u w=2.5u l=1u
X195 resistor_network_0.resistor_leg_2.p1 AVDD.t25 AVDD.t3 rhigh l=13.42u w=0.5u
X196 AVSS.t20 AVSS.t20 AVDD.t3 rhigh l=13.42u w=0.5u
X197 AVSS.t11 AVSS.t11 AVDD.t3 rhigh l=13.42u w=0.5u
X198 vctrl.t23 resistor_network_0.resistor_leg_1.pt AVDD.t3 rhigh l=13.42u w=0.5u
X199 comparator_slice_0.comparator_body_0.mref_m5_diff_0.tail.t95 vctrl.t62 a_54772_23927# AVSS.t24 sg13_hv_nmos ad=0.85p pd=5.68u as=0.85p ps=5.68u w=2.5u l=1u
X200 AVDD.t74 comparator_slice_0.comparator_body_0.m3_m4_diff_0.n1.t82 a_51218_22314# AVDD.t0 sg13_hv_pmos ad=0.85p pd=5.68u as=0.85p ps=5.68u w=2.5u l=1u
X201 resistor_network_0.resistor_leg_3.p1 resistor_network_0.p1 AVDD.t3 rhigh l=13.42u w=0.5u
X202 AVDD.t143 comparator_slice_1.comparator_body_0.m3_m4_diff_0.n1.t32 a_51802_36237# AVDD.t4 sg13_hv_pmos ad=0.85p pd=5.68u as=0.85p ps=5.68u w=2.5u l=1u
X203 a_50902_10154# comparator_slice_0.comparator_body_0.m3_m4_diff_0.n1.t88 AVDD.t11 AVDD.t0 sg13_hv_pmos ad=0.85p pd=5.68u as=0.85p ps=5.68u w=2.5u l=1u
X204 ibias0.t43 ibias0.t42 a_57666_22640# AVSS.t59 sg13_hv_nmos ad=0.85p pd=5.68u as=0.85p ps=5.68u w=2.5u l=1u
X205 a_56766_28641# ibias1.t46 AVSS.t228 AVSS.t57 sg13_hv_nmos ad=0.85p pd=5.68u as=0.85p ps=5.68u w=2.5u l=1u
X206 a_61058_12138# comparator_slice_0.comparator_body_0.outx.t64 AVDD.t37 AVDD.t7 sg13_hv_pmos ad=0.85p pd=5.68u as=0.85p ps=5.68u w=2.5u l=1u
X207 ibias0.t53 ibias0.t52 a_57666_17644# AVSS.t59 sg13_hv_nmos ad=0.85p pd=5.68u as=0.85p ps=5.68u w=2.5u l=1u
X208 comparator_slice_0.comparator_body_0.mref_m5_diff_0.tail.t24 trigger.t6 a_54186_7784# AVSS.t30 sg13_hv_nmos ad=0.85p pd=5.68u as=0.85p ps=5.68u w=2.5u l=1u
X209 AVSS.t223 ibias1.t36 a_57666_31021# AVSS.t59 sg13_hv_nmos ad=0.85p pd=5.68u as=0.85p ps=5.68u w=2.5u l=1u
X210 AVSS.t37 AVSS.t37 AVDD.t3 rhigh l=13.42u w=0.5u
X211 comparator_slice_0.comparator_body_0.outx.t13 comparator_slice_0.comparator_body_0.m3_m4_diff_0.n1.t82 a_51218_22314# AVDD.t0 sg13_hv_pmos ad=0.85p pd=5.68u as=0.85p ps=5.68u w=2.5u l=1u
X212 a_53873_31074# resistor_network_0.p1 comparator_slice_1.comparator_body_0.mref_m5_diff_0.tail.t19 AVSS.t23 sg13_hv_nmos ad=0.85p pd=5.68u as=0.85p ps=5.68u w=2.5u l=1u
X213 comparator_slice_0.comparator_body_0.mref_m5_diff_0.tail.t38 ibias0.t60 a_57666_6462# AVSS.t103 sg13_hv_nmos ad=0.85p pd=5.68u as=0.85p ps=5.68u w=2.5u l=1u
X214 ibias1.t37 ibias1.t36 a_57666_31021# AVSS.t59 sg13_hv_nmos ad=0.85p pd=5.68u as=0.85p ps=5.68u w=2.5u l=1u
X215 a_56766_21450# ibias0.t50 AVSS.t61 AVSS.t57 sg13_hv_nmos ad=0.85p pd=5.68u as=0.85p ps=5.68u w=2.5u l=1u
X216 resistor_network_0.resistor_leg_1.p2 resistor_network_0.pb AVDD.t3 rhigh l=13.42u w=0.5u
X217 a_56766_16454# ibias0.t22 AVSS.t76 AVSS.t57 sg13_hv_nmos ad=0.85p pd=5.68u as=0.85p ps=5.68u w=2.5u l=1u
X218 a_50318_43637# comparator_slice_1.comparator_body_0.m3_m4_diff_0.n1.t28 AVDD.t6 AVDD.t4 sg13_hv_pmos ad=0.85p pd=5.68u as=0.85p ps=5.68u w=2.5u l=1u
X219 AVDD.t42 comparator_slice_0.comparator_body_0.m3_m4_diff_0.n1.t78 a_51218_13854# AVDD.t0 sg13_hv_pmos ad=0.85p pd=5.68u as=0.85p ps=5.68u w=2.5u l=1u
X220 AVDD.t126 comparator_slice_0.comparator_body_0.m3_m4_diff_0.n1.t44 a_51218_17424# AVDD.t0 sg13_hv_pmos ad=0.85p pd=5.68u as=0.85p ps=5.68u w=2.5u l=1u
X221 a_50318_47207# comparator_slice_1.comparator_body_0.m3_m4_diff_0.n1.t36 AVDD.t54 AVDD.t4 sg13_hv_pmos ad=0.85p pd=5.68u as=0.85p ps=5.68u w=2.5u l=1u
X222 a_56182_29831# ibias1.t20 AVSS.t224 AVSS.t55 sg13_hv_nmos ad=0.85p pd=5.68u as=0.85p ps=5.68u w=2.5u l=1u
X223 AVSS.t16 AVSS.t16 AVDD.t3 rhigh l=13.42u w=0.5u
X224 a_50902_31347# comparator_slice_1.comparator_body_0.m3_m4_diff_0.n1.t44 comparator_slice_1.comparator_body_0.m3_m4_diff_0.n1.t45 AVDD.t4 sg13_hv_pmos ad=0.85p pd=5.68u as=0.85p ps=5.68u w=2.5u l=1u
X225 comparator_slice_0.comparator_body_0.outx.t12 comparator_slice_0.comparator_body_0.m3_m4_diff_0.n1.t48 a_51802_8964# AVDD.t0 sg13_hv_pmos ad=0.85p pd=5.68u as=0.85p ps=5.68u w=2.5u l=1u
X226 a_56182_14074# ibias0.t46 ibias0.t47 AVSS.t55 sg13_hv_nmos ad=0.85p pd=5.68u as=0.85p ps=5.68u w=2.5u l=1u
X227 a_62350_12138# a_60176_13955# reset_b AVDD1V2 sg13_hv_pmos ad=0.85p pd=5.68u as=0.85p ps=5.68u w=2.5u l=1u
X228 a_50318_47207# comparator_slice_1.comparator_body_0.m3_m4_diff_0.n1.t36 comparator_slice_1.comparator_body_0.m3_m4_diff_0.n1.t37 AVDD.t4 sg13_hv_pmos ad=0.85p pd=5.68u as=0.85p ps=5.68u w=2.5u l=1u
X229 AVSS.t227 ibias1.t54 a_57082_29831# AVSS.t53 sg13_hv_nmos ad=0.85p pd=5.68u as=0.85p ps=5.68u w=2.5u l=1u
X230 comparator_slice_0.comparator_body_0.outx.t59 comparator_slice_0.comparator_body_0.m3_m4_diff_0.n1.t44 a_51218_17424# AVDD.t0 sg13_hv_pmos ad=0.85p pd=5.68u as=0.85p ps=5.68u w=2.5u l=1u
X231 resistor_network_0.resistor_leg_0.pt resistor_network_0.p1 AVDD.t3 rhigh l=13.42u w=0.5u
X232 vctrl.t1 resistor_network_0.resistor_leg_0.pt AVDD.t3 rhigh l=13.42u w=0.5u
X233 a_56766_9078# ibias0.t6 AVSS.t94 AVSS.t93 sg13_hv_nmos ad=0.85p pd=5.68u as=0.85p ps=5.68u w=2.5u l=1u
X234 a_53290_4064# vctrl.t33 comparator_slice_0.comparator_body_0.outx.t43 AVSS.t146 sg13_hv_nmos ad=0.85p pd=5.68u as=0.85p ps=5.68u w=2.5u l=1u
X235 comparator_slice_0.comparator_body_0.outx.t0 comparator_slice_0.comparator_body_0.m3_m4_diff_0.n1.t36 a_51218_10154# AVDD.t0 sg13_hv_pmos ad=0.85p pd=5.68u as=0.85p ps=5.68u w=2.5u l=1u
X236 a_50318_13854# comparator_slice_0.comparator_body_0.m3_m4_diff_0.n1.t46 comparator_slice_0.comparator_body_0.m3_m4_diff_0.n1.t47 AVDD.t0 sg13_hv_pmos ad=0.85p pd=5.68u as=0.85p ps=5.68u w=2.5u l=1u
X237 a_50318_39937# comparator_slice_1.comparator_body_0.m3_m4_diff_0.n1.t46 comparator_slice_1.comparator_body_0.m3_m4_diff_0.n1.t47 AVDD.t4 sg13_hv_pmos ad=0.85p pd=5.68u as=0.85p ps=5.68u w=2.5u l=1u
X238 AVSS.t127 AVSS.t128 AVDD.t3 rhigh l=13.42u w=0.5u
X239 AVSS.t85 ibias0.t12 a_57666_14074# AVSS.t59 sg13_hv_nmos ad=0.85p pd=5.68u as=0.85p ps=5.68u w=2.5u l=1u
X240 AVDD.t25 resistor_network_0.resistor_leg_2.p1 AVDD.t3 rhigh l=13.42u w=0.5u
X241 a_53289_39366# threshold.t19 comparator_slice_1.comparator_body_0.mref_m5_diff_0.tail.t34 AVSS.t157 sg13_hv_nmos ad=0.85p pd=5.68u as=0.85p ps=5.68u w=2.5u l=1u
X242 a_53289_32744# resistor_network_0.p1 comparator_slice_1.comparator_body_0.mref_m5_diff_0.tail.t31 AVSS.t21 sg13_hv_nmos ad=0.85p pd=5.68u as=0.85p ps=5.68u w=2.5u l=1u
X243 a_50318_5264# comparator_slice_0.comparator_body_0.m3_m4_diff_0.n1.t90 AVDD.t147 AVDD.t0 sg13_hv_pmos ad=0.85p pd=5.68u as=0.85p ps=5.68u w=2.5u l=1u
X244 a_53289_23927# trigger.t31 comparator_slice_0.comparator_body_0.mref_m5_diff_0.tail.t30 AVSS.t21 sg13_hv_nmos ad=0.85p pd=5.68u as=0.85p ps=5.68u w=2.5u l=1u
X245 ibias0.t11 ibias0.t10 a_57082_14074# AVSS.t53 sg13_hv_nmos ad=0.85p pd=5.68u as=0.85p ps=5.68u w=2.5u l=1u
X246 a_56182_22640# ibias0.t34 AVSS.t56 AVSS.t55 sg13_hv_nmos ad=0.85p pd=5.68u as=0.85p ps=5.68u w=2.5u l=1u
X247 a_56182_17644# ibias0.t40 AVSS.t71 AVSS.t55 sg13_hv_nmos ad=0.85p pd=5.68u as=0.85p ps=5.68u w=2.5u l=1u
X248 a_53289_21447# trigger.t27 comparator_slice_0.comparator_body_0.mref_m5_diff_0.tail.t8 AVSS.t21 sg13_hv_nmos ad=0.85p pd=5.68u as=0.85p ps=5.68u w=2.5u l=1u
X249 a_56766_41013# ibias1.t60 AVSS.t185 AVSS.t165 sg13_hv_nmos ad=0.85p pd=5.68u as=0.85p ps=5.68u w=2.5u l=1u
X250 AVSS.t0 AVSS.t0 AVDD.t3 rhigh l=13.42u w=0.5u
X251 a_61058_12138# comparator_slice_0.comparator_body_0.outx.t64 a_60176_13955# AVDD.t7 sg13_hv_pmos ad=0.85p pd=5.68u as=0.85p ps=5.68u w=2.5u l=1u
X252 AVSS.t6 AVSS.t6 AVDD.t3 rhigh l=13.42u w=0.5u
X253 a_56766_36017# ibias1.t16 AVSS.t208 AVSS.t57 sg13_hv_nmos ad=0.85p pd=5.68u as=0.85p ps=5.68u w=2.5u l=1u
X254 a_50902_21124# comparator_slice_0.comparator_body_0.m3_m4_diff_0.n1.t68 AVDD.t28 AVDD.t0 sg13_hv_pmos ad=0.85p pd=5.68u as=0.85p ps=5.68u w=2.5u l=1u
X255 a_50318_38747# comparator_slice_1.comparator_body_0.m3_m4_diff_0.n1.t46 AVDD.t73 AVDD.t4 sg13_hv_pmos ad=0.85p pd=5.68u as=0.85p ps=5.68u w=2.5u l=1u
X256 a_53873_27354# threshold.t1 comparator_slice_1.comparator_body_0.outx.t36 AVSS.t23 sg13_hv_nmos ad=0.85p pd=5.68u as=0.85p ps=5.68u w=2.5u l=1u
X257 AVSS.t56 ibias0.t18 a_57082_22640# AVSS.t53 sg13_hv_nmos ad=0.85p pd=5.68u as=0.85p ps=5.68u w=2.5u l=1u
X258 AVSS.t73 ibias0.t4 a_57082_17644# AVSS.t53 sg13_hv_nmos ad=0.85p pd=5.68u as=0.85p ps=5.68u w=2.5u l=1u
X259 a_53873_11915# trigger.t13 comparator_slice_0.comparator_body_0.m3_m4_diff_0.n1.t2 AVSS.t27 sg13_hv_nmos ad=0.85p pd=5.68u as=0.85p ps=5.68u w=2.5u l=1u
X260 a_56766_41013# ibias1.t60 ibias1.t61 AVSS.t165 sg13_hv_nmos ad=0.85p pd=5.68u as=0.85p ps=5.68u w=2.5u l=1u
X261 AVSS.t16 AVSS.t16 AVDD.t3 rhigh l=13.42u w=0.5u
X262 comparator_slice_1.comparator_body_0.mref_m5_diff_0.tail.t7 resistor_network_0.p1 a_54186_32744# AVSS.t22 sg13_hv_nmos ad=0.85p pd=5.68u as=0.85p ps=5.68u w=2.5u l=1u
X263 comparator_slice_1.comparator_body_0.outx.t49 threshold.t4 a_54772_29834# AVSS.t24 sg13_hv_nmos ad=0.85p pd=5.68u as=0.85p ps=5.68u w=2.5u l=1u
X264 a_56766_36017# ibias1.t16 ibias1.t17 AVSS.t57 sg13_hv_nmos ad=0.85p pd=5.68u as=0.85p ps=5.68u w=2.5u l=1u
X265 a_50902_21124# comparator_slice_0.comparator_body_0.m3_m4_diff_0.n1.t68 comparator_slice_0.comparator_body_0.outx.t5 AVDD.t0 sg13_hv_pmos ad=0.85p pd=5.68u as=0.85p ps=5.68u w=2.5u l=1u
X266 comparator_slice_1.comparator_body_0.mref_m5_diff_0.tail.t42 threshold.t18 a_54186_39366# AVSS.t158 sg13_hv_nmos ad=0.85p pd=5.68u as=0.85p ps=5.68u w=2.5u l=1u
X267 comparator_slice_0.comparator_body_0.mref_m5_diff_0.tail.t17 trigger.t30 a_54186_23927# AVSS.t22 sg13_hv_nmos ad=0.85p pd=5.68u as=0.85p ps=5.68u w=2.5u l=1u
X268 comparator_slice_0.comparator_body_0.mref_m5_diff_0.tail.t0 trigger.t26 a_54186_21447# AVSS.t22 sg13_hv_nmos ad=0.85p pd=5.68u as=0.85p ps=5.68u w=2.5u l=1u
X269 a_50318_35047# comparator_slice_1.comparator_body_0.m3_m4_diff_0.n1.t22 comparator_slice_1.comparator_body_0.m3_m4_diff_0.n1.t23 AVDD.t4 sg13_hv_pmos ad=0.85p pd=5.68u as=0.85p ps=5.68u w=2.5u l=1u
X270 vctrl.t29 resistor_network_0.resistor_leg_0.pt AVDD.t3 rhigh l=13.42u w=0.5u
X271 AVSS.t49 AVSS.t50 AVDD.t3 rhigh l=13.42u w=0.5u
X272 AVDD.t97 comparator_slice_1.comparator_body_0.m3_m4_diff_0.n1.t54 a_51218_31347# AVDD.t4 sg13_hv_pmos ad=0.85p pd=5.68u as=0.85p ps=5.68u w=2.5u l=1u
X273 a_56182_5272# ibias0.t38 AVSS.t118 AVSS.t91 sg13_hv_nmos ad=0.85p pd=5.68u as=0.85p ps=5.68u w=2.5u l=1u
X274 AVSS.t234 AVSS.t15 AVDD.t3 rhigh l=13.42u w=0.5u
X275 a_56182_42203# ibias1.t40 AVSS.t181 AVSS.t163 sg13_hv_nmos ad=0.85p pd=5.68u as=0.85p ps=5.68u w=2.5u l=1u
X276 a_50902_6454# comparator_slice_0.comparator_body_0.m3_m4_diff_0.n1.t54 comparator_slice_0.comparator_body_0.outx.t18 AVDD.t0 sg13_hv_pmos ad=0.85p pd=5.68u as=0.85p ps=5.68u w=2.5u l=1u
X277 a_56182_37207# ibias1.t48 AVSS.t200 AVSS.t55 sg13_hv_nmos ad=0.85p pd=5.68u as=0.85p ps=5.68u w=2.5u l=1u
X278 a_56182_33637# ibias1.t12 AVSS.t215 AVSS.t55 sg13_hv_nmos ad=0.85p pd=5.68u as=0.85p ps=5.68u w=2.5u l=1u
X279 resistor_network_0.resistor_leg_0.pt vctrl.t2 AVDD.t3 rhigh l=13.42u w=0.5u
X280 a_53290_41846# threshold.t23 comparator_slice_1.comparator_body_0.mref_m5_diff_0.tail.t33 AVSS.t156 sg13_hv_nmos ad=0.85p pd=5.68u as=0.85p ps=5.68u w=2.5u l=1u
X281 comparator_slice_1.comparator_body_0.outx.t45 threshold.t16 a_54772_38126# AVSS.t24 sg13_hv_nmos ad=0.85p pd=5.68u as=0.85p ps=5.68u w=2.5u l=1u
X282 comparator_slice_1.comparator_body_0.m3_m4_diff_0.n1.t94 resistor_network_0.p1 a_54772_33984# AVSS.t24 sg13_hv_nmos ad=0.85p pd=5.68u as=0.85p ps=5.68u w=2.5u l=1u
X283 resistor_network_0.resistor_leg_3.p1 AVDD.t25 AVDD.t3 rhigh l=13.42u w=0.5u
X284 comparator_slice_0.comparator_body_0.m3_m4_diff_0.n1.t21 trigger.t28 a_54772_22687# AVSS.t24 sg13_hv_nmos ad=0.85p pd=5.68u as=0.85p ps=5.68u w=2.5u l=1u
X285 resistor_network_0.p1 resistor_network_0.resistor_leg_2.p1 AVDD.t3 rhigh l=13.42u w=0.5u
X286 a_50902_42317# comparator_slice_1.comparator_body_0.m3_m4_diff_0.n1.t12 AVDD.t95 AVDD.t4 sg13_hv_pmos ad=0.85p pd=5.68u as=0.85p ps=5.68u w=2.5u l=1u
X287 AVSS.t183 ibias1.t62 a_57082_42203# AVSS.t166 sg13_hv_nmos ad=0.85p pd=5.68u as=0.85p ps=5.68u w=2.5u l=1u
X288 a_56182_42203# ibias1.t40 ibias1.t41 AVSS.t163 sg13_hv_nmos ad=0.85p pd=5.68u as=0.85p ps=5.68u w=2.5u l=1u
X289 AVSS.t205 ibias1.t58 a_57082_33637# AVSS.t53 sg13_hv_nmos ad=0.85p pd=5.68u as=0.85p ps=5.68u w=2.5u l=1u
X290 a_53289_23927# trigger.t31 comparator_slice_0.comparator_body_0.m3_m4_diff_0.n1.t30 AVSS.t21 sg13_hv_nmos ad=0.85p pd=5.68u as=0.85p ps=5.68u w=2.5u l=1u
X291 a_56766_9078# ibias0.t6 comparator_slice_0.comparator_body_0.mref_m5_diff_0.tail.t48 AVSS.t93 sg13_hv_nmos ad=0.85p pd=5.68u as=0.85p ps=5.68u w=2.5u l=1u
X292 AVSS.t202 ibias1.t44 a_57082_37207# AVSS.t53 sg13_hv_nmos ad=0.85p pd=5.68u as=0.85p ps=5.68u w=2.5u l=1u
X293 a_56182_37207# ibias1.t48 ibias1.t49 AVSS.t55 sg13_hv_nmos ad=0.85p pd=5.68u as=0.85p ps=5.68u w=2.5u l=1u
X294 a_53289_6544# vctrl.t37 comparator_slice_0.comparator_body_0.outx.t47 AVSS.t29 sg13_hv_nmos ad=0.85p pd=5.68u as=0.85p ps=5.68u w=2.5u l=1u
X295 a_53873_45977# threshold.t29 comparator_slice_1.comparator_body_0.outx.t60 AVSS.t135 sg13_hv_nmos ad=0.85p pd=5.68u as=0.85p ps=5.68u w=2.5u l=1u
X296 a_53873_43497# threshold.t25 comparator_slice_1.comparator_body_0.outx.t33 AVSS.t135 sg13_hv_nmos ad=0.85p pd=5.68u as=0.85p ps=5.68u w=2.5u l=1u
X297 ibias1.t57 ibias1.t56 a_57666_43629# AVSS.t167 sg13_hv_nmos ad=0.85p pd=5.68u as=0.85p ps=5.68u w=2.5u l=1u
X298 AVSS.t15 AVSS.t15 AVDD.t3 rhigh l=13.42u w=0.5u
X299 comparator_slice_1.comparator_body_0.mref_m5_diff_0.tail.t48 threshold.t16 a_54772_38126# AVSS.t24 sg13_hv_nmos ad=0.85p pd=5.68u as=0.85p ps=5.68u w=2.5u l=1u
X300 ibias1.t1 ibias1.t0 a_57666_38633# AVSS.t191 sg13_hv_nmos ad=0.85p pd=5.68u as=0.85p ps=5.68u w=2.5u l=1u
X301 a_62350_39143# a_60176_37898# set_b AVDD1V2 sg13_hv_pmos ad=0.85p pd=5.68u as=0.85p ps=5.68u w=2.5u l=1u
X302 comparator_slice_0.comparator_body_0.m3_m4_diff_0.n1.t87 comparator_slice_0.comparator_body_0.m3_m4_diff_0.n1.t86 a_51802_12534# AVDD.t0 sg13_hv_pmos ad=0.85p pd=5.68u as=0.85p ps=5.68u w=2.5u l=1u
X303 a_50902_16234# comparator_slice_0.comparator_body_0.m3_m4_diff_0.n1.t40 comparator_slice_0.comparator_body_0.outx.t1 AVDD.t0 sg13_hv_pmos ad=0.85p pd=5.68u as=0.85p ps=5.68u w=2.5u l=1u
X304 a_50902_42317# comparator_slice_1.comparator_body_0.m3_m4_diff_0.n1.t12 comparator_slice_1.comparator_body_0.outx.t21 AVDD.t4 sg13_hv_pmos ad=0.85p pd=5.68u as=0.85p ps=5.68u w=2.5u l=1u
X305 ibias1.t63 ibias1.t62 a_57082_42203# AVSS.t166 sg13_hv_nmos ad=0.85p pd=5.68u as=0.85p ps=5.68u w=2.5u l=1u
X306 AVSS.t37 AVSS.t37 AVDD.t3 rhigh l=13.42u w=0.5u
X307 ibias1.t45 ibias1.t44 a_57082_37207# AVSS.t53 sg13_hv_nmos ad=0.85p pd=5.68u as=0.85p ps=5.68u w=2.5u l=1u
X308 a_62904_13955# a_60176_13955# AVSS.t4 AVSS.t5 sg13_hv_nmos ad=0.85p pd=5.68u as=0.85p ps=5.68u w=2.5u l=1u
X309 a_53873_11915# trigger.t13 comparator_slice_0.comparator_body_0.mref_m5_diff_0.tail.t2 AVSS.t27 sg13_hv_nmos ad=0.85p pd=5.68u as=0.85p ps=5.68u w=2.5u l=1u
X310 resistor_network_0.resistor_leg_2.p1 resistor_network_0.p1 AVDD.t3 rhigh l=13.42u w=0.5u
X311 AVSS.t14 AVSS.t14 AVDD.t3 rhigh l=13.42u w=0.5u
X312 comparator_slice_1.comparator_body_0.m3_m4_diff_0.n1.t59 comparator_slice_1.comparator_body_0.m3_m4_diff_0.n1.t58 a_51802_43637# AVDD.t4 sg13_hv_pmos ad=0.85p pd=5.68u as=0.85p ps=5.68u w=2.5u l=1u
X313 AVDD.t47 comparator_slice_1.comparator_body_0.m3_m4_diff_0.n1.t20 a_51218_35047# AVDD.t4 sg13_hv_pmos ad=0.85p pd=5.68u as=0.85p ps=5.68u w=2.5u l=1u
X314 a_61058_39143# comparator_slice_1.comparator_body_0.outx.t66 a_60176_37898# AVDD.t76 sg13_hv_pmos ad=0.85p pd=5.68u as=0.85p ps=5.68u w=2.5u l=1u
X315 resistor_network_0.resistor_leg_0.pt vctrl.t30 AVDD.t3 rhigh l=13.42u w=0.5u
X316 comparator_slice_0.comparator_body_0.m3_m4_diff_0.n1.t17 trigger.t30 a_54186_23927# AVSS.t22 sg13_hv_nmos ad=0.85p pd=5.68u as=0.85p ps=5.68u w=2.5u l=1u
X317 a_56766_10268# ibias0.t6 AVSS.t104 AVSS.t93 sg13_hv_nmos ad=0.85p pd=5.68u as=0.85p ps=5.68u w=2.5u l=1u
X318 ibias0.t9 ibias0.t8 a_57666_5272# AVSS.t103 sg13_hv_nmos ad=0.85p pd=5.68u as=0.85p ps=5.68u w=2.5u l=1u
X319 a_50902_12534# comparator_slice_0.comparator_body_0.m3_m4_diff_0.n1.t64 AVDD.t110 AVDD.t0 sg13_hv_pmos ad=0.85p pd=5.68u as=0.85p ps=5.68u w=2.5u l=1u
X320 resistor_network_0.resistor_leg_3.p1 AVDD.t25 AVDD.t3 rhigh l=13.42u w=0.5u
X321 a_50902_37427# comparator_slice_1.comparator_body_0.m3_m4_diff_0.n1.t24 AVDD.t22 AVDD.t4 sg13_hv_pmos ad=0.85p pd=5.68u as=0.85p ps=5.68u w=2.5u l=1u
X322 a_50902_33857# comparator_slice_1.comparator_body_0.m3_m4_diff_0.n1.t48 AVDD.t113 AVDD.t4 sg13_hv_pmos ad=0.85p pd=5.68u as=0.85p ps=5.68u w=2.5u l=1u
X323 a_53873_16057# vctrl.t51 comparator_slice_0.comparator_body_0.outx.t33 AVSS.t23 sg13_hv_nmos ad=0.85p pd=5.68u as=0.85p ps=5.68u w=2.5u l=1u
X324 a_53873_18537# vctrl.t55 comparator_slice_0.comparator_body_0.outx.t31 AVSS.t23 sg13_hv_nmos ad=0.85p pd=5.68u as=0.85p ps=5.68u w=2.5u l=1u
X325 AVSS.t161 AVSS.t162 AVDD.t3 rhigh l=13.42u w=0.5u
X326 a_60474_39143# comparator_slice_1.comparator_body_0.outx.t67 AVDD.t76 AVDD.t76 sg13_hv_pmos ad=0.85p pd=5.68u as=0.85p ps=5.68u w=2.5u l=1u
X327 comparator_slice_1.comparator_body_0.mref_m5_diff_0.tail.t78 ibias1.t10 a_57666_29831# AVSS.t59 sg13_hv_nmos ad=0.85p pd=5.68u as=0.85p ps=5.68u w=2.5u l=1u
X328 AVDD.t77 comparator_slice_0.comparator_body_0.m3_m4_diff_0.n1.t84 a_51218_19934# AVDD.t0 sg13_hv_pmos ad=0.85p pd=5.68u as=0.85p ps=5.68u w=2.5u l=1u
X329 a_53873_41846# resistor_network_0.p1 comparator_slice_1.comparator_body_0.m3_m4_diff_0.n1.t82 AVSS.t135 sg13_hv_nmos ad=0.85p pd=5.68u as=0.85p ps=5.68u w=2.5u l=1u
X330 a_50902_37427# comparator_slice_1.comparator_body_0.m3_m4_diff_0.n1.t24 comparator_slice_1.comparator_body_0.outx.t22 AVDD.t4 sg13_hv_pmos ad=0.85p pd=5.68u as=0.85p ps=5.68u w=2.5u l=1u
X331 a_56766_47199# ibias1.t26 comparator_slice_1.comparator_body_0.mref_m5_diff_0.tail.t86 AVSS.t165 sg13_hv_nmos ad=0.85p pd=5.68u as=0.85p ps=5.68u w=2.5u l=1u
X332 a_50902_30157# comparator_slice_1.comparator_body_0.m3_m4_diff_0.n1.t14 comparator_slice_1.comparator_body_0.outx.t24 AVDD.t4 sg13_hv_pmos ad=0.85p pd=5.68u as=0.85p ps=5.68u w=2.5u l=1u
X333 AVSS.t20 AVSS.t237 AVDD.t3 rhigh l=13.42u w=0.5u
X334 AVDD.t13 comparator_slice_0.comparator_body_0.m3_m4_diff_0.n1.t70 a_51218_5264# AVDD.t0 sg13_hv_pmos ad=0.85p pd=5.68u as=0.85p ps=5.68u w=2.5u l=1u
X335 AVDD.t25 resistor_network_0.resistor_leg_2.p1 AVDD.t3 rhigh l=13.42u w=0.5u
X336 comparator_slice_1.comparator_body_0.m3_m4_diff_0.n1.t74 resistor_network_0.p1 a_54772_36464# AVSS.t24 sg13_hv_nmos ad=0.85p pd=5.68u as=0.85p ps=5.68u w=2.5u l=1u
X337 AVSS.t228 ibias1.t10 a_57666_28641# AVSS.t59 sg13_hv_nmos ad=0.85p pd=5.68u as=0.85p ps=5.68u w=2.5u l=1u
X338 comparator_slice_1.comparator_body_0.m3_m4_diff_0.n1.t43 comparator_slice_1.comparator_body_0.m3_m4_diff_0.n1.t42 a_51802_38747# AVDD.t4 sg13_hv_pmos ad=0.85p pd=5.68u as=0.85p ps=5.68u w=2.5u l=1u
X339 a_56766_19070# ibias0.t54 comparator_slice_0.comparator_body_0.mref_m5_diff_0.tail.t58 AVSS.t57 sg13_hv_nmos ad=0.85p pd=5.68u as=0.85p ps=5.68u w=2.5u l=1u
X340 a_56182_11458# ibias0.t44 ibias0.t45 AVSS.t91 sg13_hv_nmos ad=0.85p pd=5.68u as=0.85p ps=5.68u w=2.5u l=1u
X341 AVDD.t127 comparator_slice_0.comparator_body_0.m3_m4_diff_0.n1.t44 a_51218_16234# AVDD.t0 sg13_hv_pmos ad=0.85p pd=5.68u as=0.85p ps=5.68u w=2.5u l=1u
X342 AVSS.t6 AVSS.t6 AVDD.t3 rhigh l=13.42u w=0.5u
X343 a_50902_28967# comparator_slice_1.comparator_body_0.m3_m4_diff_0.n1.t14 AVDD.t107 AVDD.t4 sg13_hv_pmos ad=0.85p pd=5.68u as=0.85p ps=5.68u w=2.5u l=1u
X344 AVSS.t0 AVSS.t0 AVDD.t3 rhigh l=13.42u w=0.5u
X345 a_50318_4074# comparator_slice_0.comparator_body_0.m3_m4_diff_0.n1.t90 comparator_slice_0.comparator_body_0.m3_m4_diff_0.n1.t91 AVDD.t0 sg13_hv_pmos ad=0.85p pd=5.68u as=0.85p ps=5.68u w=2.5u l=1u
X346 a_60444_37326# comparator_slice_1.comparator_body_0.outx.t65 a_60176_37898# AVSS.t131 sg13_hv_nmos ad=0.85p pd=5.68u as=0.85p ps=5.68u w=2.5u l=1u
X347 a_53290_9435# vctrl.t41 comparator_slice_0.comparator_body_0.mref_m5_diff_0.tail.t82 AVSS.t146 sg13_hv_nmos ad=0.85p pd=5.68u as=0.85p ps=5.68u w=2.5u l=1u
X348 ibias0.t33 ibias0.t32 a_57082_11458# AVSS.t102 sg13_hv_nmos ad=0.85p pd=5.68u as=0.85p ps=5.68u w=2.5u l=1u
X349 AVSS.t125 AVSS.t126 AVDD.t3 rhigh l=13.42u w=0.5u
X350 AVSS.t62 ibias0.t42 a_57666_21450# AVSS.t59 sg13_hv_nmos ad=0.85p pd=5.68u as=0.85p ps=5.68u w=2.5u l=1u
X351 AVSS.t16 AVSS.t16 AVDD.t3 rhigh l=13.42u w=0.5u
X352 AVSS.t20 AVSS.t20 AVDD.t3 rhigh l=13.42u w=0.5u
X353 AVSS.t77 ibias0.t52 a_57666_16454# AVSS.t59 sg13_hv_nmos ad=0.85p pd=5.68u as=0.85p ps=5.68u w=2.5u l=1u
X354 a_53289_29834# resistor_network_0.p1 comparator_slice_1.comparator_body_0.mref_m5_diff_0.tail.t15 AVSS.t21 sg13_hv_nmos ad=0.85p pd=5.68u as=0.85p ps=5.68u w=2.5u l=1u
X355 a_50318_7644# comparator_slice_0.comparator_body_0.m3_m4_diff_0.n1.t94 AVDD.t83 AVDD.t0 sg13_hv_pmos ad=0.85p pd=5.68u as=0.85p ps=5.68u w=2.5u l=1u
X356 a_60444_37326# comparator_slice_1.comparator_body_0.outx.t65 AVSS.t41 AVSS.t131 sg13_hv_nmos ad=0.85p pd=5.68u as=0.85p ps=5.68u w=2.5u l=1u
X357 AVSS.t11 AVSS.t11 AVDD.t3 rhigh l=13.42u w=0.5u
X358 a_50902_8964# comparator_slice_0.comparator_body_0.m3_m4_diff_0.n1.t88 AVDD.t12 AVDD.t0 sg13_hv_pmos ad=0.85p pd=5.68u as=0.85p ps=5.68u w=2.5u l=1u
X359 a_56766_10268# ibias0.t6 ibias0.t7 AVSS.t93 sg13_hv_nmos ad=0.85p pd=5.68u as=0.85p ps=5.68u w=2.5u l=1u
X360 AVDD.t50 comparator_slice_1.comparator_body_0.m3_m4_diff_0.n1.t2 a_51218_46017# AVDD.t4 sg13_hv_pmos ad=0.85p pd=5.68u as=0.85p ps=5.68u w=2.5u l=1u
X361 resistor_network_0.pb resistor_network_0.resistor_leg_0.p2 AVDD.t3 rhigh l=13.42u w=0.5u
X362 a_53289_5304# trigger.t3 comparator_slice_0.comparator_body_0.m3_m4_diff_0.n1.t3 AVSS.t29 sg13_hv_nmos ad=0.85p pd=5.68u as=0.85p ps=5.68u w=2.5u l=1u
X363 comparator_slice_0.comparator_body_0.outx.t15 comparator_slice_0.comparator_body_0.m3_m4_diff_0.n1.t34 a_51802_6454# AVDD.t0 sg13_hv_pmos ad=0.85p pd=5.68u as=0.85p ps=5.68u w=2.5u l=1u
X364 a_50902_19934# comparator_slice_0.comparator_body_0.m3_m4_diff_0.n1.t42 comparator_slice_0.comparator_body_0.m3_m4_diff_0.n1.t43 AVDD.t0 sg13_hv_pmos ad=0.85p pd=5.68u as=0.85p ps=5.68u w=2.5u l=1u
X365 AVDD.t46 comparator_slice_1.comparator_body_0.m3_m4_diff_0.n1.t18 a_51802_30157# AVDD.t4 sg13_hv_pmos ad=0.85p pd=5.68u as=0.85p ps=5.68u w=2.5u l=1u
X366 comparator_slice_1.comparator_body_0.mref_m5_diff_0.tail.t32 threshold.t8 a_54772_32744# AVSS.t24 sg13_hv_nmos ad=0.85p pd=5.68u as=0.85p ps=5.68u w=2.5u l=1u
X367 AVSS.t143 AVSS.t144 AVDD.t3 rhigh l=13.42u w=0.5u
X368 a_53289_33984# threshold.t11 comparator_slice_1.comparator_body_0.mref_m5_diff_0.tail.t40 AVSS.t21 sg13_hv_nmos ad=0.85p pd=5.68u as=0.85p ps=5.68u w=2.5u l=1u
X369 a_50318_11344# comparator_slice_0.comparator_body_0.m3_m4_diff_0.n1.t38 comparator_slice_0.comparator_body_0.m3_m4_diff_0.n1.t39 AVDD.t0 sg13_hv_pmos ad=0.85p pd=5.68u as=0.85p ps=5.68u w=2.5u l=1u
X370 AVSS.t129 AVSS.t130 AVDD.t3 rhigh l=13.42u w=0.5u
X371 a_53289_38126# resistor_network_0.p1 comparator_slice_1.comparator_body_0.mref_m5_diff_0.tail.t25 AVSS.t21 sg13_hv_nmos ad=0.85p pd=5.68u as=0.85p ps=5.68u w=2.5u l=1u
X372 a_56182_4082# ibias0.t38 ibias0.t39 AVSS.t91 sg13_hv_nmos ad=0.85p pd=5.68u as=0.85p ps=5.68u w=2.5u l=1u
X373 resistor_network_0.p1 resistor_network_0.resistor_leg_2.p1 AVDD.t3 rhigh l=13.42u w=0.5u
X374 a_53290_47217# threshold.t31 comparator_slice_1.comparator_body_0.mref_m5_diff_0.tail.t57 AVSS.t156 sg13_hv_nmos ad=0.85p pd=5.68u as=0.85p ps=5.68u w=2.5u l=1u
X375 AVSS.t0 AVSS.t0 AVDD.t3 rhigh l=13.42u w=0.5u
X376 a_53289_5304# trigger.t3 comparator_slice_0.comparator_body_0.mref_m5_diff_0.tail.t3 AVSS.t29 sg13_hv_nmos ad=0.85p pd=5.68u as=0.85p ps=5.68u w=2.5u l=1u
X377 a_53289_22687# vctrl.t61 comparator_slice_0.comparator_body_0.mref_m5_diff_0.tail.t94 AVSS.t21 sg13_hv_nmos ad=0.85p pd=5.68u as=0.85p ps=5.68u w=2.5u l=1u
X378 a_50902_5264# comparator_slice_0.comparator_body_0.m3_m4_diff_0.n1.t76 comparator_slice_0.comparator_body_0.m3_m4_diff_0.n1.t77 AVDD.t0 sg13_hv_pmos ad=0.85p pd=5.68u as=0.85p ps=5.68u w=2.5u l=1u
X379 comparator_slice_1.comparator_body_0.outx.t10 comparator_slice_1.comparator_body_0.m3_m4_diff_0.n1.t2 a_51218_46017# AVDD.t4 sg13_hv_pmos ad=0.85p pd=5.68u as=0.85p ps=5.68u w=2.5u l=1u
X380 comparator_slice_1.comparator_body_0.mref_m5_diff_0.tail.t20 resistor_network_0.p1 a_54186_29834# AVSS.t22 sg13_hv_nmos ad=0.85p pd=5.68u as=0.85p ps=5.68u w=2.5u l=1u
X381 a_56766_47199# ibias1.t26 AVSS.t164 AVSS.t165 sg13_hv_nmos ad=0.85p pd=5.68u as=0.85p ps=5.68u w=2.5u l=1u
X382 a_56766_38633# ibias1.t8 AVSS.t198 AVSS.t57 sg13_hv_nmos ad=0.85p pd=5.68u as=0.85p ps=5.68u w=2.5u l=1u
X383 a_53873_44737# resistor_network_0.p1 comparator_slice_1.comparator_body_0.mref_m5_diff_0.tail.t2 AVSS.t135 sg13_hv_nmos ad=0.85p pd=5.68u as=0.85p ps=5.68u w=2.5u l=1u
X384 a_50902_18744# comparator_slice_0.comparator_body_0.m3_m4_diff_0.n1.t42 AVDD.t123 AVDD.t0 sg13_hv_pmos ad=0.85p pd=5.68u as=0.85p ps=5.68u w=2.5u l=1u
X385 a_50902_44827# comparator_slice_1.comparator_body_0.m3_m4_diff_0.n1.t50 AVDD.t94 AVDD.t4 sg13_hv_pmos ad=0.85p pd=5.68u as=0.85p ps=5.68u w=2.5u l=1u
X386 AVSS.t187 ibias1.t4 a_57666_41013# AVSS.t167 sg13_hv_nmos ad=0.85p pd=5.68u as=0.85p ps=5.68u w=2.5u l=1u
X387 a_56182_28641# ibias1.t20 comparator_slice_1.comparator_body_0.mref_m5_diff_0.tail.t94 AVSS.t55 sg13_hv_nmos ad=0.85p pd=5.68u as=0.85p ps=5.68u w=2.5u l=1u
X388 AVSS.t203 ibias1.t30 a_57666_36017# AVSS.t59 sg13_hv_nmos ad=0.85p pd=5.68u as=0.85p ps=5.68u w=2.5u l=1u
X389 a_53289_38126# resistor_network_0.p1 comparator_slice_1.comparator_body_0.m3_m4_diff_0.n1.t89 AVSS.t21 sg13_hv_nmos ad=0.85p pd=5.68u as=0.85p ps=5.68u w=2.5u l=1u
X390 AVSS.t15 AVSS.t15 AVDD.t3 rhigh l=13.42u w=0.5u
X391 a_53290_47217# threshold.t31 comparator_slice_1.comparator_body_0.outx.t54 AVSS.t156 sg13_hv_nmos ad=0.85p pd=5.68u as=0.85p ps=5.68u w=2.5u l=1u
X392 a_56182_7652# ibias0.t24 AVSS.t92 AVSS.t91 sg13_hv_nmos ad=0.85p pd=5.68u as=0.85p ps=5.68u w=2.5u l=1u
X393 a_53873_10675# vctrl.t43 comparator_slice_0.comparator_body_0.outx.t38 AVSS.t31 sg13_hv_nmos ad=0.85p pd=5.68u as=0.85p ps=5.68u w=2.5u l=1u
X394 comparator_slice_1.comparator_body_0.m3_m4_diff_0.n1.t69 resistor_network_0.p1 a_54772_31074# AVSS.t24 sg13_hv_nmos ad=0.85p pd=5.68u as=0.85p ps=5.68u w=2.5u l=1u
X395 comparator_slice_1.comparator_body_0.mref_m5_diff_0.tail.t72 ibias1.t54 a_57082_28641# AVSS.t53 sg13_hv_nmos ad=0.85p pd=5.68u as=0.85p ps=5.68u w=2.5u l=1u
X396 a_56766_6462# ibias0.t0 comparator_slice_0.comparator_body_0.mref_m5_diff_0.tail.t32 AVSS.t93 sg13_hv_nmos ad=0.85p pd=5.68u as=0.85p ps=5.68u w=2.5u l=1u
X397 AVSS.t9 AVSS.t10 AVDD.t3 rhigh l=13.42u w=0.5u
X398 AVSS.t14 AVSS.t14 AVDD.t3 rhigh l=13.42u w=0.5u
X399 comparator_slice_1.comparator_body_0.mref_m5_diff_0.tail.t3 resistor_network_0.p1 a_54186_38126# AVSS.t22 sg13_hv_nmos ad=0.85p pd=5.68u as=0.85p ps=5.68u w=2.5u l=1u
X400 comparator_slice_1.comparator_body_0.mref_m5_diff_0.tail.t43 threshold.t10 a_54186_33984# AVSS.t22 sg13_hv_nmos ad=0.85p pd=5.68u as=0.85p ps=5.68u w=2.5u l=1u
X401 ibias1.t5 ibias1.t4 a_57666_41013# AVSS.t167 sg13_hv_nmos ad=0.85p pd=5.68u as=0.85p ps=5.68u w=2.5u l=1u
X402 ibias1.t31 ibias1.t30 a_57666_36017# AVSS.t59 sg13_hv_nmos ad=0.85p pd=5.68u as=0.85p ps=5.68u w=2.5u l=1u
X403 a_50902_15044# comparator_slice_0.comparator_body_0.m3_m4_diff_0.n1.t60 comparator_slice_0.comparator_body_0.m3_m4_diff_0.n1.t61 AVDD.t0 sg13_hv_pmos ad=0.85p pd=5.68u as=0.85p ps=5.68u w=2.5u l=1u
X404 comparator_slice_0.comparator_body_0.mref_m5_diff_0.tail.t84 vctrl.t60 a_54186_22687# AVSS.t22 sg13_hv_nmos ad=0.85p pd=5.68u as=0.85p ps=5.68u w=2.5u l=1u
X405 AVDD.t121 comparator_slice_0.comparator_body_0.m3_m4_diff_0.n1.t86 a_51802_11344# AVDD.t0 sg13_hv_pmos ad=0.85p pd=5.68u as=0.85p ps=5.68u w=2.5u l=1u
X406 a_50318_32537# comparator_slice_1.comparator_body_0.m3_m4_diff_0.n1.t30 comparator_slice_1.comparator_body_0.m3_m4_diff_0.n1.t31 AVDD.t4 sg13_hv_pmos ad=0.85p pd=5.68u as=0.85p ps=5.68u w=2.5u l=1u
X407 a_56182_39823# ibias1.t50 AVSS.t193 AVSS.t188 sg13_hv_nmos ad=0.85p pd=5.68u as=0.85p ps=5.68u w=2.5u l=1u
X408 resistor_network_0.resistor_leg_0.p2 resistor_network_0.pb AVDD.t3 rhigh l=13.42u w=0.5u
X409 resistor_network_0.resistor_leg_1.p2 vctrl.t7 AVDD.t3 rhigh l=13.42u w=0.5u
X410 comparator_slice_1.comparator_body_0.m3_m4_diff_0.n1.t67 resistor_network_0.p1 a_54186_38126# AVSS.t22 sg13_hv_nmos ad=0.85p pd=5.68u as=0.85p ps=5.68u w=2.5u l=1u
X411 resistor_network_0.resistor_leg_0.pt resistor_network_0.p1 AVDD.t3 rhigh l=13.42u w=0.5u
X412 comparator_slice_1.comparator_body_0.outx.t57 threshold.t12 a_54772_35224# AVSS.t24 sg13_hv_nmos ad=0.85p pd=5.68u as=0.85p ps=5.68u w=2.5u l=1u
X413 comparator_slice_1.comparator_body_0.outx.t9 comparator_slice_1.comparator_body_0.m3_m4_diff_0.n1.t20 a_51218_33857# AVDD.t4 sg13_hv_pmos ad=0.85p pd=5.68u as=0.85p ps=5.68u w=2.5u l=1u
X414 a_50902_39937# comparator_slice_1.comparator_body_0.m3_m4_diff_0.n1.t56 AVDD.t21 AVDD.t4 sg13_hv_pmos ad=0.85p pd=5.68u as=0.85p ps=5.68u w=2.5u l=1u
X415 a_53873_40606# threshold.t21 comparator_slice_1.comparator_body_0.mref_m5_diff_0.tail.t38 AVSS.t135 sg13_hv_nmos ad=0.85p pd=5.68u as=0.85p ps=5.68u w=2.5u l=1u
X416 AVSS.t37 AVSS.t37 AVDD.t3 rhigh l=13.42u w=0.5u
X417 AVSS.t192 ibias1.t6 a_57082_39823# AVSS.t190 sg13_hv_nmos ad=0.85p pd=5.68u as=0.85p ps=5.68u w=2.5u l=1u
X418 a_53289_7784# trigger.t7 comparator_slice_0.comparator_body_0.m3_m4_diff_0.n1.t20 AVSS.t29 sg13_hv_nmos ad=0.85p pd=5.68u as=0.85p ps=5.68u w=2.5u l=1u
X419 AVSS.t15 AVSS.t15 AVDD.t3 rhigh l=13.42u w=0.5u
X420 a_53873_47217# resistor_network_0.p1 comparator_slice_1.comparator_body_0.m3_m4_diff_0.n1.t87 AVSS.t135 sg13_hv_nmos ad=0.85p pd=5.68u as=0.85p ps=5.68u w=2.5u l=1u
X421 comparator_slice_1.comparator_body_0.mref_m5_diff_0.tail.t16 resistor_network_0.p1 a_54772_39366# AVSS.t140 sg13_hv_nmos ad=0.85p pd=5.68u as=0.85p ps=5.68u w=2.5u l=1u
X422 comparator_slice_1.comparator_body_0.mref_m5_diff_0.tail.t60 threshold.t12 a_54772_35224# AVSS.t24 sg13_hv_nmos ad=0.85p pd=5.68u as=0.85p ps=5.68u w=2.5u l=1u
X423 a_50902_44827# comparator_slice_1.comparator_body_0.m3_m4_diff_0.n1.t50 comparator_slice_1.comparator_body_0.outx.t18 AVDD.t4 sg13_hv_pmos ad=0.85p pd=5.68u as=0.85p ps=5.68u w=2.5u l=1u
X424 AVDD.t130 comparator_slice_1.comparator_body_0.m3_m4_diff_0.n1.t6 a_51802_41127# AVDD.t4 sg13_hv_pmos ad=0.85p pd=5.68u as=0.85p ps=5.68u w=2.5u l=1u
X425 resistor_network_0.pb resistor_network_0.resistor_leg_0.p2 AVDD.t3 rhigh l=13.42u w=0.5u
X426 a_50318_22314# comparator_slice_0.comparator_body_0.m3_m4_diff_0.n1.t50 AVDD.t133 AVDD.t0 sg13_hv_pmos ad=0.85p pd=5.68u as=0.85p ps=5.68u w=2.5u l=1u
X427 a_50902_36237# comparator_slice_1.comparator_body_0.m3_m4_diff_0.n1.t24 AVDD.t103 AVDD.t4 sg13_hv_pmos ad=0.85p pd=5.68u as=0.85p ps=5.68u w=2.5u l=1u
X428 a_53873_47217# resistor_network_0.p1 comparator_slice_1.comparator_body_0.mref_m5_diff_0.tail.t23 AVSS.t135 sg13_hv_nmos ad=0.85p pd=5.68u as=0.85p ps=5.68u w=2.5u l=1u
X429 AVSS.t0 AVSS.t0 AVDD.t3 rhigh l=13.42u w=0.5u
X430 comparator_slice_0.comparator_body_0.m3_m4_diff_0.n1.t71 comparator_slice_0.comparator_body_0.m3_m4_diff_0.n1.t70 a_51218_4074# AVDD.t0 sg13_hv_pmos ad=0.85p pd=5.68u as=0.85p ps=5.68u w=2.5u l=1u
X431 AVDD.t108 comparator_slice_0.comparator_body_0.m3_m4_diff_0.n1.t58 a_51802_15044# AVDD.t0 sg13_hv_pmos ad=0.85p pd=5.68u as=0.85p ps=5.68u w=2.5u l=1u
X432 comparator_slice_1.comparator_body_0.m3_m4_diff_0.n1.t7 comparator_slice_1.comparator_body_0.m3_m4_diff_0.n1.t6 a_51802_41127# AVDD.t4 sg13_hv_pmos ad=0.85p pd=5.68u as=0.85p ps=5.68u w=2.5u l=1u
X433 a_50318_22314# comparator_slice_0.comparator_body_0.m3_m4_diff_0.n1.t50 comparator_slice_0.comparator_body_0.outx.t61 AVDD.t0 sg13_hv_pmos ad=0.85p pd=5.68u as=0.85p ps=5.68u w=2.5u l=1u
X434 a_56766_21450# ibias0.t50 comparator_slice_0.comparator_body_0.mref_m5_diff_0.tail.t63 AVSS.t57 sg13_hv_nmos ad=0.85p pd=5.68u as=0.85p ps=5.68u w=2.5u l=1u
X435 comparator_slice_1.comparator_body_0.outx.t2 comparator_slice_1.comparator_body_0.m3_m4_diff_0.n1.t62 a_51218_28967# AVDD.t4 sg13_hv_pmos ad=0.85p pd=5.68u as=0.85p ps=5.68u w=2.5u l=1u
X436 a_53873_28594# resistor_network_0.p1 comparator_slice_1.comparator_body_0.m3_m4_diff_0.n1.t76 AVSS.t23 sg13_hv_nmos ad=0.85p pd=5.68u as=0.85p ps=5.68u w=2.5u l=1u
X437 a_56766_46009# ibias1.t26 ibias1.t27 AVSS.t165 sg13_hv_nmos ad=0.85p pd=5.68u as=0.85p ps=5.68u w=2.5u l=1u
X438 a_56182_11458# ibias0.t44 AVSS.t97 AVSS.t87 sg13_hv_nmos ad=0.85p pd=5.68u as=0.85p ps=5.68u w=2.5u l=1u
X439 a_56766_16454# ibias0.t22 comparator_slice_0.comparator_body_0.mref_m5_diff_0.tail.t45 AVSS.t57 sg13_hv_nmos ad=0.85p pd=5.68u as=0.85p ps=5.68u w=2.5u l=1u
X440 a_56182_44819# ibias1.t32 ibias1.t33 AVSS.t163 sg13_hv_nmos ad=0.85p pd=5.68u as=0.85p ps=5.68u w=2.5u l=1u
X441 a_53873_13155# vctrl.t47 comparator_slice_0.comparator_body_0.outx.t24 AVSS.t27 sg13_hv_nmos ad=0.85p pd=5.68u as=0.85p ps=5.68u w=2.5u l=1u
X442 a_53873_17297# trigger.t21 comparator_slice_0.comparator_body_0.m3_m4_diff_0.n1.t26 AVSS.t23 sg13_hv_nmos ad=0.85p pd=5.68u as=0.85p ps=5.68u w=2.5u l=1u
X443 AVSS.t106 ibias0.t62 a_57666_10268# AVSS.t103 sg13_hv_nmos ad=0.85p pd=5.68u as=0.85p ps=5.68u w=2.5u l=1u
X444 comparator_slice_1.comparator_body_0.mref_m5_diff_0.tail.t59 threshold.t14 a_54186_36464# AVSS.t22 sg13_hv_nmos ad=0.85p pd=5.68u as=0.85p ps=5.68u w=2.5u l=1u
X445 vctrl.t31 resistor_network_0.resistor_leg_1.p2 AVDD.t3 rhigh l=13.42u w=0.5u
X446 AVDD.t34 comparator_slice_0.comparator_body_0.m3_m4_diff_0.n1.t62 a_51218_7644# AVDD.t0 sg13_hv_pmos ad=0.85p pd=5.68u as=0.85p ps=5.68u w=2.5u l=1u
X447 resistor_network_0.p1 resistor_network_0.resistor_leg_2.p1 AVDD.t3 rhigh l=13.42u w=0.5u
X448 AVDD.t68 comparator_slice_0.comparator_body_0.m3_m4_diff_0.n1.t48 a_51802_8964# AVDD.t0 sg13_hv_pmos ad=0.85p pd=5.68u as=0.85p ps=5.68u w=2.5u l=1u
X449 ibias1.t53 ibias1.t52 a_57082_44819# AVSS.t166 sg13_hv_nmos ad=0.85p pd=5.68u as=0.85p ps=5.68u w=2.5u l=1u
X450 a_56182_43629# ibias1.t32 AVSS.t175 AVSS.t163 sg13_hv_nmos ad=0.85p pd=5.68u as=0.85p ps=5.68u w=2.5u l=1u
X451 AVSS.t100 ibias0.t32 a_57082_11458# AVSS.t89 sg13_hv_nmos ad=0.85p pd=5.68u as=0.85p ps=5.68u w=2.5u l=1u
X452 a_53873_40606# threshold.t21 comparator_slice_1.comparator_body_0.outx.t35 AVSS.t135 sg13_hv_nmos ad=0.85p pd=5.68u as=0.85p ps=5.68u w=2.5u l=1u
X453 resistor_network_0.resistor_leg_0.p2 resistor_network_0.pb AVDD.t3 rhigh l=13.42u w=0.5u
X454 resistor_network_0.pb resistor_network_0.resistor_leg_0.p2 AVDD.t3 rhigh l=13.42u w=0.5u
X455 a_50318_13854# comparator_slice_0.comparator_body_0.m3_m4_diff_0.n1.t46 AVDD.t92 AVDD.t0 sg13_hv_pmos ad=0.85p pd=5.68u as=0.85p ps=5.68u w=2.5u l=1u
X456 AVSS.t120 ibias0.t20 a_57082_5272# AVSS.t102 sg13_hv_nmos ad=0.85p pd=5.68u as=0.85p ps=5.68u w=2.5u l=1u
X457 a_50318_17424# comparator_slice_0.comparator_body_0.m3_m4_diff_0.n1.t74 AVDD.t131 AVDD.t0 sg13_hv_pmos ad=0.85p pd=5.68u as=0.85p ps=5.68u w=2.5u l=1u
X458 a_53289_32744# resistor_network_0.p1 comparator_slice_1.comparator_body_0.m3_m4_diff_0.n1.t95 AVSS.t21 sg13_hv_nmos ad=0.85p pd=5.68u as=0.85p ps=5.68u w=2.5u l=1u
X459 comparator_slice_1.comparator_body_0.mref_m5_diff_0.tail.t91 ibias1.t18 a_57666_47199# AVSS.t167 sg13_hv_nmos ad=0.85p pd=5.68u as=0.85p ps=5.68u w=2.5u l=1u
X460 AVSS.t178 ibias1.t52 a_57082_43629# AVSS.t166 sg13_hv_nmos ad=0.85p pd=5.68u as=0.85p ps=5.68u w=2.5u l=1u
X461 a_56182_22640# ibias0.t34 comparator_slice_0.comparator_body_0.mref_m5_diff_0.tail.t50 AVSS.t55 sg13_hv_nmos ad=0.85p pd=5.68u as=0.85p ps=5.68u w=2.5u l=1u
X462 vctrl.t9 resistor_network_0.resistor_leg_1.pt AVDD.t3 rhigh l=13.42u w=0.5u
X463 a_56182_17644# ibias0.t40 comparator_slice_0.comparator_body_0.mref_m5_diff_0.tail.t56 AVSS.t55 sg13_hv_nmos ad=0.85p pd=5.68u as=0.85p ps=5.68u w=2.5u l=1u
X464 comparator_slice_0.comparator_body_0.m3_m4_diff_0.n1.t81 comparator_slice_0.comparator_body_0.m3_m4_diff_0.n1.t80 a_51802_5264# AVDD.t0 sg13_hv_pmos ad=0.85p pd=5.68u as=0.85p ps=5.68u w=2.5u l=1u
X465 comparator_slice_1.comparator_body_0.m3_m4_diff_0.n1.t33 comparator_slice_1.comparator_body_0.m3_m4_diff_0.n1.t32 a_51802_36237# AVDD.t4 sg13_hv_pmos ad=0.85p pd=5.68u as=0.85p ps=5.68u w=2.5u l=1u
X466 comparator_slice_0.comparator_body_0.mref_m5_diff_0.tail.t52 ibias0.t14 a_57666_19070# AVSS.t59 sg13_hv_nmos ad=0.85p pd=5.68u as=0.85p ps=5.68u w=2.5u l=1u
X467 a_56182_31021# ibias1.t22 AVSS.t220 AVSS.t55 sg13_hv_nmos ad=0.85p pd=5.68u as=0.85p ps=5.68u w=2.5u l=1u
X468 a_50318_17424# comparator_slice_0.comparator_body_0.m3_m4_diff_0.n1.t74 comparator_slice_0.comparator_body_0.outx.t60 AVDD.t0 sg13_hv_pmos ad=0.85p pd=5.68u as=0.85p ps=5.68u w=2.5u l=1u
X469 a_50318_10154# comparator_slice_0.comparator_body_0.m3_m4_diff_0.n1.t66 comparator_slice_0.comparator_body_0.outx.t9 AVDD.t0 sg13_hv_pmos ad=0.85p pd=5.68u as=0.85p ps=5.68u w=2.5u l=1u
X470 comparator_slice_0.comparator_body_0.mref_m5_diff_0.tail.t51 ibias0.t18 a_57082_22640# AVSS.t53 sg13_hv_nmos ad=0.85p pd=5.68u as=0.85p ps=5.68u w=2.5u l=1u
X471 a_60474_12138# comparator_slice_0.comparator_body_0.outx.t65 AVDD.t8 AVDD.t7 sg13_hv_pmos ad=0.85p pd=5.68u as=0.85p ps=5.68u w=2.5u l=1u
X472 comparator_slice_0.comparator_body_0.mref_m5_diff_0.tail.t53 ibias0.t4 a_57082_17644# AVSS.t53 sg13_hv_nmos ad=0.85p pd=5.68u as=0.85p ps=5.68u w=2.5u l=1u
X473 comparator_slice_0.comparator_body_0.m3_m4_diff_0.n1.t85 comparator_slice_0.comparator_body_0.m3_m4_diff_0.n1.t84 a_51218_18744# AVDD.t0 sg13_hv_pmos ad=0.85p pd=5.68u as=0.85p ps=5.68u w=2.5u l=1u
X474 AVSS.t15 AVSS.t15 AVDD.t3 rhigh l=13.42u w=0.5u
X475 AVDD.t52 comparator_slice_1.comparator_body_0.m3_m4_diff_0.n1.t8 a_51802_32537# AVDD.t4 sg13_hv_pmos ad=0.85p pd=5.68u as=0.85p ps=5.68u w=2.5u l=1u
X476 comparator_slice_1.comparator_body_0.m3_m4_diff_0.n1.t71 resistor_network_0.p1 a_54186_32744# AVSS.t22 sg13_hv_nmos ad=0.85p pd=5.68u as=0.85p ps=5.68u w=2.5u l=1u
X477 AVSS.t222 ibias1.t34 a_57082_31021# AVSS.t53 sg13_hv_nmos ad=0.85p pd=5.68u as=0.85p ps=5.68u w=2.5u l=1u
X478 a_56182_31021# ibias1.t22 comparator_slice_1.comparator_body_0.mref_m5_diff_0.tail.t73 AVSS.t55 sg13_hv_nmos ad=0.85p pd=5.68u as=0.85p ps=5.68u w=2.5u l=1u
X479 resistor_network_0.resistor_leg_0.p2 resistor_network_0.pb AVDD.t3 rhigh l=13.42u w=0.5u
X480 AVSS.t14 AVSS.t14 AVDD.t3 rhigh l=13.42u w=0.5u
X481 comparator_slice_1.comparator_body_0.mref_m5_diff_0.tail.t84 ibias1.t34 a_57082_31021# AVSS.t53 sg13_hv_nmos ad=0.85p pd=5.68u as=0.85p ps=5.68u w=2.5u l=1u
X482 a_56766_5272# ibias0.t58 ibias0.t59 AVSS.t93 sg13_hv_nmos ad=0.85p pd=5.68u as=0.85p ps=5.68u w=2.5u l=1u
X483 resistor_network_0.resistor_leg_0.p2 resistor_network_0.pb AVDD.t3 rhigh l=13.42u w=0.5u
X484 resistor_network_0.resistor_leg_1.p2 vctrl.t4 AVDD.t3 rhigh l=13.42u w=0.5u
X485 ibias0.t63 ibias0.t62 a_57666_10268# AVSS.t103 sg13_hv_nmos ad=0.85p pd=5.68u as=0.85p ps=5.68u w=2.5u l=1u
X486 a_53290_41846# threshold.t23 comparator_slice_1.comparator_body_0.outx.t30 AVSS.t156 sg13_hv_nmos ad=0.85p pd=5.68u as=0.85p ps=5.68u w=2.5u l=1u
X487 comparator_slice_1.comparator_body_0.mref_m5_diff_0.tail.t30 resistor_network_0.p1 a_54772_33984# AVSS.t24 sg13_hv_nmos ad=0.85p pd=5.68u as=0.85p ps=5.68u w=2.5u l=1u
X488 comparator_slice_0.comparator_body_0.mref_m5_diff_0.tail.t23 trigger.t8 a_54772_9435# AVSS.t32 sg13_hv_nmos ad=0.85p pd=5.68u as=0.85p ps=5.68u w=2.5u l=1u
X489 comparator_slice_0.comparator_body_0.mref_m5_diff_0.tail.t66 vctrl.t50 a_54772_16057# AVSS.t24 sg13_hv_nmos ad=0.85p pd=5.68u as=0.85p ps=5.68u w=2.5u l=1u
X490 resistor_network_0.resistor_leg_0.pt resistor_network_0.p1 AVDD.t3 rhigh l=13.42u w=0.5u
X491 a_53289_35224# resistor_network_0.p1 comparator_slice_1.comparator_body_0.mref_m5_diff_0.tail.t4 AVSS.t21 sg13_hv_nmos ad=0.85p pd=5.68u as=0.85p ps=5.68u w=2.5u l=1u
X492 a_50318_31347# comparator_slice_1.comparator_body_0.m3_m4_diff_0.n1.t30 AVDD.t105 AVDD.t4 sg13_hv_pmos ad=0.85p pd=5.68u as=0.85p ps=5.68u w=2.5u l=1u
X493 a_56182_14074# ibias0.t46 AVSS.t83 AVSS.t55 sg13_hv_nmos ad=0.85p pd=5.68u as=0.85p ps=5.68u w=2.5u l=1u
X494 a_53289_6544# vctrl.t37 comparator_slice_0.comparator_body_0.mref_m5_diff_0.tail.t90 AVSS.t29 sg13_hv_nmos ad=0.85p pd=5.68u as=0.85p ps=5.68u w=2.5u l=1u
X495 a_53873_45977# threshold.t29 comparator_slice_1.comparator_body_0.mref_m5_diff_0.tail.t63 AVSS.t135 sg13_hv_nmos ad=0.85p pd=5.68u as=0.85p ps=5.68u w=2.5u l=1u
X496 a_53873_43497# threshold.t25 comparator_slice_1.comparator_body_0.mref_m5_diff_0.tail.t36 AVSS.t135 sg13_hv_nmos ad=0.85p pd=5.68u as=0.85p ps=5.68u w=2.5u l=1u
X497 comparator_slice_1.comparator_body_0.mref_m5_diff_0.tail.t58 threshold.t6 a_54186_31074# AVSS.t22 sg13_hv_nmos ad=0.85p pd=5.68u as=0.85p ps=5.68u w=2.5u l=1u
X498 AVSS.t164 ibias1.t18 a_57666_47199# AVSS.t167 sg13_hv_nmos ad=0.85p pd=5.68u as=0.85p ps=5.68u w=2.5u l=1u
X499 AVSS.t196 ibias1.t0 a_57666_38633# AVSS.t59 sg13_hv_nmos ad=0.85p pd=5.68u as=0.85p ps=5.68u w=2.5u l=1u
X500 a_53290_4064# vctrl.t33 comparator_slice_0.comparator_body_0.mref_m5_diff_0.tail.t86 AVSS.t146 sg13_hv_nmos ad=0.85p pd=5.68u as=0.85p ps=5.68u w=2.5u l=1u
X501 AVDD.t1 comparator_slice_0.comparator_body_0.m3_m4_diff_0.n1.t36 a_51218_10154# AVDD.t0 sg13_hv_pmos ad=0.85p pd=5.68u as=0.85p ps=5.68u w=2.5u l=1u
X502 a_53289_39366# threshold.t19 comparator_slice_1.comparator_body_0.outx.t31 AVSS.t157 sg13_hv_nmos ad=0.85p pd=5.68u as=0.85p ps=5.68u w=2.5u l=1u
X503 a_53289_35224# resistor_network_0.p1 comparator_slice_1.comparator_body_0.m3_m4_diff_0.n1.t68 AVSS.t21 sg13_hv_nmos ad=0.85p pd=5.68u as=0.85p ps=5.68u w=2.5u l=1u
X504 resistor_network_0.pb resistor_network_0.resistor_leg_0.p2 AVDD.t3 rhigh l=13.42u w=0.5u
X505 AVSS.t85 ibias0.t10 a_57082_14074# AVSS.t53 sg13_hv_nmos ad=0.85p pd=5.68u as=0.85p ps=5.68u w=2.5u l=1u
X506 a_62904_13955# a_60176_13955# reset_b AVSS.t5 sg13_hv_nmos ad=0.85p pd=5.68u as=0.85p ps=5.68u w=2.5u l=1u
X507 AVSS.t14 AVSS.t14 AVDD.t3 rhigh l=13.42u w=0.5u
X508 AVDD.t115 comparator_slice_1.comparator_body_0.m3_m4_diff_0.n1.t16 a_51802_47207# AVDD.t4 sg13_hv_pmos ad=0.85p pd=5.68u as=0.85p ps=5.68u w=2.5u l=1u
X509 AVDD.t58 comparator_slice_1.comparator_body_0.m3_m4_diff_0.n1.t58 a_51802_43637# AVDD.t4 sg13_hv_pmos ad=0.85p pd=5.68u as=0.85p ps=5.68u w=2.5u l=1u
X510 comparator_slice_1.comparator_body_0.mref_m5_diff_0.tail.t17 resistor_network_0.p1 a_54186_35224# AVSS.t22 sg13_hv_nmos ad=0.85p pd=5.68u as=0.85p ps=5.68u w=2.5u l=1u
X511 a_60474_12138# comparator_slice_0.comparator_body_0.outx.t65 a_60176_13955# AVDD.t7 sg13_hv_pmos ad=0.85p pd=5.68u as=0.85p ps=5.68u w=2.5u l=1u
X512 a_53873_29834# threshold.t5 comparator_slice_1.comparator_body_0.mref_m5_diff_0.tail.t54 AVSS.t23 sg13_hv_nmos ad=0.85p pd=5.68u as=0.85p ps=5.68u w=2.5u l=1u
X513 a_53873_27354# threshold.t1 comparator_slice_1.comparator_body_0.mref_m5_diff_0.tail.t39 AVSS.t23 sg13_hv_nmos ad=0.85p pd=5.68u as=0.85p ps=5.68u w=2.5u l=1u
X514 a_50902_12534# comparator_slice_0.comparator_body_0.m3_m4_diff_0.n1.t64 comparator_slice_0.comparator_body_0.m3_m4_diff_0.n1.t65 AVDD.t0 sg13_hv_pmos ad=0.85p pd=5.68u as=0.85p ps=5.68u w=2.5u l=1u
X515 comparator_slice_1.comparator_body_0.outx.t26 comparator_slice_1.comparator_body_0.m3_m4_diff_0.n1.t16 a_51802_47207# AVDD.t4 sg13_hv_pmos ad=0.85p pd=5.68u as=0.85p ps=5.68u w=2.5u l=1u
X516 comparator_slice_1.comparator_body_0.m3_m4_diff_0.n1.t81 resistor_network_0.p1 a_54186_35224# AVSS.t22 sg13_hv_nmos ad=0.85p pd=5.68u as=0.85p ps=5.68u w=2.5u l=1u
X517 AVDD.t25 resistor_network_0.resistor_leg_3.p1 AVDD.t3 rhigh l=13.42u w=0.5u
X518 a_50902_43637# comparator_slice_1.comparator_body_0.m3_m4_diff_0.n1.t50 comparator_slice_1.comparator_body_0.m3_m4_diff_0.n1.t51 AVDD.t4 sg13_hv_pmos ad=0.85p pd=5.68u as=0.85p ps=5.68u w=2.5u l=1u
X519 comparator_slice_1.comparator_body_0.outx.t15 comparator_slice_1.comparator_body_0.m3_m4_diff_0.n1.t42 a_51802_39937# AVDD.t4 sg13_hv_pmos ad=0.85p pd=5.68u as=0.85p ps=5.68u w=2.5u l=1u
X520 comparator_slice_1.comparator_body_0.outx.t39 threshold.t18 a_54186_39366# AVSS.t158 sg13_hv_nmos ad=0.85p pd=5.68u as=0.85p ps=5.68u w=2.5u l=1u
X521 vctrl.t13 resistor_network_0.resistor_leg_1.p2 AVDD.t3 rhigh l=13.42u w=0.5u
X522 comparator_slice_0.comparator_body_0.outx.t53 comparator_slice_0.comparator_body_0.m3_m4_diff_0.n1.t58 a_51802_13854# AVDD.t0 sg13_hv_pmos ad=0.85p pd=5.68u as=0.85p ps=5.68u w=2.5u l=1u
X523 resistor_network_0.p1 resistor_network_0.resistor_leg_2.p1 AVDD.t3 rhigh l=13.42u w=0.5u
X524 AVSS.t20 AVSS.t20 AVDD.t3 rhigh l=13.42u w=0.5u
X525 a_56766_20260# ibias0.t54 ibias0.t55 AVSS.t57 sg13_hv_nmos ad=0.85p pd=5.68u as=0.85p ps=5.68u w=2.5u l=1u
X526 a_50318_35047# comparator_slice_1.comparator_body_0.m3_m4_diff_0.n1.t22 AVDD.t18 AVDD.t4 sg13_hv_pmos ad=0.85p pd=5.68u as=0.85p ps=5.68u w=2.5u l=1u
X527 a_56766_15264# ibias0.t30 ibias0.t31 AVSS.t57 sg13_hv_nmos ad=0.85p pd=5.68u as=0.85p ps=5.68u w=2.5u l=1u
X528 comparator_slice_1.comparator_body_0.outx.t19 comparator_slice_1.comparator_body_0.m3_m4_diff_0.n1.t54 a_51218_31347# AVDD.t4 sg13_hv_pmos ad=0.85p pd=5.68u as=0.85p ps=5.68u w=2.5u l=1u
X529 a_53873_41846# resistor_network_0.p1 comparator_slice_1.comparator_body_0.mref_m5_diff_0.tail.t18 AVSS.t135 sg13_hv_nmos ad=0.85p pd=5.68u as=0.85p ps=5.68u w=2.5u l=1u
X530 AVSS.t152 AVSS.t153 AVDD.t3 rhigh l=13.42u w=0.5u
X531 comparator_slice_1.comparator_body_0.mref_m5_diff_0.tail.t10 resistor_network_0.p1 a_54772_36464# AVSS.t24 sg13_hv_nmos ad=0.85p pd=5.68u as=0.85p ps=5.68u w=2.5u l=1u
X532 AVDD.t62 comparator_slice_1.comparator_body_0.m3_m4_diff_0.n1.t42 a_51802_38747# AVDD.t4 sg13_hv_pmos ad=0.85p pd=5.68u as=0.85p ps=5.68u w=2.5u l=1u
X533 comparator_slice_0.comparator_body_0.mref_m5_diff_0.tail.t73 vctrl.t54 a_54772_18537# AVSS.t24 sg13_hv_nmos ad=0.85p pd=5.68u as=0.85p ps=5.68u w=2.5u l=1u
X534 a_50318_19934# comparator_slice_0.comparator_body_0.m3_m4_diff_0.n1.t52 AVDD.t116 AVDD.t0 sg13_hv_pmos ad=0.85p pd=5.68u as=0.85p ps=5.68u w=2.5u l=1u
X535 a_56182_43629# ibias1.t32 comparator_slice_1.comparator_body_0.mref_m5_diff_0.tail.t65 AVSS.t163 sg13_hv_nmos ad=0.85p pd=5.68u as=0.85p ps=5.68u w=2.5u l=1u
X536 a_56182_38633# ibias1.t50 comparator_slice_1.comparator_body_0.mref_m5_diff_0.tail.t70 AVSS.t188 sg13_hv_nmos ad=0.85p pd=5.68u as=0.85p ps=5.68u w=2.5u l=1u
X537 ibias0.t21 ibias0.t20 a_57082_4082# AVSS.t102 sg13_hv_nmos ad=0.85p pd=5.68u as=0.85p ps=5.68u w=2.5u l=1u
X538 a_53873_21447# vctrl.t59 comparator_slice_0.comparator_body_0.mref_m5_diff_0.tail.t71 AVSS.t23 sg13_hv_nmos ad=0.85p pd=5.68u as=0.85p ps=5.68u w=2.5u l=1u
X539 resistor_network_0.resistor_leg_1.p2 vctrl.t10 AVDD.t3 rhigh l=13.42u w=0.5u
X540 AVDD.t25 resistor_network_0.resistor_leg_3.p1 AVDD.t3 rhigh l=13.42u w=0.5u
X541 a_50902_38747# comparator_slice_1.comparator_body_0.m3_m4_diff_0.n1.t56 comparator_slice_1.comparator_body_0.m3_m4_diff_0.n1.t57 AVDD.t4 sg13_hv_pmos ad=0.85p pd=5.68u as=0.85p ps=5.68u w=2.5u l=1u
X542 comparator_slice_1.comparator_body_0.mref_m5_diff_0.tail.t80 ibias1.t52 a_57082_43629# AVSS.t166 sg13_hv_nmos ad=0.85p pd=5.68u as=0.85p ps=5.68u w=2.5u l=1u
X543 AVDD.t75 comparator_slice_0.comparator_body_0.m3_m4_diff_0.n1.t82 a_51218_21124# AVDD.t0 sg13_hv_pmos ad=0.85p pd=5.68u as=0.85p ps=5.68u w=2.5u l=1u
X544 comparator_slice_1.comparator_body_0.outx.t20 comparator_slice_1.comparator_body_0.m3_m4_diff_0.n1.t60 a_51802_35047# AVDD.t4 sg13_hv_pmos ad=0.85p pd=5.68u as=0.85p ps=5.68u w=2.5u l=1u
X545 comparator_slice_1.comparator_body_0.mref_m5_diff_0.tail.t64 ibias1.t6 a_57082_38633# AVSS.t190 sg13_hv_nmos ad=0.85p pd=5.68u as=0.85p ps=5.68u w=2.5u l=1u
X546 AVSS.t111 ibias0.t48 a_57082_7652# AVSS.t102 sg13_hv_nmos ad=0.85p pd=5.68u as=0.85p ps=5.68u w=2.5u l=1u
X547 comparator_slice_0.comparator_body_0.mref_m5_diff_0.tail.t41 ibias0.t42 a_57666_21450# AVSS.t59 sg13_hv_nmos ad=0.85p pd=5.68u as=0.85p ps=5.68u w=2.5u l=1u
X548 a_50318_16234# comparator_slice_0.comparator_body_0.m3_m4_diff_0.n1.t74 AVDD.t132 AVDD.t0 sg13_hv_pmos ad=0.85p pd=5.68u as=0.85p ps=5.68u w=2.5u l=1u
X549 ibias1.t19 ibias1.t18 a_57666_46009# AVSS.t167 sg13_hv_nmos ad=0.85p pd=5.68u as=0.85p ps=5.68u w=2.5u l=1u
X550 comparator_slice_0.comparator_body_0.mref_m5_diff_0.tail.t34 ibias0.t52 a_57666_16454# AVSS.t59 sg13_hv_nmos ad=0.85p pd=5.68u as=0.85p ps=5.68u w=2.5u l=1u
X551 a_62320_13955# a_60176_13955# AVSS.t4 AVSS.t3 sg13_hv_nmos ad=0.85p pd=5.68u as=0.85p ps=5.68u w=2.5u l=1u
X552 a_50318_7644# comparator_slice_0.comparator_body_0.m3_m4_diff_0.n1.t94 comparator_slice_0.comparator_body_0.outx.t17 AVDD.t0 sg13_hv_pmos ad=0.85p pd=5.68u as=0.85p ps=5.68u w=2.5u l=1u
X553 resistor_network_0.resistor_leg_2.p1 resistor_network_0.p1 AVDD.t3 rhigh l=13.42u w=0.5u
X554 comparator_slice_0.comparator_body_0.m3_m4_diff_0.n1.t83 comparator_slice_0.comparator_body_0.m3_m4_diff_0.n1.t82 a_51218_21124# AVDD.t0 sg13_hv_pmos ad=0.85p pd=5.68u as=0.85p ps=5.68u w=2.5u l=1u
X555 vctrl.t26 resistor_network_0.resistor_leg_0.p2 AVDD.t3 rhigh l=13.42u w=0.5u
X556 a_56766_34827# ibias1.t14 AVSS.t211 AVSS.t57 sg13_hv_nmos ad=0.85p pd=5.68u as=0.85p ps=5.68u w=2.5u l=1u
X557 a_56182_29831# ibias1.t20 ibias1.t21 AVSS.t55 sg13_hv_nmos ad=0.85p pd=5.68u as=0.85p ps=5.68u w=2.5u l=1u
X558 AVSS.t117 ibias0.t8 a_57666_5272# AVSS.t103 sg13_hv_nmos ad=0.85p pd=5.68u as=0.85p ps=5.68u w=2.5u l=1u
X559 comparator_slice_0.comparator_body_0.m3_m4_diff_0.n1.t18 trigger.t16 a_54772_14817# AVSS.t24 sg13_hv_nmos ad=0.85p pd=5.68u as=0.85p ps=5.68u w=2.5u l=1u
X560 a_60474_39143# comparator_slice_1.comparator_body_0.outx.t67 a_60176_37898# AVDD.t76 sg13_hv_pmos ad=0.85p pd=5.68u as=0.85p ps=5.68u w=2.5u l=1u
X561 a_53289_33984# threshold.t11 comparator_slice_1.comparator_body_0.outx.t37 AVSS.t21 sg13_hv_nmos ad=0.85p pd=5.68u as=0.85p ps=5.68u w=2.5u l=1u
X562 AVSS.t141 AVSS.t142 AVDD.t3 rhigh l=13.42u w=0.5u
X563 a_53289_16057# trigger.t19 comparator_slice_0.comparator_body_0.m3_m4_diff_0.n1.t13 AVSS.t21 sg13_hv_nmos ad=0.85p pd=5.68u as=0.85p ps=5.68u w=2.5u l=1u
X564 a_53290_20207# vctrl.t57 comparator_slice_0.comparator_body_0.outx.t36 AVSS.t145 sg13_hv_nmos ad=0.85p pd=5.68u as=0.85p ps=5.68u w=2.5u l=1u
X565 AVSS.t38 AVSS.t39 AVDD.t3 rhigh l=13.42u w=0.5u
X566 a_61028_13955# comparator_slice_0.comparator_body_0.outx.t66 AVSS.t132 AVSS.t40 sg13_hv_nmos ad=0.85p pd=5.68u as=0.85p ps=5.68u w=2.5u l=1u
X567 ibias1.t55 ibias1.t54 a_57082_29831# AVSS.t53 sg13_hv_nmos ad=0.85p pd=5.68u as=0.85p ps=5.68u w=2.5u l=1u
X568 a_50318_46017# comparator_slice_1.comparator_body_0.m3_m4_diff_0.n1.t36 AVDD.t55 AVDD.t4 sg13_hv_pmos ad=0.85p pd=5.68u as=0.85p ps=5.68u w=2.5u l=1u
X569 AVDD.t25 resistor_network_0.resistor_leg_3.p1 AVDD.t3 rhigh l=13.42u w=0.5u
X570 AVDD.t23 comparator_slice_1.comparator_body_0.m3_m4_diff_0.n1.t10 a_51218_42317# AVDD.t4 sg13_hv_pmos ad=0.85p pd=5.68u as=0.85p ps=5.68u w=2.5u l=1u
X571 a_56182_28641# ibias1.t20 AVSS.t228 AVSS.t55 sg13_hv_nmos ad=0.85p pd=5.68u as=0.85p ps=5.68u w=2.5u l=1u
X572 a_50902_30157# comparator_slice_1.comparator_body_0.m3_m4_diff_0.n1.t14 AVDD.t106 AVDD.t4 sg13_hv_pmos ad=0.85p pd=5.68u as=0.85p ps=5.68u w=2.5u l=1u
X573 a_53290_20207# vctrl.t57 comparator_slice_0.comparator_body_0.mref_m5_diff_0.tail.t79 AVSS.t145 sg13_hv_nmos ad=0.85p pd=5.68u as=0.85p ps=5.68u w=2.5u l=1u
X574 a_56182_7652# ibias0.t24 comparator_slice_0.comparator_body_0.mref_m5_diff_0.tail.t37 AVSS.t91 sg13_hv_nmos ad=0.85p pd=5.68u as=0.85p ps=5.68u w=2.5u l=1u
X575 a_56766_19070# ibias0.t54 AVSS.t67 AVSS.t57 sg13_hv_nmos ad=0.85p pd=5.68u as=0.85p ps=5.68u w=2.5u l=1u
X576 resistor_network_0.p1 resistor_network_0.resistor_leg_3.p1 AVDD.t3 rhigh l=13.42u w=0.5u
X577 AVSS.t228 ibias1.t54 a_57082_28641# AVSS.t53 sg13_hv_nmos ad=0.85p pd=5.68u as=0.85p ps=5.68u w=2.5u l=1u
X578 comparator_slice_0.comparator_body_0.m3_m4_diff_0.n1.t45 comparator_slice_0.comparator_body_0.m3_m4_diff_0.n1.t44 a_51218_16234# AVDD.t0 sg13_hv_pmos ad=0.85p pd=5.68u as=0.85p ps=5.68u w=2.5u l=1u
X579 a_50318_46017# comparator_slice_1.comparator_body_0.m3_m4_diff_0.n1.t36 comparator_slice_1.comparator_body_0.outx.t12 AVDD.t4 sg13_hv_pmos ad=0.85p pd=5.68u as=0.85p ps=5.68u w=2.5u l=1u
X580 comparator_slice_1.comparator_body_0.m3_m4_diff_0.n1.t11 comparator_slice_1.comparator_body_0.m3_m4_diff_0.n1.t10 a_51218_42317# AVDD.t4 sg13_hv_pmos ad=0.85p pd=5.68u as=0.85p ps=5.68u w=2.5u l=1u
X581 comparator_slice_1.comparator_body_0.outx.t40 threshold.t10 a_54186_33984# AVSS.t22 sg13_hv_nmos ad=0.85p pd=5.68u as=0.85p ps=5.68u w=2.5u l=1u
X582 comparator_slice_0.comparator_body_0.outx.t35 vctrl.t40 a_54186_9435# AVSS.t30 sg13_hv_nmos ad=0.85p pd=5.68u as=0.85p ps=5.68u w=2.5u l=1u
X583 comparator_slice_0.comparator_body_0.m3_m4_diff_0.n1.t11 trigger.t18 a_54186_16057# AVSS.t22 sg13_hv_nmos ad=0.85p pd=5.68u as=0.85p ps=5.68u w=2.5u l=1u
X584 a_50318_4074# comparator_slice_0.comparator_body_0.m3_m4_diff_0.n1.t90 AVDD.t148 AVDD.t0 sg13_hv_pmos ad=0.85p pd=5.68u as=0.85p ps=5.68u w=2.5u l=1u
X585 comparator_slice_1.comparator_body_0.m3_m4_diff_0.n1.t85 resistor_network_0.p1 a_54772_44737# AVSS.t136 sg13_hv_nmos ad=0.85p pd=5.68u as=0.85p ps=5.68u w=2.5u l=1u
X586 a_56182_21450# ibias0.t34 AVSS.t60 AVSS.t55 sg13_hv_nmos ad=0.85p pd=5.68u as=0.85p ps=5.68u w=2.5u l=1u
X587 AVSS.t11 AVSS.t11 AVDD.t3 rhigh l=13.42u w=0.5u
X588 a_56182_16454# ibias0.t40 AVSS.t75 AVSS.t55 sg13_hv_nmos ad=0.85p pd=5.68u as=0.85p ps=5.68u w=2.5u l=1u
X589 a_56766_39823# ibias1.t8 comparator_slice_1.comparator_body_0.mref_m5_diff_0.tail.t83 AVSS.t189 sg13_hv_nmos ad=0.85p pd=5.68u as=0.85p ps=5.68u w=2.5u l=1u
X590 resistor_network_0.resistor_leg_1.pt vctrl.t22 AVDD.t3 rhigh l=13.42u w=0.5u
X591 resistor_network_0.pb resistor_network_0.resistor_leg_1.p2 AVDD.t3 rhigh l=13.42u w=0.5u
X592 a_56766_34827# ibias1.t14 comparator_slice_1.comparator_body_0.mref_m5_diff_0.tail.t75 AVSS.t57 sg13_hv_nmos ad=0.85p pd=5.68u as=0.85p ps=5.68u w=2.5u l=1u
X593 comparator_slice_0.comparator_body_0.mref_m5_diff_0.tail.t89 vctrl.t46 a_54772_13155# AVSS.t24 sg13_hv_nmos ad=0.85p pd=5.68u as=0.85p ps=5.68u w=2.5u l=1u
X594 AVDD.t31 comparator_slice_0.comparator_body_0.m3_m4_diff_0.n1.t32 a_51218_12534# AVDD.t0 sg13_hv_pmos ad=0.85p pd=5.68u as=0.85p ps=5.68u w=2.5u l=1u
X595 AVDD.t25 resistor_network_0.resistor_leg_3.p1 AVDD.t3 rhigh l=13.42u w=0.5u
X596 AVDD.t71 comparator_slice_1.comparator_body_0.m3_m4_diff_0.n1.t0 a_51218_37427# AVDD.t4 sg13_hv_pmos ad=0.85p pd=5.68u as=0.85p ps=5.68u w=2.5u l=1u
X597 AVDD.t48 comparator_slice_1.comparator_body_0.m3_m4_diff_0.n1.t20 a_51218_33857# AVDD.t4 sg13_hv_pmos ad=0.85p pd=5.68u as=0.85p ps=5.68u w=2.5u l=1u
X598 comparator_slice_0.comparator_body_0.mref_m5_diff_0.tail.t77 vctrl.t42 a_54772_10675# AVSS.t32 sg13_hv_nmos ad=0.85p pd=5.68u as=0.85p ps=5.68u w=2.5u l=1u
X599 comparator_slice_0.comparator_body_0.mref_m5_diff_0.tail.t18 trigger.t16 a_54772_14817# AVSS.t24 sg13_hv_nmos ad=0.85p pd=5.68u as=0.85p ps=5.68u w=2.5u l=1u
X600 comparator_slice_0.comparator_body_0.mref_m5_diff_0.tail.t9 trigger.t20 a_54772_17297# AVSS.t24 sg13_hv_nmos ad=0.85p pd=5.68u as=0.85p ps=5.68u w=2.5u l=1u
X601 AVSS.t54 ibias0.t18 a_57082_21450# AVSS.t53 sg13_hv_nmos ad=0.85p pd=5.68u as=0.85p ps=5.68u w=2.5u l=1u
X602 a_50902_11344# comparator_slice_0.comparator_body_0.m3_m4_diff_0.n1.t64 AVDD.t111 AVDD.t0 sg13_hv_pmos ad=0.85p pd=5.68u as=0.85p ps=5.68u w=2.5u l=1u
X603 AVSS.t47 AVSS.t48 AVDD.t3 rhigh l=13.42u w=0.5u
X604 AVSS.t78 ibias0.t4 a_57082_16454# AVSS.t53 sg13_hv_nmos ad=0.85p pd=5.68u as=0.85p ps=5.68u w=2.5u l=1u
X605 AVSS.t239 AVSS.t240 AVDD.t3 rhigh l=13.42u w=0.5u
X606 a_53289_7784# trigger.t7 comparator_slice_0.comparator_body_0.mref_m5_diff_0.tail.t20 AVSS.t29 sg13_hv_nmos ad=0.85p pd=5.68u as=0.85p ps=5.68u w=2.5u l=1u
X607 a_53873_20207# trigger.t25 comparator_slice_0.comparator_body_0.mref_m5_diff_0.tail.t15 AVSS.t23 sg13_hv_nmos ad=0.85p pd=5.68u as=0.85p ps=5.68u w=2.5u l=1u
X608 resistor_network_0.p1 resistor_network_0.resistor_leg_3.p1 AVDD.t3 rhigh l=13.42u w=0.5u
X609 comparator_slice_1.comparator_body_0.m3_m4_diff_0.n1.t1 comparator_slice_1.comparator_body_0.m3_m4_diff_0.n1.t0 a_51218_37427# AVDD.t4 sg13_hv_pmos ad=0.85p pd=5.68u as=0.85p ps=5.68u w=2.5u l=1u
X610 a_53873_4064# trigger.t1 comparator_slice_0.comparator_body_0.mref_m5_diff_0.tail.t12 AVSS.t31 sg13_hv_nmos ad=0.85p pd=5.68u as=0.85p ps=5.68u w=2.5u l=1u
X611 a_50318_33857# comparator_slice_1.comparator_body_0.m3_m4_diff_0.n1.t22 comparator_slice_1.comparator_body_0.outx.t1 AVDD.t4 sg13_hv_pmos ad=0.85p pd=5.68u as=0.85p ps=5.68u w=2.5u l=1u
X612 AVSS.t20 AVSS.t20 AVDD.t3 rhigh l=13.42u w=0.5u
X613 AVSS.t11 AVSS.t11 AVDD.t3 rhigh l=13.42u w=0.5u
X614 comparator_slice_1.comparator_body_0.m3_m4_diff_0.n1.t63 comparator_slice_1.comparator_body_0.m3_m4_diff_0.n1.t62 a_51218_30157# AVDD.t4 sg13_hv_pmos ad=0.85p pd=5.68u as=0.85p ps=5.68u w=2.5u l=1u
X615 a_56766_12648# ibias0.t56 ibias0.t57 AVSS.t95 sg13_hv_nmos ad=0.85p pd=5.68u as=0.85p ps=5.68u w=2.5u l=1u
X616 a_56182_4082# ibias0.t38 AVSS.t121 AVSS.t91 sg13_hv_nmos ad=0.85p pd=5.68u as=0.85p ps=5.68u w=2.5u l=1u
X617 a_53289_18537# trigger.t23 comparator_slice_0.comparator_body_0.m3_m4_diff_0.n1.t4 AVSS.t21 sg13_hv_nmos ad=0.85p pd=5.68u as=0.85p ps=5.68u w=2.5u l=1u
X618 a_56182_41013# ibias1.t40 AVSS.t180 AVSS.t163 sg13_hv_nmos ad=0.85p pd=5.68u as=0.85p ps=5.68u w=2.5u l=1u
X619 a_53873_20207# trigger.t25 comparator_slice_0.comparator_body_0.m3_m4_diff_0.n1.t15 AVSS.t23 sg13_hv_nmos ad=0.85p pd=5.68u as=0.85p ps=5.68u w=2.5u l=1u
X620 a_50902_5264# comparator_slice_0.comparator_body_0.m3_m4_diff_0.n1.t76 AVDD.t65 AVDD.t0 sg13_hv_pmos ad=0.85p pd=5.68u as=0.85p ps=5.68u w=2.5u l=1u
X621 a_56182_36017# ibias1.t48 AVSS.t209 AVSS.t55 sg13_hv_nmos ad=0.85p pd=5.68u as=0.85p ps=5.68u w=2.5u l=1u
X622 resistor_network_0.resistor_leg_1.p2 vctrl.t14 AVDD.t3 rhigh l=13.42u w=0.5u
X623 AVSS.t44 AVSS.t6 AVDD.t3 rhigh l=13.42u w=0.5u
X624 a_50902_41127# comparator_slice_1.comparator_body_0.m3_m4_diff_0.n1.t12 AVDD.t101 AVDD.t4 sg13_hv_pmos ad=0.85p pd=5.68u as=0.85p ps=5.68u w=2.5u l=1u
X625 a_53873_28594# resistor_network_0.p1 comparator_slice_1.comparator_body_0.mref_m5_diff_0.tail.t12 AVSS.t23 sg13_hv_nmos ad=0.85p pd=5.68u as=0.85p ps=5.68u w=2.5u l=1u
X626 AVDD.t20 comparator_slice_1.comparator_body_0.m3_m4_diff_0.n1.t62 a_51218_28967# AVDD.t4 sg13_hv_pmos ad=0.85p pd=5.68u as=0.85p ps=5.68u w=2.5u l=1u
X627 AVSS.t186 ibias1.t62 a_57082_41013# AVSS.t166 sg13_hv_nmos ad=0.85p pd=5.68u as=0.85p ps=5.68u w=2.5u l=1u
X628 a_56182_41013# ibias1.t40 comparator_slice_1.comparator_body_0.mref_m5_diff_0.tail.t76 AVSS.t163 sg13_hv_nmos ad=0.85p pd=5.68u as=0.85p ps=5.68u w=2.5u l=1u
X629 AVSS.t207 ibias1.t44 a_57082_36017# AVSS.t53 sg13_hv_nmos ad=0.85p pd=5.68u as=0.85p ps=5.68u w=2.5u l=1u
X630 a_56182_36017# ibias1.t48 comparator_slice_1.comparator_body_0.mref_m5_diff_0.tail.t79 AVSS.t55 sg13_hv_nmos ad=0.85p pd=5.68u as=0.85p ps=5.68u w=2.5u l=1u
X631 comparator_slice_1.comparator_body_0.mref_m5_diff_0.tail.t5 resistor_network_0.p1 a_54772_31074# AVSS.t24 sg13_hv_nmos ad=0.85p pd=5.68u as=0.85p ps=5.68u w=2.5u l=1u
X632 resistor_network_0.resistor_leg_1.p2 resistor_network_0.pb AVDD.t3 rhigh l=13.42u w=0.5u
X633 comparator_slice_0.comparator_body_0.outx.t7 comparator_slice_0.comparator_body_0.m3_m4_diff_0.n1.t62 a_51218_7644# AVDD.t0 sg13_hv_pmos ad=0.85p pd=5.68u as=0.85p ps=5.68u w=2.5u l=1u
X634 resistor_network_0.resistor_leg_1.pt resistor_network_0.p1 AVDD.t3 rhigh l=13.42u w=0.5u
X635 comparator_slice_1.comparator_body_0.outx.t56 threshold.t14 a_54186_36464# AVSS.t22 sg13_hv_nmos ad=0.85p pd=5.68u as=0.85p ps=5.68u w=2.5u l=1u
X636 comparator_slice_0.comparator_body_0.m3_m4_diff_0.n1.t27 trigger.t22 a_54186_18537# AVSS.t22 sg13_hv_nmos ad=0.85p pd=5.68u as=0.85p ps=5.68u w=2.5u l=1u
X637 AVSS.t37 AVSS.t37 AVDD.t3 rhigh l=13.42u w=0.5u
X638 comparator_slice_0.comparator_body_0.outx.t57 comparator_slice_0.comparator_body_0.m3_m4_diff_0.n1.t86 a_51802_11344# AVDD.t0 sg13_hv_pmos ad=0.85p pd=5.68u as=0.85p ps=5.68u w=2.5u l=1u
X639 a_50902_15044# comparator_slice_0.comparator_body_0.m3_m4_diff_0.n1.t60 AVDD.t149 AVDD.t0 sg13_hv_pmos ad=0.85p pd=5.68u as=0.85p ps=5.68u w=2.5u l=1u
X640 a_50902_41127# comparator_slice_1.comparator_body_0.m3_m4_diff_0.n1.t12 comparator_slice_1.comparator_body_0.m3_m4_diff_0.n1.t13 AVDD.t4 sg13_hv_pmos ad=0.85p pd=5.68u as=0.85p ps=5.68u w=2.5u l=1u
X641 AVSS.t154 AVSS.t155 AVDD.t3 rhigh l=13.42u w=0.5u
X642 resistor_network_0.p1 resistor_network_0.resistor_leg_1.pt AVDD.t3 rhigh l=13.42u w=0.5u
X643 comparator_slice_1.comparator_body_0.mref_m5_diff_0.tail.t90 ibias1.t62 a_57082_41013# AVSS.t166 sg13_hv_nmos ad=0.85p pd=5.68u as=0.85p ps=5.68u w=2.5u l=1u
X644 vctrl.t27 resistor_network_0.resistor_leg_0.p2 AVDD.t3 rhigh l=13.42u w=0.5u
X645 ibias0.t15 ibias0.t14 a_57666_20260# AVSS.t59 sg13_hv_nmos ad=0.85p pd=5.68u as=0.85p ps=5.68u w=2.5u l=1u
X646 a_50318_28967# comparator_slice_1.comparator_body_0.m3_m4_diff_0.n1.t38 comparator_slice_1.comparator_body_0.outx.t5 AVDD.t4 sg13_hv_pmos ad=0.85p pd=5.68u as=0.85p ps=5.68u w=2.5u l=1u
X647 comparator_slice_1.comparator_body_0.mref_m5_diff_0.tail.t66 ibias1.t44 a_57082_36017# AVSS.t53 sg13_hv_nmos ad=0.85p pd=5.68u as=0.85p ps=5.68u w=2.5u l=1u
X648 ibias0.t13 ibias0.t12 a_57666_15264# AVSS.t59 sg13_hv_nmos ad=0.85p pd=5.68u as=0.85p ps=5.68u w=2.5u l=1u
X649 comparator_slice_0.comparator_body_0.outx.t14 comparator_slice_0.comparator_body_0.m3_m4_diff_0.n1.t84 a_51218_19934# AVDD.t0 sg13_hv_pmos ad=0.85p pd=5.68u as=0.85p ps=5.68u w=2.5u l=1u
X650 comparator_slice_0.comparator_body_0.mref_m5_diff_0.tail.t35 ibias0.t8 a_57666_4082# AVSS.t103 sg13_hv_nmos ad=0.85p pd=5.68u as=0.85p ps=5.68u w=2.5u l=1u
X651 a_53873_22687# trigger.t29 comparator_slice_0.comparator_body_0.mref_m5_diff_0.tail.t16 AVSS.t23 sg13_hv_nmos ad=0.85p pd=5.68u as=0.85p ps=5.68u w=2.5u l=1u
X652 resistor_network_0.p1 resistor_network_0.resistor_leg_0.pt AVDD.t3 rhigh l=13.42u w=0.5u
X653 a_53873_6544# trigger.t5 comparator_slice_0.comparator_body_0.mref_m5_diff_0.tail.t6 AVSS.t31 sg13_hv_nmos ad=0.85p pd=5.68u as=0.85p ps=5.68u w=2.5u l=1u
X654 AVDD.t39 comparator_slice_1.comparator_body_0.m3_m4_diff_0.n1.t40 a_51218_44827# AVDD.t4 sg13_hv_pmos ad=0.85p pd=5.68u as=0.85p ps=5.68u w=2.5u l=1u
X655 AVDD.t78 comparator_slice_0.comparator_body_0.m3_m4_diff_0.n1.t84 a_51218_18744# AVDD.t0 sg13_hv_pmos ad=0.85p pd=5.68u as=0.85p ps=5.68u w=2.5u l=1u
X656 AVSS.t111 ibias0.t60 a_57666_7652# AVSS.t103 sg13_hv_nmos ad=0.85p pd=5.68u as=0.85p ps=5.68u w=2.5u l=1u
X657 AVSS.t33 AVSS.t34 AVDD.t3 rhigh l=13.42u w=0.5u
X658 a_50902_36237# comparator_slice_1.comparator_body_0.m3_m4_diff_0.n1.t24 comparator_slice_1.comparator_body_0.m3_m4_diff_0.n1.t25 AVDD.t4 sg13_hv_pmos ad=0.85p pd=5.68u as=0.85p ps=5.68u w=2.5u l=1u
X659 AVSS.t37 AVSS.t37 AVDD.t3 rhigh l=13.42u w=0.5u
X660 comparator_slice_1.comparator_body_0.outx.t11 comparator_slice_1.comparator_body_0.m3_m4_diff_0.n1.t8 a_51802_32537# AVDD.t4 sg13_hv_pmos ad=0.85p pd=5.68u as=0.85p ps=5.68u w=2.5u l=1u
X661 comparator_slice_0.comparator_body_0.mref_m5_diff_0.tail.t65 vctrl.t48 a_54186_14817# AVSS.t22 sg13_hv_nmos ad=0.85p pd=5.68u as=0.85p ps=5.68u w=2.5u l=1u
X662 AVSS.t15 AVSS.t15 AVDD.t3 rhigh l=13.42u w=0.5u
X663 AVSS.t7 AVSS.t8 AVDD.t3 rhigh l=13.42u w=0.5u
X664 AVDD.t14 comparator_slice_0.comparator_body_0.m3_m4_diff_0.n1.t70 a_51218_4074# AVDD.t0 sg13_hv_pmos ad=0.85p pd=5.68u as=0.85p ps=5.68u w=2.5u l=1u
X665 a_53289_44737# threshold.t27 comparator_slice_1.comparator_body_0.mref_m5_diff_0.tail.t62 AVSS.t137 sg13_hv_nmos ad=0.85p pd=5.68u as=0.85p ps=5.68u w=2.5u l=1u
X666 a_56182_10268# ibias0.t36 AVSS.t99 AVSS.t91 sg13_hv_nmos ad=0.85p pd=5.68u as=0.85p ps=5.68u w=2.5u l=1u
X667 comparator_slice_0.comparator_body_0.outx.t8 comparator_slice_0.comparator_body_0.m3_m4_diff_0.n1.t78 a_51218_15044# AVDD.t0 sg13_hv_pmos ad=0.85p pd=5.68u as=0.85p ps=5.68u w=2.5u l=1u
X668 a_50318_18744# comparator_slice_0.comparator_body_0.m3_m4_diff_0.n1.t52 comparator_slice_0.comparator_body_0.m3_m4_diff_0.n1.t53 AVDD.t0 sg13_hv_pmos ad=0.85p pd=5.68u as=0.85p ps=5.68u w=2.5u l=1u
X669 AVSS.t6 AVSS.t6 AVDD.t3 rhigh l=13.42u w=0.5u
X670 comparator_slice_1.comparator_body_0.outx.t42 threshold.t0 a_54772_27354# AVSS.t24 sg13_hv_nmos ad=0.85p pd=5.68u as=0.85p ps=5.68u w=2.5u l=1u
X671 resistor_network_0.resistor_leg_1.pt vctrl.t28 AVDD.t3 rhigh l=13.42u w=0.5u
X672 comparator_slice_0.comparator_body_0.m3_m4_diff_0.n1.t14 trigger.t12 a_54772_11915# AVSS.t28 sg13_hv_nmos ad=0.85p pd=5.68u as=0.85p ps=5.68u w=2.5u l=1u
X673 a_50902_32537# comparator_slice_1.comparator_body_0.m3_m4_diff_0.n1.t44 AVDD.t113 AVDD.t4 sg13_hv_pmos ad=0.85p pd=5.68u as=0.85p ps=5.68u w=2.5u l=1u
X674 AVSS.t213 ibias1.t38 a_57666_34827# AVSS.t59 sg13_hv_nmos ad=0.85p pd=5.68u as=0.85p ps=5.68u w=2.5u l=1u
X675 a_53289_10675# trigger.t11 comparator_slice_0.comparator_body_0.m3_m4_diff_0.n1.t31 AVSS.t29 sg13_hv_nmos ad=0.85p pd=5.68u as=0.85p ps=5.68u w=2.5u l=1u
X676 a_53289_13155# trigger.t15 comparator_slice_0.comparator_body_0.m3_m4_diff_0.n1.t7 AVSS.t21 sg13_hv_nmos ad=0.85p pd=5.68u as=0.85p ps=5.68u w=2.5u l=1u
X677 a_53289_17297# vctrl.t53 comparator_slice_0.comparator_body_0.outx.t49 AVSS.t21 sg13_hv_nmos ad=0.85p pd=5.68u as=0.85p ps=5.68u w=2.5u l=1u
X678 AVSS.t20 AVSS.t20 AVDD.t3 rhigh l=13.42u w=0.5u
X679 AVSS.t105 ibias0.t28 a_57082_10268# AVSS.t102 sg13_hv_nmos ad=0.85p pd=5.68u as=0.85p ps=5.68u w=2.5u l=1u
X680 a_56182_47199# ibias1.t42 ibias1.t43 AVSS.t163 sg13_hv_nmos ad=0.85p pd=5.68u as=0.85p ps=5.68u w=2.5u l=1u
X681 AVDD.t81 comparator_slice_0.comparator_body_0.m3_m4_diff_0.n1.t72 a_51802_22314# AVDD.t0 sg13_hv_pmos ad=0.85p pd=5.68u as=0.85p ps=5.68u w=2.5u l=1u
X682 AVDD.t70 comparator_slice_1.comparator_body_0.m3_m4_diff_0.n1.t26 a_51218_39937# AVDD.t4 sg13_hv_pmos ad=0.85p pd=5.68u as=0.85p ps=5.68u w=2.5u l=1u
X683 a_50318_6454# comparator_slice_0.comparator_body_0.m3_m4_diff_0.n1.t94 AVDD.t84 AVDD.t0 sg13_hv_pmos ad=0.85p pd=5.68u as=0.85p ps=5.68u w=2.5u l=1u
X684 comparator_slice_1.comparator_body_0.mref_m5_diff_0.tail.t61 threshold.t26 a_54186_44737# AVSS.t138 sg13_hv_nmos ad=0.85p pd=5.68u as=0.85p ps=5.68u w=2.5u l=1u
X685 resistor_network_0.resistor_leg_2.p1 resistor_network_0.p1 AVDD.t3 rhigh l=13.42u w=0.5u
X686 a_56182_19070# ibias0.t26 ibias0.t27 AVSS.t55 sg13_hv_nmos ad=0.85p pd=5.68u as=0.85p ps=5.68u w=2.5u l=1u
X687 resistor_network_0.resistor_leg_3.p1 AVDD.t25 AVDD.t3 rhigh l=13.42u w=0.5u
X688 comparator_slice_0.comparator_body_0.mref_m5_diff_0.tail.t29 trigger.t0 a_54772_4064# AVSS.t32 sg13_hv_nmos ad=0.85p pd=5.68u as=0.85p ps=5.68u w=2.5u l=1u
X689 comparator_slice_1.comparator_body_0.m3_m4_diff_0.n1.t41 comparator_slice_1.comparator_body_0.m3_m4_diff_0.n1.t40 a_51218_44827# AVDD.t4 sg13_hv_pmos ad=0.85p pd=5.68u as=0.85p ps=5.68u w=2.5u l=1u
X690 ibias1.t29 ibias1.t28 a_57082_47199# AVSS.t166 sg13_hv_nmos ad=0.85p pd=5.68u as=0.85p ps=5.68u w=2.5u l=1u
X691 a_56766_33637# ibias1.t14 ibias1.t15 AVSS.t57 sg13_hv_nmos ad=0.85p pd=5.68u as=0.85p ps=5.68u w=2.5u l=1u
X692 comparator_slice_0.comparator_body_0.m3_m4_diff_0.n1.t73 comparator_slice_0.comparator_body_0.m3_m4_diff_0.n1.t72 a_51802_22314# AVDD.t0 sg13_hv_pmos ad=0.85p pd=5.68u as=0.85p ps=5.68u w=2.5u l=1u
X693 AVDD.t89 comparator_slice_0.comparator_body_0.m3_m4_diff_0.n1.t80 a_51802_5264# AVDD.t0 sg13_hv_pmos ad=0.85p pd=5.68u as=0.85p ps=5.68u w=2.5u l=1u
X694 AVSS.t69 ibias0.t14 a_57666_19070# AVSS.t59 sg13_hv_nmos ad=0.85p pd=5.68u as=0.85p ps=5.68u w=2.5u l=1u
X695 comparator_slice_0.comparator_body_0.m3_m4_diff_0.n1.t5 trigger.t10 a_54186_10675# AVSS.t30 sg13_hv_nmos ad=0.85p pd=5.68u as=0.85p ps=5.68u w=2.5u l=1u
X696 comparator_slice_0.comparator_body_0.m3_m4_diff_0.n1.t22 trigger.t14 a_54186_13155# AVSS.t22 sg13_hv_nmos ad=0.85p pd=5.68u as=0.85p ps=5.68u w=2.5u l=1u
X697 comparator_slice_0.comparator_body_0.outx.t22 vctrl.t48 a_54186_14817# AVSS.t22 sg13_hv_nmos ad=0.85p pd=5.68u as=0.85p ps=5.68u w=2.5u l=1u
X698 comparator_slice_0.comparator_body_0.outx.t29 vctrl.t52 a_54186_17297# AVSS.t22 sg13_hv_nmos ad=0.85p pd=5.68u as=0.85p ps=5.68u w=2.5u l=1u
X699 AVSS.t6 AVSS.t6 AVDD.t3 rhigh l=13.42u w=0.5u
X700 AVDD.t125 comparator_slice_1.comparator_body_0.m3_m4_diff_0.n1.t0 a_51218_36237# AVDD.t4 sg13_hv_pmos ad=0.85p pd=5.68u as=0.85p ps=5.68u w=2.5u l=1u
X701 a_50318_10154# comparator_slice_0.comparator_body_0.m3_m4_diff_0.n1.t66 AVDD.t43 AVDD.t0 sg13_hv_pmos ad=0.85p pd=5.68u as=0.85p ps=5.68u w=2.5u l=1u
X702 comparator_slice_1.comparator_body_0.outx.t52 threshold.t28 a_54772_45977# AVSS.t136 sg13_hv_nmos ad=0.85p pd=5.68u as=0.85p ps=5.68u w=2.5u l=1u
X703 comparator_slice_1.comparator_body_0.outx.t47 threshold.t24 a_54772_43497# AVSS.t136 sg13_hv_nmos ad=0.85p pd=5.68u as=0.85p ps=5.68u w=2.5u l=1u
X704 ibias0.t3 ibias0.t2 a_57082_19070# AVSS.t53 sg13_hv_nmos ad=0.85p pd=5.68u as=0.85p ps=5.68u w=2.5u l=1u
X705 a_56766_12648# ibias0.t56 AVSS.t88 AVSS.t95 sg13_hv_nmos ad=0.85p pd=5.68u as=0.85p ps=5.68u w=2.5u l=1u
X706 a_53873_9435# trigger.t9 comparator_slice_0.comparator_body_0.m3_m4_diff_0.n1.t10 AVSS.t31 sg13_hv_nmos ad=0.85p pd=5.68u as=0.85p ps=5.68u w=2.5u l=1u
X707 a_56766_46009# ibias1.t26 AVSS.t171 AVSS.t165 sg13_hv_nmos ad=0.85p pd=5.68u as=0.85p ps=5.68u w=2.5u l=1u
X708 a_50902_4074# comparator_slice_0.comparator_body_0.m3_m4_diff_0.n1.t76 comparator_slice_0.comparator_body_0.outx.t11 AVDD.t0 sg13_hv_pmos ad=0.85p pd=5.68u as=0.85p ps=5.68u w=2.5u l=1u
X709 AVSS.t16 AVSS.t16 AVDD.t3 rhigh l=13.42u w=0.5u
X710 a_50902_43637# comparator_slice_1.comparator_body_0.m3_m4_diff_0.n1.t50 AVDD.t95 AVDD.t4 sg13_hv_pmos ad=0.85p pd=5.68u as=0.85p ps=5.68u w=2.5u l=1u
X711 comparator_slice_1.comparator_body_0.mref_m5_diff_0.tail.t68 ibias1.t0 a_57666_39823# AVSS.t191 sg13_hv_nmos ad=0.85p pd=5.68u as=0.85p ps=5.68u w=2.5u l=1u
X712 AVDD.t109 comparator_slice_0.comparator_body_0.m3_m4_diff_0.n1.t58 a_51802_13854# AVDD.t0 sg13_hv_pmos ad=0.85p pd=5.68u as=0.85p ps=5.68u w=2.5u l=1u
X713 AVDD.t64 comparator_slice_0.comparator_body_0.m3_m4_diff_0.n1.t92 a_51802_17424# AVDD.t0 sg13_hv_pmos ad=0.85p pd=5.68u as=0.85p ps=5.68u w=2.5u l=1u
X714 a_50902_47207# comparator_slice_1.comparator_body_0.m3_m4_diff_0.n1.t34 AVDD.t35 AVDD.t4 sg13_hv_pmos ad=0.85p pd=5.68u as=0.85p ps=5.68u w=2.5u l=1u
X715 comparator_slice_1.comparator_body_0.mref_m5_diff_0.tail.t67 ibias1.t38 a_57666_34827# AVSS.t59 sg13_hv_nmos ad=0.85p pd=5.68u as=0.85p ps=5.68u w=2.5u l=1u
X716 comparator_slice_0.comparator_body_0.mref_m5_diff_0.tail.t14 trigger.t12 a_54772_11915# AVSS.t28 sg13_hv_nmos ad=0.85p pd=5.68u as=0.85p ps=5.68u w=2.5u l=1u
X717 AVSS.t37 AVSS.t37 AVDD.t3 rhigh l=13.42u w=0.5u
X718 a_56766_44819# ibias1.t2 AVSS.t173 AVSS.t165 sg13_hv_nmos ad=0.85p pd=5.68u as=0.85p ps=5.68u w=2.5u l=1u
X719 a_56182_10268# ibias0.t36 comparator_slice_0.comparator_body_0.mref_m5_diff_0.tail.t33 AVSS.t91 sg13_hv_nmos ad=0.85p pd=5.68u as=0.85p ps=5.68u w=2.5u l=1u
X720 a_56182_6462# ibias0.t24 AVSS.t114 AVSS.t91 sg13_hv_nmos ad=0.85p pd=5.68u as=0.85p ps=5.68u w=2.5u l=1u
X721 resistor_network_0.p1 resistor_network_0.resistor_leg_1.pt AVDD.t3 rhigh l=13.42u w=0.5u
X722 a_50902_7644# comparator_slice_0.comparator_body_0.m3_m4_diff_0.n1.t54 AVDD.t85 AVDD.t0 sg13_hv_pmos ad=0.85p pd=5.68u as=0.85p ps=5.68u w=2.5u l=1u
X723 a_56766_5272# ibias0.t58 AVSS.t119 AVSS.t93 sg13_hv_nmos ad=0.85p pd=5.68u as=0.85p ps=5.68u w=2.5u l=1u
X724 comparator_slice_0.comparator_body_0.m3_m4_diff_0.n1.t93 comparator_slice_0.comparator_body_0.m3_m4_diff_0.n1.t92 a_51802_17424# AVDD.t0 sg13_hv_pmos ad=0.85p pd=5.68u as=0.85p ps=5.68u w=2.5u l=1u
X725 a_50902_47207# comparator_slice_1.comparator_body_0.m3_m4_diff_0.n1.t34 comparator_slice_1.comparator_body_0.outx.t6 AVDD.t4 sg13_hv_pmos ad=0.85p pd=5.68u as=0.85p ps=5.68u w=2.5u l=1u
X726 a_53873_5304# vctrl.t35 comparator_slice_0.comparator_body_0.mref_m5_diff_0.tail.t85 AVSS.t31 sg13_hv_nmos ad=0.85p pd=5.68u as=0.85p ps=5.68u w=2.5u l=1u
X727 comparator_slice_0.comparator_body_0.outx.t23 vctrl.t50 a_54772_16057# AVSS.t24 sg13_hv_nmos ad=0.85p pd=5.68u as=0.85p ps=5.68u w=2.5u l=1u
X728 comparator_slice_0.comparator_body_0.outx.t30 vctrl.t54 a_54772_18537# AVSS.t24 sg13_hv_nmos ad=0.85p pd=5.68u as=0.85p ps=5.68u w=2.5u l=1u
X729 a_50902_13854# comparator_slice_0.comparator_body_0.m3_m4_diff_0.n1.t60 comparator_slice_0.comparator_body_0.outx.t63 AVDD.t0 sg13_hv_pmos ad=0.85p pd=5.68u as=0.85p ps=5.68u w=2.5u l=1u
X730 a_50902_39937# comparator_slice_1.comparator_body_0.m3_m4_diff_0.n1.t56 comparator_slice_1.comparator_body_0.outx.t3 AVDD.t4 sg13_hv_pmos ad=0.85p pd=5.68u as=0.85p ps=5.68u w=2.5u l=1u
X731 comparator_slice_0.comparator_body_0.mref_m5_diff_0.tail.t39 ibias0.t28 a_57082_10268# AVSS.t102 sg13_hv_nmos ad=0.85p pd=5.68u as=0.85p ps=5.68u w=2.5u l=1u
X732 comparator_slice_0.comparator_body_0.m3_m4_diff_0.n1.t49 comparator_slice_0.comparator_body_0.m3_m4_diff_0.n1.t48 a_51802_10154# AVDD.t0 sg13_hv_pmos ad=0.85p pd=5.68u as=0.85p ps=5.68u w=2.5u l=1u
X733 a_53873_39366# resistor_network_0.p1 comparator_slice_1.comparator_body_0.m3_m4_diff_0.n1.t88 AVSS.t139 sg13_hv_nmos ad=0.85p pd=5.68u as=0.85p ps=5.68u w=2.5u l=1u
X734 a_53873_32744# threshold.t9 comparator_slice_1.comparator_body_0.outx.t48 AVSS.t23 sg13_hv_nmos ad=0.85p pd=5.68u as=0.85p ps=5.68u w=2.5u l=1u
X735 resistor_network_0.resistor_leg_1.pt resistor_network_0.p1 AVDD.t3 rhigh l=13.42u w=0.5u
X736 a_50318_31347# comparator_slice_1.comparator_body_0.m3_m4_diff_0.n1.t30 comparator_slice_1.comparator_body_0.outx.t23 AVDD.t4 sg13_hv_pmos ad=0.85p pd=5.68u as=0.85p ps=5.68u w=2.5u l=1u
X737 a_56182_47199# ibias1.t42 AVSS.t164 AVSS.t163 sg13_hv_nmos ad=0.85p pd=5.68u as=0.85p ps=5.68u w=2.5u l=1u
X738 a_56182_38633# ibias1.t50 AVSS.t198 AVSS.t55 sg13_hv_nmos ad=0.85p pd=5.68u as=0.85p ps=5.68u w=2.5u l=1u
X739 a_56766_32211# ibias1.t24 AVSS.t217 AVSS.t57 sg13_hv_nmos ad=0.85p pd=5.68u as=0.85p ps=5.68u w=2.5u l=1u
X740 a_53873_23927# vctrl.t63 comparator_slice_0.comparator_body_0.outx.t45 AVSS.t23 sg13_hv_nmos ad=0.85p pd=5.68u as=0.85p ps=5.68u w=2.5u l=1u
X741 ibias0.t17 ibias0.t16 a_57666_12648# AVSS.t96 sg13_hv_nmos ad=0.85p pd=5.68u as=0.85p ps=5.68u w=2.5u l=1u
X742 a_53873_21447# vctrl.t59 comparator_slice_0.comparator_body_0.outx.t28 AVSS.t23 sg13_hv_nmos ad=0.85p pd=5.68u as=0.85p ps=5.68u w=2.5u l=1u
X743 comparator_slice_1.comparator_body_0.outx.t55 threshold.t6 a_54186_31074# AVSS.t22 sg13_hv_nmos ad=0.85p pd=5.68u as=0.85p ps=5.68u w=2.5u l=1u
X744 AVSS.t232 AVSS.t233 AVDD.t3 rhigh l=13.42u w=0.5u
X745 comparator_slice_1.comparator_body_0.m3_m4_diff_0.n1.t92 resistor_network_0.p1 a_54772_41846# AVSS.t136 sg13_hv_nmos ad=0.85p pd=5.68u as=0.85p ps=5.68u w=2.5u l=1u
X746 a_53873_5304# vctrl.t35 comparator_slice_0.comparator_body_0.outx.t42 AVSS.t31 sg13_hv_nmos ad=0.85p pd=5.68u as=0.85p ps=5.68u w=2.5u l=1u
X747 resistor_network_0.p1 resistor_network_0.resistor_leg_0.pt AVDD.t3 rhigh l=13.42u w=0.5u
X748 a_50902_38747# comparator_slice_1.comparator_body_0.m3_m4_diff_0.n1.t56 AVDD.t22 AVDD.t4 sg13_hv_pmos ad=0.85p pd=5.68u as=0.85p ps=5.68u w=2.5u l=1u
X749 AVSS.t164 ibias1.t28 a_57082_47199# AVSS.t166 sg13_hv_nmos ad=0.85p pd=5.68u as=0.85p ps=5.68u w=2.5u l=1u
X750 AVSS.t196 ibias1.t6 a_57082_38633# AVSS.t53 sg13_hv_nmos ad=0.85p pd=5.68u as=0.85p ps=5.68u w=2.5u l=1u
X751 comparator_slice_0.comparator_body_0.mref_m5_diff_0.tail.t25 trigger.t4 a_54772_6544# AVSS.t32 sg13_hv_nmos ad=0.85p pd=5.68u as=0.85p ps=5.68u w=2.5u l=1u
X752 a_56766_32211# ibias1.t24 comparator_slice_1.comparator_body_0.mref_m5_diff_0.tail.t93 AVSS.t57 sg13_hv_nmos ad=0.85p pd=5.68u as=0.85p ps=5.68u w=2.5u l=1u
X753 comparator_slice_0.comparator_body_0.mref_m5_diff_0.tail.t62 ibias0.t48 a_57082_7652# AVSS.t102 sg13_hv_nmos ad=0.85p pd=5.68u as=0.85p ps=5.68u w=2.5u l=1u
X754 a_62320_13955# a_60176_13955# reset_b AVSS.t3 sg13_hv_nmos ad=0.85p pd=5.68u as=0.85p ps=5.68u w=2.5u l=1u
X755 AVSS.t37 AVSS.t37 AVDD.t3 rhigh l=13.42u w=0.5u
X756 AVSS.t14 AVSS.t14 AVDD.t3 rhigh l=13.42u w=0.5u
X757 a_50318_21124# comparator_slice_0.comparator_body_0.m3_m4_diff_0.n1.t50 AVDD.t134 AVDD.t0 sg13_hv_pmos ad=0.85p pd=5.68u as=0.85p ps=5.68u w=2.5u l=1u
X758 a_50902_35047# comparator_slice_1.comparator_body_0.m3_m4_diff_0.n1.t48 comparator_slice_1.comparator_body_0.outx.t25 AVDD.t4 sg13_hv_pmos ad=0.85p pd=5.68u as=0.85p ps=5.68u w=2.5u l=1u
X759 AVSS.t6 AVSS.t6 AVDD.t3 rhigh l=13.42u w=0.5u
X760 AVDD.t53 comparator_slice_1.comparator_body_0.m3_m4_diff_0.n1.t8 a_51802_31347# AVDD.t4 sg13_hv_pmos ad=0.85p pd=5.68u as=0.85p ps=5.68u w=2.5u l=1u
X761 AVSS.t11 AVSS.t11 AVDD.t3 rhigh l=13.42u w=0.5u
X762 a_53289_27354# resistor_network_0.p1 comparator_slice_1.comparator_body_0.mref_m5_diff_0.tail.t27 AVSS.t21 sg13_hv_nmos ad=0.85p pd=5.68u as=0.85p ps=5.68u w=2.5u l=1u
X763 AVSS.t1 AVSS.t2 AVDD.t3 rhigh l=13.42u w=0.5u
X764 a_53289_11915# vctrl.t45 comparator_slice_0.comparator_body_0.mref_m5_diff_0.tail.t93 AVSS.t25 sg13_hv_nmos ad=0.85p pd=5.68u as=0.85p ps=5.68u w=2.5u l=1u
X765 a_61028_13955# comparator_slice_0.comparator_body_0.outx.t66 a_60176_13955# AVSS.t40 sg13_hv_nmos ad=0.85p pd=5.68u as=0.85p ps=5.68u w=2.5u l=1u
X766 a_56766_20260# ibias0.t54 AVSS.t65 AVSS.t57 sg13_hv_nmos ad=0.85p pd=5.68u as=0.85p ps=5.68u w=2.5u l=1u
X767 a_50318_21124# comparator_slice_0.comparator_body_0.m3_m4_diff_0.n1.t50 comparator_slice_0.comparator_body_0.m3_m4_diff_0.n1.t51 AVDD.t0 sg13_hv_pmos ad=0.85p pd=5.68u as=0.85p ps=5.68u w=2.5u l=1u
X768 a_56766_15264# ibias0.t30 AVSS.t80 AVSS.t57 sg13_hv_nmos ad=0.85p pd=5.68u as=0.85p ps=5.68u w=2.5u l=1u
X769 a_50318_8964# comparator_slice_0.comparator_body_0.m3_m4_diff_0.n1.t66 comparator_slice_0.comparator_body_0.m3_m4_diff_0.n1.t67 AVDD.t0 sg13_hv_pmos ad=0.85p pd=5.68u as=0.85p ps=5.68u w=2.5u l=1u
X770 a_53873_23927# vctrl.t63 comparator_slice_0.comparator_body_0.mref_m5_diff_0.tail.t88 AVSS.t23 sg13_hv_nmos ad=0.85p pd=5.68u as=0.85p ps=5.68u w=2.5u l=1u
X771 AVDD.t33 comparator_slice_0.comparator_body_0.m3_m4_diff_0.n1.t62 a_51218_6454# AVDD.t0 sg13_hv_pmos ad=0.85p pd=5.68u as=0.85p ps=5.68u w=2.5u l=1u
X772 resistor_network_0.resistor_leg_2.p1 resistor_network_0.p1 AVDD.t3 rhigh l=13.42u w=0.5u
X773 AVSS.t20 AVSS.t20 AVDD.t3 rhigh l=13.42u w=0.5u
X774 a_56182_9078# ibias0.t36 AVSS.t94 AVSS.t91 sg13_hv_nmos ad=0.85p pd=5.68u as=0.85p ps=5.68u w=2.5u l=1u
X775 a_53873_7784# vctrl.t39 comparator_slice_0.comparator_body_0.mref_m5_diff_0.tail.t87 AVSS.t31 sg13_hv_nmos ad=0.85p pd=5.68u as=0.85p ps=5.68u w=2.5u l=1u
X776 resistor_network_0.resistor_leg_3.p1 AVDD.t25 AVDD.t3 rhigh l=13.42u w=0.5u
X777 comparator_slice_1.comparator_body_0.mref_m5_diff_0.tail.t13 resistor_network_0.p1 a_54186_27354# AVSS.t22 sg13_hv_nmos ad=0.85p pd=5.68u as=0.85p ps=5.68u w=2.5u l=1u
X778 a_62934_39143# a_60176_37898# AVDD1V2 AVDD1V2 sg13_hv_pmos ad=0.85p pd=5.68u as=0.85p ps=5.68u w=2.5u l=1u
X779 AVSS.t121 ibias0.t20 a_57082_4082# AVSS.t102 sg13_hv_nmos ad=0.85p pd=5.68u as=0.85p ps=5.68u w=2.5u l=1u
X780 comparator_slice_0.comparator_body_0.mref_m5_diff_0.tail.t80 vctrl.t44 a_54186_11915# AVSS.t26 sg13_hv_nmos ad=0.85p pd=5.68u as=0.85p ps=5.68u w=2.5u l=1u
X781 a_50318_42317# comparator_slice_1.comparator_body_0.m3_m4_diff_0.n1.t52 AVDD.t6 AVDD.t4 sg13_hv_pmos ad=0.85p pd=5.68u as=0.85p ps=5.68u w=2.5u l=1u
X782 comparator_slice_1.comparator_body_0.mref_m5_diff_0.tail.t21 resistor_network_0.p1 a_54772_44737# AVSS.t136 sg13_hv_nmos ad=0.85p pd=5.68u as=0.85p ps=5.68u w=2.5u l=1u
X783 AVSS.t0 AVSS.t0 AVDD.t3 rhigh l=13.42u w=0.5u
X784 a_56182_21450# ibias0.t34 ibias0.t35 AVSS.t55 sg13_hv_nmos ad=0.85p pd=5.68u as=0.85p ps=5.68u w=2.5u l=1u
X785 AVSS.t6 AVSS.t6 AVDD.t3 rhigh l=13.42u w=0.5u
X786 a_53289_45977# resistor_network_0.p1 comparator_slice_1.comparator_body_0.mref_m5_diff_0.tail.t14 AVSS.t137 sg13_hv_nmos ad=0.85p pd=5.68u as=0.85p ps=5.68u w=2.5u l=1u
X787 a_53289_43497# resistor_network_0.p1 comparator_slice_1.comparator_body_0.mref_m5_diff_0.tail.t6 AVSS.t137 sg13_hv_nmos ad=0.85p pd=5.68u as=0.85p ps=5.68u w=2.5u l=1u
X788 a_56182_46009# ibias1.t42 comparator_slice_1.comparator_body_0.mref_m5_diff_0.tail.t88 AVSS.t163 sg13_hv_nmos ad=0.85p pd=5.68u as=0.85p ps=5.68u w=2.5u l=1u
X789 vctrl.t17 resistor_network_0.resistor_leg_1.p2 AVDD.t3 rhigh l=13.42u w=0.5u
X790 a_56182_16454# ibias0.t40 ibias0.t41 AVSS.t55 sg13_hv_nmos ad=0.85p pd=5.68u as=0.85p ps=5.68u w=2.5u l=1u
X791 comparator_slice_0.comparator_body_0.outx.t19 comparator_slice_0.comparator_body_0.m3_m4_diff_0.n1.t80 a_51802_4074# AVDD.t0 sg13_hv_pmos ad=0.85p pd=5.68u as=0.85p ps=5.68u w=2.5u l=1u
X792 AVDD.t98 comparator_slice_1.comparator_body_0.m3_m4_diff_0.n1.t60 a_51802_35047# AVDD.t4 sg13_hv_pmos ad=0.85p pd=5.68u as=0.85p ps=5.68u w=2.5u l=1u
X793 a_50318_42317# comparator_slice_1.comparator_body_0.m3_m4_diff_0.n1.t52 comparator_slice_1.comparator_body_0.m3_m4_diff_0.n1.t53 AVDD.t4 sg13_hv_pmos ad=0.85p pd=5.68u as=0.85p ps=5.68u w=2.5u l=1u
X794 comparator_slice_0.comparator_body_0.m3_m4_diff_0.n1.t23 trigger.t8 a_54772_9435# AVSS.t32 sg13_hv_nmos ad=0.85p pd=5.68u as=0.85p ps=5.68u w=2.5u l=1u
X795 comparator_slice_0.comparator_body_0.outx.t6 comparator_slice_0.comparator_body_0.m3_m4_diff_0.n1.t32 a_51218_12534# AVDD.t0 sg13_hv_pmos ad=0.85p pd=5.68u as=0.85p ps=5.68u w=2.5u l=1u
X796 a_50318_16234# comparator_slice_0.comparator_body_0.m3_m4_diff_0.n1.t74 comparator_slice_0.comparator_body_0.m3_m4_diff_0.n1.t75 AVDD.t0 sg13_hv_pmos ad=0.85p pd=5.68u as=0.85p ps=5.68u w=2.5u l=1u
X797 AVSS.t16 AVSS.t16 AVDD.t3 rhigh l=13.42u w=0.5u
X798 comparator_slice_0.comparator_body_0.outx.t34 vctrl.t42 a_54772_10675# AVSS.t32 sg13_hv_nmos ad=0.85p pd=5.68u as=0.85p ps=5.68u w=2.5u l=1u
X799 ibias0.t19 ibias0.t18 a_57082_21450# AVSS.t53 sg13_hv_nmos ad=0.85p pd=5.68u as=0.85p ps=5.68u w=2.5u l=1u
X800 ibias0.t5 ibias0.t4 a_57082_16454# AVSS.t53 sg13_hv_nmos ad=0.85p pd=5.68u as=0.85p ps=5.68u w=2.5u l=1u
X801 a_53289_11915# vctrl.t45 comparator_slice_0.comparator_body_0.outx.t50 AVSS.t25 sg13_hv_nmos ad=0.85p pd=5.68u as=0.85p ps=5.68u w=2.5u l=1u
X802 comparator_slice_1.comparator_body_0.outx.t7 comparator_slice_1.comparator_body_0.m3_m4_diff_0.n1.t40 a_51218_43637# AVDD.t4 sg13_hv_pmos ad=0.85p pd=5.68u as=0.85p ps=5.68u w=2.5u l=1u
X803 comparator_slice_1.comparator_body_0.mref_m5_diff_0.tail.t81 ibias1.t28 a_57082_46009# AVSS.t166 sg13_hv_nmos ad=0.85p pd=5.68u as=0.85p ps=5.68u w=2.5u l=1u
X804 AVDD.t79 comparator_slice_0.comparator_body_0.m3_m4_diff_0.n1.t34 a_51802_7644# AVDD.t0 sg13_hv_pmos ad=0.85p pd=5.68u as=0.85p ps=5.68u w=2.5u l=1u
X805 AVDD.t118 comparator_slice_0.comparator_body_0.m3_m4_diff_0.n1.t56 a_51802_19934# AVDD.t0 sg13_hv_pmos ad=0.85p pd=5.68u as=0.85p ps=5.68u w=2.5u l=1u
X806 a_62904_37326# a_60176_37898# set_b AVSS.t5 sg13_hv_nmos ad=0.85p pd=5.68u as=0.85p ps=5.68u w=2.5u l=1u
X807 resistor_network_0.resistor_leg_0.p2 vctrl.t0 AVDD.t3 rhigh l=13.42u w=0.5u
X808 a_50318_12534# comparator_slice_0.comparator_body_0.m3_m4_diff_0.n1.t38 AVDD.t15 AVDD.t0 sg13_hv_pmos ad=0.85p pd=5.68u as=0.85p ps=5.68u w=2.5u l=1u
X809 comparator_slice_1.comparator_body_0.mref_m5_diff_0.tail.t29 resistor_network_0.p1 a_54186_45977# AVSS.t138 sg13_hv_nmos ad=0.85p pd=5.68u as=0.85p ps=5.68u w=2.5u l=1u
X810 a_50318_37427# comparator_slice_1.comparator_body_0.m3_m4_diff_0.n1.t4 AVDD.t73 AVDD.t4 sg13_hv_pmos ad=0.85p pd=5.68u as=0.85p ps=5.68u w=2.5u l=1u
X811 a_50318_33857# comparator_slice_1.comparator_body_0.m3_m4_diff_0.n1.t22 AVDD.t17 AVDD.t4 sg13_hv_pmos ad=0.85p pd=5.68u as=0.85p ps=5.68u w=2.5u l=1u
X812 comparator_slice_1.comparator_body_0.mref_m5_diff_0.tail.t26 resistor_network_0.p1 a_54186_43497# AVSS.t138 sg13_hv_nmos ad=0.85p pd=5.68u as=0.85p ps=5.68u w=2.5u l=1u
X813 a_53289_16057# trigger.t19 comparator_slice_0.comparator_body_0.mref_m5_diff_0.tail.t13 AVSS.t21 sg13_hv_nmos ad=0.85p pd=5.68u as=0.85p ps=5.68u w=2.5u l=1u
X814 a_53289_18537# trigger.t23 comparator_slice_0.comparator_body_0.mref_m5_diff_0.tail.t4 AVSS.t21 sg13_hv_nmos ad=0.85p pd=5.68u as=0.85p ps=5.68u w=2.5u l=1u
X815 comparator_slice_0.comparator_body_0.mref_m5_diff_0.tail.t69 vctrl.t34 a_54772_5304# AVSS.t32 sg13_hv_nmos ad=0.85p pd=5.68u as=0.85p ps=5.68u w=2.5u l=1u
X816 resistor_network_0.resistor_leg_1.pt resistor_network_0.p1 AVDD.t3 rhigh l=13.42u w=0.5u
X817 a_56766_4082# ibias0.t58 comparator_slice_0.comparator_body_0.mref_m5_diff_0.tail.t55 AVSS.t93 sg13_hv_nmos ad=0.85p pd=5.68u as=0.85p ps=5.68u w=2.5u l=1u
X818 comparator_slice_1.comparator_body_0.mref_m5_diff_0.tail.t46 threshold.t20 a_54772_40606# AVSS.t136 sg13_hv_nmos ad=0.85p pd=5.68u as=0.85p ps=5.68u w=2.5u l=1u
X819 a_62904_37326# a_60176_37898# AVSS.t159 AVSS.t5 sg13_hv_nmos ad=0.85p pd=5.68u as=0.85p ps=5.68u w=2.5u l=1u
X820 a_60444_13955# comparator_slice_0.comparator_body_0.outx.t67 AVSS.t132 AVSS.t131 sg13_hv_nmos ad=0.85p pd=5.68u as=0.85p ps=5.68u w=2.5u l=1u
X821 AVDD.t63 comparator_slice_0.comparator_body_0.m3_m4_diff_0.n1.t92 a_51802_16234# AVDD.t0 sg13_hv_pmos ad=0.85p pd=5.68u as=0.85p ps=5.68u w=2.5u l=1u
X822 ibias1.t39 ibias1.t38 a_57666_33637# AVSS.t59 sg13_hv_nmos ad=0.85p pd=5.68u as=0.85p ps=5.68u w=2.5u l=1u
X823 comparator_slice_0.comparator_body_0.outx.t37 vctrl.t44 a_54186_11915# AVSS.t26 sg13_hv_nmos ad=0.85p pd=5.68u as=0.85p ps=5.68u w=2.5u l=1u
X824 a_50318_37427# comparator_slice_1.comparator_body_0.m3_m4_diff_0.n1.t4 comparator_slice_1.comparator_body_0.m3_m4_diff_0.n1.t5 AVDD.t4 sg13_hv_pmos ad=0.85p pd=5.68u as=0.85p ps=5.68u w=2.5u l=1u
X825 a_56182_9078# ibias0.t36 ibias0.t37 AVSS.t91 sg13_hv_nmos ad=0.85p pd=5.68u as=0.85p ps=5.68u w=2.5u l=1u
X826 a_50318_30157# comparator_slice_1.comparator_body_0.m3_m4_diff_0.n1.t38 comparator_slice_1.comparator_body_0.m3_m4_diff_0.n1.t39 AVDD.t4 sg13_hv_pmos ad=0.85p pd=5.68u as=0.85p ps=5.68u w=2.5u l=1u
X827 comparator_slice_1.comparator_body_0.m3_m4_diff_0.n1.t64 resistor_network_0.p1 a_54772_47217# AVSS.t136 sg13_hv_nmos ad=0.85p pd=5.68u as=0.85p ps=5.68u w=2.5u l=1u
X828 comparator_slice_0.comparator_body_0.outx.t26 vctrl.t34 a_54772_5304# AVSS.t32 sg13_hv_nmos ad=0.85p pd=5.68u as=0.85p ps=5.68u w=2.5u l=1u
X829 AVSS.t15 AVSS.t15 AVDD.t3 rhigh l=13.42u w=0.5u
X830 a_56766_7652# ibias0.t0 AVSS.t92 AVSS.t93 sg13_hv_nmos ad=0.85p pd=5.68u as=0.85p ps=5.68u w=2.5u l=1u
X831 AVSS.t90 ibias0.t16 a_57666_12648# AVSS.t96 sg13_hv_nmos ad=0.85p pd=5.68u as=0.85p ps=5.68u w=2.5u l=1u
X832 comparator_slice_0.comparator_body_0.outx.t40 vctrl.t32 a_54186_4064# AVSS.t30 sg13_hv_nmos ad=0.85p pd=5.68u as=0.85p ps=5.68u w=2.5u l=1u
X833 comparator_slice_1.comparator_body_0.outx.t16 comparator_slice_1.comparator_body_0.m3_m4_diff_0.n1.t26 a_51218_38747# AVDD.t4 sg13_hv_pmos ad=0.85p pd=5.68u as=0.85p ps=5.68u w=2.5u l=1u
X834 AVSS.t169 ibias1.t18 a_57666_46009# AVSS.t167 sg13_hv_nmos ad=0.85p pd=5.68u as=0.85p ps=5.68u w=2.5u l=1u
X835 comparator_slice_0.comparator_body_0.mref_m5_diff_0.tail.t27 trigger.t22 a_54186_18537# AVSS.t22 sg13_hv_nmos ad=0.85p pd=5.68u as=0.85p ps=5.68u w=2.5u l=1u
X836 AVSS.t37 AVSS.t37 AVDD.t3 rhigh l=13.42u w=0.5u
X837 resistor_network_0.resistor_leg_0.p2 vctrl.t3 AVDD.t3 rhigh l=13.42u w=0.5u
X838 comparator_slice_0.comparator_body_0.mref_m5_diff_0.tail.t11 trigger.t18 a_54186_16057# AVSS.t22 sg13_hv_nmos ad=0.85p pd=5.68u as=0.85p ps=5.68u w=2.5u l=1u
X839 a_53873_29834# threshold.t5 comparator_slice_1.comparator_body_0.outx.t51 AVSS.t23 sg13_hv_nmos ad=0.85p pd=5.68u as=0.85p ps=5.68u w=2.5u l=1u
X840 comparator_slice_1.comparator_body_0.mref_m5_diff_0.tail.t0 resistor_network_0.p1 a_54772_47217# AVSS.t136 sg13_hv_nmos ad=0.85p pd=5.68u as=0.85p ps=5.68u w=2.5u l=1u
X841 AVSS.t14 AVSS.t14 AVDD.t3 rhigh l=13.42u w=0.5u
X842 a_50318_28967# comparator_slice_1.comparator_body_0.m3_m4_diff_0.n1.t38 AVDD.t30 AVDD.t4 sg13_hv_pmos ad=0.85p pd=5.68u as=0.85p ps=5.68u w=2.5u l=1u
X843 AVSS.t176 ibias1.t56 a_57666_44819# AVSS.t167 sg13_hv_nmos ad=0.85p pd=5.68u as=0.85p ps=5.68u w=2.5u l=1u
X844 AVDD.t114 comparator_slice_1.comparator_body_0.m3_m4_diff_0.n1.t16 a_51802_46017# AVDD.t4 sg13_hv_pmos ad=0.85p pd=5.68u as=0.85p ps=5.68u w=2.5u l=1u
X845 comparator_slice_1.comparator_body_0.mref_m5_diff_0.tail.t56 threshold.t22 a_54186_41846# AVSS.t138 sg13_hv_nmos ad=0.85p pd=5.68u as=0.85p ps=5.68u w=2.5u l=1u
X846 comparator_slice_1.comparator_body_0.m3_m4_diff_0.n1.t75 resistor_network_0.p1 a_54772_28594# AVSS.t24 sg13_hv_nmos ad=0.85p pd=5.68u as=0.85p ps=5.68u w=2.5u l=1u
X847 vctrl.t12 resistor_network_0.resistor_leg_0.p2 AVDD.t3 rhigh l=13.42u w=0.5u
X848 resistor_network_0.pb resistor_network_0.resistor_leg_1.p2 AVDD.t3 rhigh l=13.42u w=0.5u
X849 comparator_slice_0.comparator_body_0.outx.t46 vctrl.t46 a_54772_13155# AVSS.t28 sg13_hv_nmos ad=0.85p pd=5.68u as=0.85p ps=5.68u w=2.5u l=1u
X850 resistor_network_0.p1 resistor_network_0.resistor_leg_3.p1 AVDD.t3 rhigh l=13.42u w=0.5u
X851 comparator_slice_0.comparator_body_0.m3_m4_diff_0.n1.t9 trigger.t20 a_54772_17297# AVSS.t24 sg13_hv_nmos ad=0.85p pd=5.68u as=0.85p ps=5.68u w=2.5u l=1u
X852 a_53873_33984# resistor_network_0.p1 comparator_slice_1.comparator_body_0.m3_m4_diff_0.n1.t73 AVSS.t23 sg13_hv_nmos ad=0.85p pd=5.68u as=0.85p ps=5.68u w=2.5u l=1u
X853 a_50902_11344# comparator_slice_0.comparator_body_0.m3_m4_diff_0.n1.t64 comparator_slice_0.comparator_body_0.outx.t54 AVDD.t0 sg13_hv_pmos ad=0.85p pd=5.68u as=0.85p ps=5.68u w=2.5u l=1u
X854 a_53873_38126# threshold.t17 comparator_slice_1.comparator_body_0.outx.t32 AVSS.t23 sg13_hv_nmos ad=0.85p pd=5.68u as=0.85p ps=5.68u w=2.5u l=1u
X855 a_56766_29831# ibias1.t46 AVSS.t225 AVSS.t57 sg13_hv_nmos ad=0.85p pd=5.68u as=0.85p ps=5.68u w=2.5u l=1u
X856 AVSS.t11 AVSS.t11 AVDD.t3 rhigh l=13.42u w=0.5u
X857 a_53873_22687# trigger.t29 comparator_slice_0.comparator_body_0.m3_m4_diff_0.n1.t16 AVSS.t23 sg13_hv_nmos ad=0.85p pd=5.68u as=0.85p ps=5.68u w=2.5u l=1u
X858 comparator_slice_0.comparator_body_0.m3_m4_diff_0.n1.t37 comparator_slice_0.comparator_body_0.m3_m4_diff_0.n1.t36 a_51218_8964# AVDD.t0 sg13_hv_pmos ad=0.85p pd=5.68u as=0.85p ps=5.68u w=2.5u l=1u
X859 comparator_slice_1.comparator_body_0.m3_m4_diff_0.n1.t17 comparator_slice_1.comparator_body_0.m3_m4_diff_0.n1.t16 a_51802_46017# AVDD.t4 sg13_hv_pmos ad=0.85p pd=5.68u as=0.85p ps=5.68u w=2.5u l=1u
X860 comparator_slice_1.comparator_body_0.outx.t43 threshold.t20 a_54772_40606# AVSS.t136 sg13_hv_nmos ad=0.85p pd=5.68u as=0.85p ps=5.68u w=2.5u l=1u
X861 a_53290_36464# threshold.t15 comparator_slice_1.comparator_body_0.mref_m5_diff_0.tail.t53 AVSS.t145 sg13_hv_nmos ad=0.85p pd=5.68u as=0.85p ps=5.68u w=2.5u l=1u
X862 AVSS.t204 ibias1.t36 a_57666_32211# AVSS.t59 sg13_hv_nmos ad=0.85p pd=5.68u as=0.85p ps=5.68u w=2.5u l=1u
X863 a_53873_4064# trigger.t1 comparator_slice_0.comparator_body_0.m3_m4_diff_0.n1.t12 AVSS.t31 sg13_hv_nmos ad=0.85p pd=5.68u as=0.85p ps=5.68u w=2.5u l=1u
X864 a_53873_6544# trigger.t5 comparator_slice_0.comparator_body_0.m3_m4_diff_0.n1.t6 AVSS.t31 sg13_hv_nmos ad=0.85p pd=5.68u as=0.85p ps=5.68u w=2.5u l=1u
X865 a_56766_14074# ibias0.t30 comparator_slice_0.comparator_body_0.mref_m5_diff_0.tail.t49 AVSS.t57 sg13_hv_nmos ad=0.85p pd=5.68u as=0.85p ps=5.68u w=2.5u l=1u
X866 a_50318_19934# comparator_slice_0.comparator_body_0.m3_m4_diff_0.n1.t52 comparator_slice_0.comparator_body_0.outx.t55 AVDD.t0 sg13_hv_pmos ad=0.85p pd=5.68u as=0.85p ps=5.68u w=2.5u l=1u
X867 AVDD.t19 comparator_slice_1.comparator_body_0.m3_m4_diff_0.n1.t62 a_51218_30157# AVDD.t4 sg13_hv_pmos ad=0.85p pd=5.68u as=0.85p ps=5.68u w=2.5u l=1u
X868 a_53873_38126# threshold.t17 comparator_slice_1.comparator_body_0.mref_m5_diff_0.tail.t35 AVSS.t23 sg13_hv_nmos ad=0.85p pd=5.68u as=0.85p ps=5.68u w=2.5u l=1u
X869 resistor_network_0.resistor_leg_0.p2 vctrl.t20 AVDD.t3 rhigh l=13.42u w=0.5u
X870 ibias0.t61 ibias0.t60 a_57666_7652# AVSS.t103 sg13_hv_nmos ad=0.85p pd=5.68u as=0.85p ps=5.68u w=2.5u l=1u
X871 AVSS.t35 AVSS.t36 AVDD.t3 rhigh l=13.42u w=0.5u
X872 comparator_slice_0.comparator_body_0.mref_m5_diff_0.tail.t91 vctrl.t38 a_54772_7784# AVSS.t32 sg13_hv_nmos ad=0.85p pd=5.68u as=0.85p ps=5.68u w=2.5u l=1u
X873 AVSS.t14 AVSS.t14 AVDD.t3 rhigh l=13.42u w=0.5u
X874 comparator_slice_1.comparator_body_0.mref_m5_diff_0.tail.t87 ibias1.t36 a_57666_32211# AVSS.t59 sg13_hv_nmos ad=0.85p pd=5.68u as=0.85p ps=5.68u w=2.5u l=1u
X875 AVSS.t0 AVSS.t0 AVDD.t3 rhigh l=13.42u w=0.5u
X876 a_56766_22640# ibias0.t50 AVSS.t56 AVSS.t57 sg13_hv_nmos ad=0.85p pd=5.68u as=0.85p ps=5.68u w=2.5u l=1u
X877 a_53289_44737# threshold.t27 comparator_slice_1.comparator_body_0.outx.t59 AVSS.t137 sg13_hv_nmos ad=0.85p pd=5.68u as=0.85p ps=5.68u w=2.5u l=1u
X878 a_56766_17644# ibias0.t22 AVSS.t71 AVSS.t57 sg13_hv_nmos ad=0.85p pd=5.68u as=0.85p ps=5.68u w=2.5u l=1u
X879 a_50318_18744# comparator_slice_0.comparator_body_0.m3_m4_diff_0.n1.t52 AVDD.t117 AVDD.t0 sg13_hv_pmos ad=0.85p pd=5.68u as=0.85p ps=5.68u w=2.5u l=1u
X880 AVSS.t6 AVSS.t6 AVDD.t3 rhigh l=13.42u w=0.5u
X881 a_50318_44827# comparator_slice_1.comparator_body_0.m3_m4_diff_0.n1.t28 AVDD.t59 AVDD.t4 sg13_hv_pmos ad=0.85p pd=5.68u as=0.85p ps=5.68u w=2.5u l=1u
X882 a_50902_32537# comparator_slice_1.comparator_body_0.m3_m4_diff_0.n1.t44 comparator_slice_1.comparator_body_0.outx.t61 AVDD.t4 sg13_hv_pmos ad=0.85p pd=5.68u as=0.85p ps=5.68u w=2.5u l=1u
X883 comparator_slice_0.comparator_body_0.outx.t32 vctrl.t36 a_54186_6544# AVSS.t30 sg13_hv_nmos ad=0.85p pd=5.68u as=0.85p ps=5.68u w=2.5u l=1u
X884 resistor_network_0.resistor_leg_1.p2 resistor_network_0.pb AVDD.t3 rhigh l=13.42u w=0.5u
X885 a_56182_20260# ibias0.t26 comparator_slice_0.comparator_body_0.mref_m5_diff_0.tail.t40 AVSS.t55 sg13_hv_nmos ad=0.85p pd=5.68u as=0.85p ps=5.68u w=2.5u l=1u
X886 a_53289_10675# trigger.t11 comparator_slice_0.comparator_body_0.mref_m5_diff_0.tail.t31 AVSS.t29 sg13_hv_nmos ad=0.85p pd=5.68u as=0.85p ps=5.68u w=2.5u l=1u
X887 a_56182_15264# ibias0.t46 comparator_slice_0.comparator_body_0.mref_m5_diff_0.tail.t44 AVSS.t55 sg13_hv_nmos ad=0.85p pd=5.68u as=0.85p ps=5.68u w=2.5u l=1u
X888 resistor_network_0.resistor_leg_1.pt resistor_network_0.p1 AVDD.t3 rhigh l=13.42u w=0.5u
X889 comparator_slice_1.comparator_body_0.m3_m4_diff_0.n1.t61 comparator_slice_1.comparator_body_0.m3_m4_diff_0.n1.t60 a_51802_33857# AVDD.t4 sg13_hv_pmos ad=0.85p pd=5.68u as=0.85p ps=5.68u w=2.5u l=1u
X890 AVSS.t115 ibias0.t48 a_57082_6462# AVSS.t102 sg13_hv_nmos ad=0.85p pd=5.68u as=0.85p ps=5.68u w=2.5u l=1u
X891 AVSS.t64 ibias0.t14 a_57666_20260# AVSS.t59 sg13_hv_nmos ad=0.85p pd=5.68u as=0.85p ps=5.68u w=2.5u l=1u
X892 AVDD.t32 comparator_slice_0.comparator_body_0.m3_m4_diff_0.n1.t32 a_51218_11344# AVDD.t0 sg13_hv_pmos ad=0.85p pd=5.68u as=0.85p ps=5.68u w=2.5u l=1u
X893 a_50318_15044# comparator_slice_0.comparator_body_0.m3_m4_diff_0.n1.t46 comparator_slice_0.comparator_body_0.outx.t20 AVDD.t0 sg13_hv_pmos ad=0.85p pd=5.68u as=0.85p ps=5.68u w=2.5u l=1u
X894 resistor_network_0.resistor_leg_0.p2 vctrl.t6 AVDD.t3 rhigh l=13.42u w=0.5u
X895 AVSS.t82 ibias0.t12 a_57666_15264# AVSS.t59 sg13_hv_nmos ad=0.85p pd=5.68u as=0.85p ps=5.68u w=2.5u l=1u
X896 comparator_slice_1.comparator_body_0.outx.t58 threshold.t26 a_54186_44737# AVSS.t138 sg13_hv_nmos ad=0.85p pd=5.68u as=0.85p ps=5.68u w=2.5u l=1u
X897 comparator_slice_0.comparator_body_0.mref_m5_diff_0.tail.t60 ibias0.t2 a_57082_20260# AVSS.t53 sg13_hv_nmos ad=0.85p pd=5.68u as=0.85p ps=5.68u w=2.5u l=1u
X898 a_50318_6454# comparator_slice_0.comparator_body_0.m3_m4_diff_0.n1.t94 comparator_slice_0.comparator_body_0.m3_m4_diff_0.n1.t95 AVDD.t0 sg13_hv_pmos ad=0.85p pd=5.68u as=0.85p ps=5.68u w=2.5u l=1u
X899 resistor_network_0.p1 resistor_network_0.resistor_leg_1.pt AVDD.t3 rhigh l=13.42u w=0.5u
X900 comparator_slice_0.comparator_body_0.mref_m5_diff_0.tail.t42 ibias0.t10 a_57082_15264# AVSS.t53 sg13_hv_nmos ad=0.85p pd=5.68u as=0.85p ps=5.68u w=2.5u l=1u
X901 a_56766_42203# ibias1.t60 AVSS.t181 AVSS.t165 sg13_hv_nmos ad=0.85p pd=5.68u as=0.85p ps=5.68u w=2.5u l=1u
X902 a_53873_36464# resistor_network_0.p1 comparator_slice_1.comparator_body_0.m3_m4_diff_0.n1.t65 AVSS.t23 sg13_hv_nmos ad=0.85p pd=5.68u as=0.85p ps=5.68u w=2.5u l=1u
X903 a_56766_37207# ibias1.t16 AVSS.t200 AVSS.t57 sg13_hv_nmos ad=0.85p pd=5.68u as=0.85p ps=5.68u w=2.5u l=1u
X904 a_56766_33637# ibias1.t14 AVSS.t215 AVSS.t57 sg13_hv_nmos ad=0.85p pd=5.68u as=0.85p ps=5.68u w=2.5u l=1u
X905 a_50902_22314# comparator_slice_0.comparator_body_0.m3_m4_diff_0.n1.t68 AVDD.t27 AVDD.t0 sg13_hv_pmos ad=0.85p pd=5.68u as=0.85p ps=5.68u w=2.5u l=1u
X906 AVSS.t121 ibias0.t8 a_57666_4082# AVSS.t103 sg13_hv_nmos ad=0.85p pd=5.68u as=0.85p ps=5.68u w=2.5u l=1u
X907 a_50318_39937# comparator_slice_1.comparator_body_0.m3_m4_diff_0.n1.t46 AVDD.t72 AVDD.t4 sg13_hv_pmos ad=0.85p pd=5.68u as=0.85p ps=5.68u w=2.5u l=1u
X908 comparator_slice_0.comparator_body_0.mref_m5_diff_0.tail.t5 trigger.t10 a_54186_10675# AVSS.t30 sg13_hv_nmos ad=0.85p pd=5.68u as=0.85p ps=5.68u w=2.5u l=1u
X909 AVSS.t51 AVSS.t52 AVDD.t3 rhigh l=13.42u w=0.5u
X910 a_53289_40606# resistor_network_0.p1 comparator_slice_1.comparator_body_0.m3_m4_diff_0.n1.t72 AVSS.t137 sg13_hv_nmos ad=0.85p pd=5.68u as=0.85p ps=5.68u w=2.5u l=1u
X911 comparator_slice_1.comparator_body_0.mref_m5_diff_0.tail.t55 threshold.t28 a_54772_45977# AVSS.t136 sg13_hv_nmos ad=0.85p pd=5.68u as=0.85p ps=5.68u w=2.5u l=1u
X912 comparator_slice_1.comparator_body_0.mref_m5_diff_0.tail.t50 threshold.t24 a_54772_43497# AVSS.t136 sg13_hv_nmos ad=0.85p pd=5.68u as=0.85p ps=5.68u w=2.5u l=1u
X913 a_56766_42203# ibias1.t60 comparator_slice_1.comparator_body_0.mref_m5_diff_0.tail.t89 AVSS.t165 sg13_hv_nmos ad=0.85p pd=5.68u as=0.85p ps=5.68u w=2.5u l=1u
X914 AVSS.t15 AVSS.t15 AVDD.t3 rhigh l=13.42u w=0.5u
X915 a_53290_31074# threshold.t7 comparator_slice_1.comparator_body_0.mref_m5_diff_0.tail.t49 AVSS.t145 sg13_hv_nmos ad=0.85p pd=5.68u as=0.85p ps=5.68u w=2.5u l=1u
X916 a_56766_37207# ibias1.t16 comparator_slice_1.comparator_body_0.mref_m5_diff_0.tail.t71 AVSS.t57 sg13_hv_nmos ad=0.85p pd=5.68u as=0.85p ps=5.68u w=2.5u l=1u
X917 a_50902_22314# comparator_slice_0.comparator_body_0.m3_m4_diff_0.n1.t68 comparator_slice_0.comparator_body_0.m3_m4_diff_0.n1.t69 AVDD.t0 sg13_hv_pmos ad=0.85p pd=5.68u as=0.85p ps=5.68u w=2.5u l=1u
X918 a_50318_44827# comparator_slice_1.comparator_body_0.m3_m4_diff_0.n1.t28 comparator_slice_1.comparator_body_0.m3_m4_diff_0.n1.t29 AVDD.t4 sg13_hv_pmos ad=0.85p pd=5.68u as=0.85p ps=5.68u w=2.5u l=1u
X919 AVDD.t24 comparator_slice_1.comparator_body_0.m3_m4_diff_0.n1.t10 a_51218_41127# AVDD.t4 sg13_hv_pmos ad=0.85p pd=5.68u as=0.85p ps=5.68u w=2.5u l=1u
X920 comparator_slice_1.comparator_body_0.m3_m4_diff_0.n1.t19 comparator_slice_1.comparator_body_0.m3_m4_diff_0.n1.t18 a_51802_28967# AVDD.t4 sg13_hv_pmos ad=0.85p pd=5.68u as=0.85p ps=5.68u w=2.5u l=1u
X921 a_50318_36237# comparator_slice_1.comparator_body_0.m3_m4_diff_0.n1.t4 AVDD.t145 AVDD.t4 sg13_hv_pmos ad=0.85p pd=5.68u as=0.85p ps=5.68u w=2.5u l=1u
X922 AVSS.t18 AVSS.t19 AVDD.t3 rhigh l=13.42u w=0.5u
X923 a_56182_6462# ibias0.t24 ibias0.t25 AVSS.t91 sg13_hv_nmos ad=0.85p pd=5.68u as=0.85p ps=5.68u w=2.5u l=1u
X924 AVSS.t0 AVSS.t0 AVDD.t3 rhigh l=13.42u w=0.5u
X925 a_50902_7644# comparator_slice_0.comparator_body_0.m3_m4_diff_0.n1.t54 comparator_slice_0.comparator_body_0.m3_m4_diff_0.n1.t55 AVDD.t0 sg13_hv_pmos ad=0.85p pd=5.68u as=0.85p ps=5.68u w=2.5u l=1u
X926 AVSS.t14 AVSS.t14 AVDD.t3 rhigh l=13.42u w=0.5u
X927 a_56182_34827# ibias1.t12 AVSS.t210 AVSS.t55 sg13_hv_nmos ad=0.85p pd=5.68u as=0.85p ps=5.68u w=2.5u l=1u
X928 AVDD.t41 comparator_slice_0.comparator_body_0.m3_m4_diff_0.n1.t78 a_51218_15044# AVDD.t0 sg13_hv_pmos ad=0.85p pd=5.68u as=0.85p ps=5.68u w=2.5u l=1u
X929 comparator_slice_1.comparator_body_0.outx.t4 comparator_slice_1.comparator_body_0.m3_m4_diff_0.n1.t10 a_51218_41127# AVDD.t4 sg13_hv_pmos ad=0.85p pd=5.68u as=0.85p ps=5.68u w=2.5u l=1u
X930 comparator_slice_1.comparator_body_0.m3_m4_diff_0.n1.t86 resistor_network_0.p1 a_54186_40606# AVSS.t138 sg13_hv_nmos ad=0.85p pd=5.68u as=0.85p ps=5.68u w=2.5u l=1u
X931 comparator_slice_1.comparator_body_0.mref_m5_diff_0.tail.t52 threshold.t4 a_54772_29834# AVSS.t24 sg13_hv_nmos ad=0.85p pd=5.68u as=0.85p ps=5.68u w=2.5u l=1u
X932 comparator_slice_1.comparator_body_0.mref_m5_diff_0.tail.t45 threshold.t0 a_54772_27354# AVSS.t24 sg13_hv_nmos ad=0.85p pd=5.68u as=0.85p ps=5.68u w=2.5u l=1u
X933 AVSS.t11 AVSS.t11 AVDD.t3 rhigh l=13.42u w=0.5u
X934 a_62934_12138# a_60176_13955# AVDD1V2 AVDD1V2 sg13_hv_pmos ad=0.85p pd=5.68u as=0.85p ps=5.68u w=2.5u l=1u
X935 a_53289_28594# threshold.t3 comparator_slice_1.comparator_body_0.mref_m5_diff_0.tail.t44 AVSS.t21 sg13_hv_nmos ad=0.85p pd=5.68u as=0.85p ps=5.68u w=2.5u l=1u
X936 vctrl.t15 resistor_network_0.resistor_leg_0.p2 AVDD.t3 rhigh l=13.42u w=0.5u
X937 comparator_slice_0.comparator_body_0.mref_m5_diff_0.tail.t78 vctrl.t40 a_54186_9435# AVSS.t30 sg13_hv_nmos ad=0.85p pd=5.68u as=0.85p ps=5.68u w=2.5u l=1u
X938 a_50902_13854# comparator_slice_0.comparator_body_0.m3_m4_diff_0.n1.t60 AVDD.t150 AVDD.t0 sg13_hv_pmos ad=0.85p pd=5.68u as=0.85p ps=5.68u w=2.5u l=1u
X939 a_50902_17424# comparator_slice_0.comparator_body_0.m3_m4_diff_0.n1.t40 AVDD.t9 AVDD.t0 sg13_hv_pmos ad=0.85p pd=5.68u as=0.85p ps=5.68u w=2.5u l=1u
X940 resistor_network_0.p1 resistor_network_0.resistor_leg_3.p1 AVDD.t3 rhigh l=13.42u w=0.5u
X941 comparator_slice_1.comparator_body_0.mref_m5_diff_0.tail.t47 threshold.t30 a_54186_47217# AVSS.t138 sg13_hv_nmos ad=0.85p pd=5.68u as=0.85p ps=5.68u w=2.5u l=1u
X942 a_53873_32744# threshold.t9 comparator_slice_1.comparator_body_0.mref_m5_diff_0.tail.t51 AVSS.t23 sg13_hv_nmos ad=0.85p pd=5.68u as=0.85p ps=5.68u w=2.5u l=1u
X943 a_53289_13155# trigger.t15 comparator_slice_0.comparator_body_0.mref_m5_diff_0.tail.t7 AVSS.t25 sg13_hv_nmos ad=0.85p pd=5.68u as=0.85p ps=5.68u w=2.5u l=1u
X944 a_53289_17297# vctrl.t53 comparator_slice_0.comparator_body_0.mref_m5_diff_0.tail.t92 AVSS.t21 sg13_hv_nmos ad=0.85p pd=5.68u as=0.85p ps=5.68u w=2.5u l=1u
X945 resistor_network_0.resistor_leg_2.p1 AVDD.t25 AVDD.t3 rhigh l=13.42u w=0.5u
X946 AVSS.t212 ibias1.t58 a_57082_34827# AVSS.t53 sg13_hv_nmos ad=0.85p pd=5.68u as=0.85p ps=5.68u w=2.5u l=1u
X947 vctrl.t21 resistor_network_0.resistor_leg_1.pt AVDD.t3 rhigh l=13.42u w=0.5u
X948 resistor_network_0.p1 resistor_network_0.resistor_leg_0.pt AVDD.t3 rhigh l=13.42u w=0.5u
X949 comparator_slice_1.comparator_body_0.mref_m5_diff_0.tail.t28 resistor_network_0.p1 a_54772_41846# AVSS.t136 sg13_hv_nmos ad=0.85p pd=5.68u as=0.85p ps=5.68u w=2.5u l=1u
X950 AVSS.t16 AVSS.t16 AVDD.t3 rhigh l=13.42u w=0.5u
X951 a_50902_17424# comparator_slice_0.comparator_body_0.m3_m4_diff_0.n1.t40 comparator_slice_0.comparator_body_0.m3_m4_diff_0.n1.t41 AVDD.t0 sg13_hv_pmos ad=0.85p pd=5.68u as=0.85p ps=5.68u w=2.5u l=1u
X952 comparator_slice_1.comparator_body_0.outx.t44 threshold.t30 a_54186_47217# AVSS.t138 sg13_hv_nmos ad=0.85p pd=5.68u as=0.85p ps=5.68u w=2.5u l=1u
X953 a_53289_40606# resistor_network_0.p1 comparator_slice_1.comparator_body_0.mref_m5_diff_0.tail.t8 AVSS.t137 sg13_hv_nmos ad=0.85p pd=5.68u as=0.85p ps=5.68u w=2.5u l=1u
X954 a_50902_10154# comparator_slice_0.comparator_body_0.m3_m4_diff_0.n1.t88 comparator_slice_0.comparator_body_0.m3_m4_diff_0.n1.t89 AVDD.t0 sg13_hv_pmos ad=0.85p pd=5.68u as=0.85p ps=5.68u w=2.5u l=1u
X955 a_56182_19070# ibias0.t26 AVSS.t67 AVSS.t55 sg13_hv_nmos ad=0.85p pd=5.68u as=0.85p ps=5.68u w=2.5u l=1u
X956 AVSS.t20 AVSS.t20 AVDD.t3 rhigh l=13.42u w=0.5u
X957 comparator_slice_0.comparator_body_0.m3_m4_diff_0.n1.t29 trigger.t0 a_54772_4064# AVSS.t32 sg13_hv_nmos ad=0.85p pd=5.68u as=0.85p ps=5.68u w=2.5u l=1u
X958 comparator_slice_0.comparator_body_0.m3_m4_diff_0.n1.t25 trigger.t4 a_54772_6544# AVSS.t32 sg13_hv_nmos ad=0.85p pd=5.68u as=0.85p ps=5.68u w=2.5u l=1u
X959 comparator_slice_1.comparator_body_0.mref_m5_diff_0.tail.t37 threshold.t2 a_54186_28594# AVSS.t22 sg13_hv_nmos ad=0.85p pd=5.68u as=0.85p ps=5.68u w=2.5u l=1u
X960 AVSS.t108 ibias0.t28 a_57082_9078# AVSS.t102 sg13_hv_nmos ad=0.85p pd=5.68u as=0.85p ps=5.68u w=2.5u l=1u
X961 comparator_slice_0.comparator_body_0.outx.t56 comparator_slice_0.comparator_body_0.m3_m4_diff_0.n1.t56 a_51802_18744# AVDD.t0 sg13_hv_pmos ad=0.85p pd=5.68u as=0.85p ps=5.68u w=2.5u l=1u
X962 vctrl.t24 resistor_network_0.resistor_leg_0.pt AVDD.t3 rhigh l=13.42u w=0.5u
X963 comparator_slice_0.comparator_body_0.m3_m4_diff_0.n1.t19 trigger.t2 a_54186_5304# AVSS.t30 sg13_hv_nmos ad=0.85p pd=5.68u as=0.85p ps=5.68u w=2.5u l=1u
X964 comparator_slice_1.comparator_body_0.outx.t27 comparator_slice_1.comparator_body_0.m3_m4_diff_0.n1.t0 a_51218_36237# AVDD.t4 sg13_hv_pmos ad=0.85p pd=5.68u as=0.85p ps=5.68u w=2.5u l=1u
X965 comparator_slice_0.comparator_body_0.mref_m5_diff_0.tail.t22 trigger.t14 a_54186_13155# AVSS.t26 sg13_hv_nmos ad=0.85p pd=5.68u as=0.85p ps=5.68u w=2.5u l=1u
X966 comparator_slice_0.comparator_body_0.mref_m5_diff_0.tail.t72 vctrl.t52 a_54186_17297# AVSS.t22 sg13_hv_nmos ad=0.85p pd=5.68u as=0.85p ps=5.68u w=2.5u l=1u
X967 a_53873_31074# resistor_network_0.p1 comparator_slice_1.comparator_body_0.m3_m4_diff_0.n1.t83 AVSS.t23 sg13_hv_nmos ad=0.85p pd=5.68u as=0.85p ps=5.68u w=2.5u l=1u
X968 comparator_slice_0.comparator_body_0.mref_m5_diff_0.tail.t64 vctrl.t58 a_54772_21447# AVSS.t24 sg13_hv_nmos ad=0.85p pd=5.68u as=0.85p ps=5.68u w=2.5u l=1u
X969 a_56766_11458# ibias0.t56 comparator_slice_0.comparator_body_0.mref_m5_diff_0.tail.t43 AVSS.t93 sg13_hv_nmos ad=0.85p pd=5.68u as=0.85p ps=5.68u w=2.5u l=1u
X970 AVSS.t69 ibias0.t2 a_57082_19070# AVSS.t53 sg13_hv_nmos ad=0.85p pd=5.68u as=0.85p ps=5.68u w=2.5u l=1u
X971 a_50902_4074# comparator_slice_0.comparator_body_0.m3_m4_diff_0.n1.t76 AVDD.t66 AVDD.t0 sg13_hv_pmos ad=0.85p pd=5.68u as=0.85p ps=5.68u w=2.5u l=1u
X972 a_56182_39823# ibias1.t50 ibias1.t51 AVSS.t188 sg13_hv_nmos ad=0.85p pd=5.68u as=0.85p ps=5.68u w=2.5u l=1u
X973 a_56182_34827# ibias1.t12 ibias1.t13 AVSS.t55 sg13_hv_nmos ad=0.85p pd=5.68u as=0.85p ps=5.68u w=2.5u l=1u
X974 comparator_slice_1.comparator_body_0.mref_m5_diff_0.tail.t22 resistor_network_0.p1 a_54186_40606# AVSS.t138 sg13_hv_nmos ad=0.85p pd=5.68u as=0.85p ps=5.68u w=2.5u l=1u
X975 AVSS.t11 AVSS.t17 AVDD.t3 rhigh l=13.42u w=0.5u
X976 comparator_slice_0.comparator_body_0.mref_m5_diff_0.tail.t19 trigger.t2 a_54186_5304# AVSS.t30 sg13_hv_nmos ad=0.85p pd=5.68u as=0.85p ps=5.68u w=2.5u l=1u
X977 resistor_network_0.p1 resistor_network_0.resistor_leg_0.pt AVDD.t3 rhigh l=13.42u w=0.5u
X978 AVDD.t48 comparator_slice_1.comparator_body_0.m3_m4_diff_0.n1.t54 a_51218_32537# AVDD.t4 sg13_hv_pmos ad=0.85p pd=5.68u as=0.85p ps=5.68u w=2.5u l=1u
X979 a_53873_35224# threshold.t13 comparator_slice_1.comparator_body_0.outx.t38 AVSS.t23 sg13_hv_nmos ad=0.85p pd=5.68u as=0.85p ps=5.68u w=2.5u l=1u
X980 ibias1.t7 ibias1.t6 a_57082_39823# AVSS.t190 sg13_hv_nmos ad=0.85p pd=5.68u as=0.85p ps=5.68u w=2.5u l=1u
X981 resistor_network_0.resistor_leg_1.pt vctrl.t5 AVDD.t3 rhigh l=13.42u w=0.5u
X982 a_50318_8964# comparator_slice_0.comparator_body_0.m3_m4_diff_0.n1.t66 AVDD.t44 AVDD.t0 sg13_hv_pmos ad=0.85p pd=5.68u as=0.85p ps=5.68u w=2.5u l=1u
X983 a_50902_31347# comparator_slice_1.comparator_body_0.m3_m4_diff_0.n1.t44 AVDD.t136 AVDD.t4 sg13_hv_pmos ad=0.85p pd=5.68u as=0.85p ps=5.68u w=2.5u l=1u
X984 ibias1.t59 ibias1.t58 a_57082_34827# AVSS.t53 sg13_hv_nmos ad=0.85p pd=5.68u as=0.85p ps=5.68u w=2.5u l=1u
X985 a_62934_12138# a_60176_13955# reset_b AVDD1V2 sg13_hv_pmos ad=0.85p pd=5.68u as=0.85p ps=5.68u w=2.5u l=1u
X986 resistor_network_0.resistor_leg_2.p1 AVDD.t25 AVDD.t3 rhigh l=13.42u w=0.5u
X987 comparator_slice_0.comparator_body_0.m3_m4_diff_0.n1.t63 comparator_slice_0.comparator_body_0.m3_m4_diff_0.n1.t62 a_51218_6454# AVDD.t0 sg13_hv_pmos ad=0.85p pd=5.68u as=0.85p ps=5.68u w=2.5u l=1u
X988 AVSS.t226 ibias1.t10 a_57666_29831# AVSS.t59 sg13_hv_nmos ad=0.85p pd=5.68u as=0.85p ps=5.68u w=2.5u l=1u
X989 a_53873_7784# vctrl.t39 comparator_slice_0.comparator_body_0.outx.t44 AVSS.t31 sg13_hv_nmos ad=0.85p pd=5.68u as=0.85p ps=5.68u w=2.5u l=1u
X990 AVDD.t67 comparator_slice_0.comparator_body_0.m3_m4_diff_0.n1.t48 a_51802_10154# AVDD.t0 sg13_hv_pmos ad=0.85p pd=5.68u as=0.85p ps=5.68u w=2.5u l=1u
X991 a_56182_12648# ibias0.t44 comparator_slice_0.comparator_body_0.mref_m5_diff_0.tail.t61 AVSS.t87 sg13_hv_nmos ad=0.85p pd=5.68u as=0.85p ps=5.68u w=2.5u l=1u
R0 ibias0 ibias0.n103 76.4787
R1 ibias0.n53 ibias0.t2 2.21734
R2 ibias0.n52 ibias0.t28 2.21734
R3 ibias0.n51 ibias0.t20 2.19376
R4 ibias0.n55 ibias0.n94 6.88138
R5 ibias0.n94 ibias0.n93 6.0005
R6 ibias0.n89 ibias0.n88 6.0005
R7 ibias0.n47 ibias0.n69 6.0005
R8 ibias0.n98 ibias0.n90 6.0005
R9 ibias0.n92 ibias0.n91 6.0005
R10 ibias0.n101 ibias0.n50 6.0005
R11 ibias0.n58 ibias0.n102 6.0005
R12 ibias0.n45 ibias0.n57 6.0005
R13 ibias0.n103 ibias0.n46 6.0005
R14 ibias0.t34 ibias0.n44 4.96805
R15 ibias0.n44 ibias0.t18 4.96805
R16 ibias0.n72 ibias0.n65 0.698072
R17 ibias0.n50 ibias0.n17 0.580541
R18 ibias0.n1 ibias0.t14 2.12712
R19 ibias0.n50 ibias0.t40 4.96805
R20 ibias0.n50 ibias0.t4 4.96805
R21 ibias0.n63 ibias0.n50 0.698072
R22 ibias0.n71 ibias0.t46 4.96805
R23 ibias0.n24 ibias0.t30 2.07821
R24 ibias0.n5 ibias0.t10 2.40788
R25 ibias0.n59 ibias0.t12 4.96805
R26 ibias0.t44 ibias0.n71 4.96805
R27 ibias0.n71 ibias0.n25 0.57296
R28 ibias0.n59 ibias0.t32 5.06482
R29 ibias0.n59 ibias0.n62 1.45383
R30 ibias0.n49 ibias0.t36 4.96805
R31 ibias0.n49 ibias0.n31 0.580541
R32 ibias0.n7 ibias0.t62 2.12712
R33 ibias0.n49 ibias0.t24 4.96805
R34 ibias0.n49 ibias0.t48 4.96805
R35 ibias0.n60 ibias0.n49 0.698072
R36 ibias0.n56 ibias0.n42 0.572908
R37 ibias0.n56 ibias0.t58 4.96805
R38 ibias0.n54 ibias0.n51 0.573518
R39 ibias0.n54 ibias0.t8 4.96805
R40 ibias0.t46 ibias0.n38 4.95855
R41 ibias0.t36 ibias0.n47 4.95855
R42 ibias0.t38 ibias0.n42 2.19672
R43 ibias0.n68 ibias0.t50 2.19647
R44 ibias0.n65 ibias0.t42 2.13398
R45 ibias0.n18 ibias0.t22 2.19647
R46 ibias0.n63 ibias0.t52 2.13398
R47 ibias0.t56 ibias0.n25 2.19647
R48 ibias0.n62 ibias0.t16 2.13398
R49 ibias0.n32 ibias0.t0 2.19647
R50 ibias0.n60 ibias0.t60 2.13398
R51 ibias0.n0 ibias0.n1 0.694361
R52 ibias0.n17 ibias0.t54 2.21307
R53 ibias0.t12 ibias0.n3 4.92968
R54 ibias0.n24 ibias0.n23 0.831182
R55 ibias0.n6 ibias0.n7 0.694361
R56 ibias0.t6 ibias0.n31 2.21307
R57 ibias0.n9 ibias0.t8 4.92968
R58 ibias0.t58 ibias0.n37 4.92968
R59 ibias0.n12 ibias0.t34 4.92968
R60 ibias0.n14 ibias0.t18 4.92968
R61 ibias0.t40 ibias0.n19 4.92968
R62 ibias0.t4 ibias0.n20 4.92968
R63 ibias0.n26 ibias0.t44 4.92968
R64 ibias0.n28 ibias0.t32 4.92968
R65 ibias0.t24 ibias0.n33 4.92968
R66 ibias0.t48 ibias0.n34 4.92968
R67 ibias0.n0 ibias0.t3 2.56884
R68 ibias0.n3 ibias0.t11 2.56884
R69 ibias0.n6 ibias0.t29 2.56884
R70 ibias0.n9 ibias0.t21 2.56884
R71 ibias0.n12 ibias0.t51 2.53654
R72 ibias0.n82 ibias0.t19 2.53654
R73 ibias0.n13 ibias0.t43 2.53654
R74 ibias0.n45 ibias0.t35 2.53654
R75 ibias0.n74 ibias0.t41 2.53654
R76 ibias0.n19 ibias0.t23 2.53654
R77 ibias0.n84 ibias0.t5 2.53654
R78 ibias0.n64 ibias0.t53 2.53654
R79 ibias0.n70 ibias0.t45 2.53654
R80 ibias0.n26 ibias0.t57 2.53654
R81 ibias0.n86 ibias0.t33 2.53654
R82 ibias0.n27 ibias0.t17 2.53654
R83 ibias0.n77 ibias0.t25 2.53654
R84 ibias0.n33 ibias0.t1 2.53654
R85 ibias0.n78 ibias0.t49 2.53654
R86 ibias0.n61 ibias0.t61 2.53654
R87 ibias0.n99 ibias0.n91 2.53314
R88 ibias0.n81 ibias0.t55 2.52548
R89 ibias0.n73 ibias0.t15 2.52548
R90 ibias0.n83 ibias0.t31 2.52548
R91 ibias0.n75 ibias0.t13 2.52548
R92 ibias0.n85 ibias0.t7 2.52548
R93 ibias0.n76 ibias0.t63 2.52548
R94 ibias0.n87 ibias0.t59 2.52548
R95 ibias0.n79 ibias0.t9 2.52548
R96 ibias0.n15 ibias0.t27 2.52309
R97 ibias0.n38 ibias0.t47 2.52309
R98 ibias0.n47 ibias0.t37 2.52309
R99 ibias0.n41 ibias0.t39 2.52309
R100 ibias0.n98 ibias0.n69 2.38882
R101 ibias0.n88 ibias0.n69 2.15738
R102 ibias0.n56 ibias0.n54 1.93146
R103 ibias0.n99 ibias0.n98 1.82298
R104 ibias0.n94 ibias0.n88 1.65402
R105 ibias0.n13 ibias0.n65 0.696597
R106 ibias0.n64 ibias0.n63 0.696597
R107 ibias0.n5 ibias0.n59 0.266489
R108 ibias0.n27 ibias0.n62 0.696597
R109 ibias0.n61 ibias0.n60 0.696597
R110 ibias0.n54 ibias0.n11 0.490555
R111 ibias0.n89 ibias0.n49 1.62016
R112 ibias0.n92 ibias0.n50 1.61796
R113 ibias0.n90 ibias0.n71 1.56626
R114 ibias0.n102 ibias0.n101 1.45426
R115 ibias0.n46 ibias0.n12 1.41848
R116 ibias0.n97 ibias0.n48 0.449131
R117 ibias0.n10 ibias0.n78 0.376415
R118 ibias0.n85 ibias0.n70 1.36629
R119 ibias0.n84 ibias0.n4 0.376415
R120 ibias0.n39 ibias0.n74 0.44795
R121 ibias0.n0 ibias0.n16 1.3625
R122 ibias0.n3 ibias0.n23 1.3625
R123 ibias0.n6 ibias0.n30 1.3625
R124 ibias0.n9 ibias0.n11 0.517319
R125 ibias0.n101 ibias0.n91 1.33722
R126 ibias0.n103 ibias0.n57 1.3293
R127 ibias0.n71 ibias0.n59 1.31005
R128 ibias0.n73 ibias0.n13 1.3095
R129 ibias0.n12 ibias0.n81 1.3095
R130 ibias0.n80 ibias0.n67 1.3095
R131 ibias0.n82 ibias0.n14 1.3095
R132 ibias0.n75 ibias0.n64 1.3095
R133 ibias0.n19 ibias0.n83 1.3095
R134 ibias0.n74 ibias0.n92 1.3095
R135 ibias0.n100 ibias0.n22 1.3095
R136 ibias0.n84 ibias0.n20 1.3095
R137 ibias0.n76 ibias0.n27 1.3095
R138 ibias0.n26 ibias0.n85 1.3095
R139 ibias0.n90 ibias0.n70 1.3095
R140 ibias0.n66 ibias0.n96 1.3095
R141 ibias0.n86 ibias0.n28 1.3095
R142 ibias0.n79 ibias0.n61 1.3095
R143 ibias0.n33 ibias0.n87 1.3095
R144 ibias0.n95 ibias0.n36 1.3095
R145 ibias0.n78 ibias0.n34 1.3095
R146 ibias0.n81 ibias0.n15 1.2941
R147 ibias0.n80 ibias0.n16 1.2941
R148 ibias0.n2 ibias0.n0 0.591067
R149 ibias0.n83 ibias0.n39 0.44795
R150 ibias0.n38 ibias0.n39 0.424325
R151 ibias0.n23 ibias0.n22 1.2941
R152 ibias0.n3 ibias0.n4 0.563614
R153 ibias0.n85 ibias0.n97 1.2941
R154 ibias0.n47 ibias0.n70 1.2941
R155 ibias0.n96 ibias0.n30 1.2941
R156 ibias0.n8 ibias0.n6 0.591067
R157 ibias0.n87 ibias0.n41 1.2941
R158 ibias0.n37 ibias0.n36 1.2941
R159 ibias0.n10 ibias0.n9 0.563614
R160 ibias0.n43 ibias0.n15 0.429007
R161 ibias0.n17 ibias0.n16 0.565076
R162 ibias0.n44 ibias0.n67 1.2919
R163 ibias0.n72 ibias0.n14 1.2919
R164 ibias0.n40 ibias0.n71 0.419323
R165 ibias0.n21 ibias0.n50 0.412947
R166 ibias0.n21 ibias0.n20 0.468505
R167 ibias0.n48 ibias0.n49 0.422529
R168 ibias0.n31 ibias0.n30 0.565076
R169 ibias0.n59 ibias0.n29 0.412947
R170 ibias0.n29 ibias0.n28 0.468505
R171 ibias0.n41 ibias0.n42 0.571814
R172 ibias0.n11 ibias0.n37 0.41259
R173 ibias0.n35 ibias0.n49 0.412947
R174 ibias0.n35 ibias0.n34 0.468505
R175 ibias0.n48 ibias0.n47 0.448908
R176 ibias0.n72 ibias0.n44 1.28781
R177 ibias0.n45 ibias0.n58 1.24878
R178 ibias0.n50 ibias0.n53 1.24557
R179 ibias0.n49 ibias0.n52 1.24557
R180 ibias0.n43 ibias0.t26 2.60499
R181 ibias0.n38 ibias0.n23 1.41966
R182 ibias0.n55 ibias0.n41 1.38411
R183 ibias0.n44 ibias0.n68 1.21661
R184 ibias0.n32 ibias0.n49 1.21661
R185 ibias0.n50 ibias0.n43 0.414668
R186 ibias0.n77 ibias0.n89 1.1775
R187 ibias0.n86 ibias0.n8 0.331612
R188 ibias0.n82 ibias0.n2 0.331612
R189 ibias0.n93 ibias0.n77 1.12998
R190 ibias0.n87 ibias0.n77 1.12671
R191 ibias0.n96 ibias0.n86 1.12671
R192 ibias0.n80 ibias0.n82 1.12671
R193 ibias0.n81 ibias0.n45 1.12671
R194 ibias0.n40 ibias0.n99 6.2984
R195 ibias0.n2 ibias0.n73 0.52412
R196 ibias0.n75 ibias0.n4 0.595011
R197 ibias0.n8 ibias0.n76 0.52412
R198 ibias0.n10 ibias0.n79 0.595011
R199 ibias0.n59 ibias0.n24 0.853942
R200 ibias0.n41 ibias0.n37 1.46607
R201 ibias0.n97 ibias0.n30 1.46607
R202 ibias0.n16 ibias0.n15 1.46607
R203 ibias0.n67 ibias0.n14 1.46607
R204 ibias0.n21 ibias0.n100 0.468505
R205 ibias0.n66 ibias0.n29 0.468505
R206 ibias0.n33 ibias0.n32 1.30436
R207 ibias0.n26 ibias0.n25 1.30436
R208 ibias0.n19 ibias0.n18 1.30436
R209 ibias0.n68 ibias0.n12 1.30436
R210 ibias0.n51 ibias0.n9 1.304
R211 ibias0.n3 ibias0.n5 0.604935
R212 ibias0.n52 ibias0.n6 1.29912
R213 ibias0.n53 ibias0.n0 1.29912
R214 ibias0.n35 ibias0.n95 0.468505
R215 ibias0.n14 ibias0.n13 1.05584
R216 ibias0.n64 ibias0.n20 1.05584
R217 ibias0.n28 ibias0.n27 1.05584
R218 ibias0.n61 ibias0.n34 1.05584
R219 ibias0.n12 ibias0.n67 1.03522
R220 ibias0.n100 ibias0.n19 1.03522
R221 ibias0.n26 ibias0.n66 1.03522
R222 ibias0.n95 ibias0.n33 1.03522
R223 ibias0.n46 ibias0.n45 0.9971
R224 ibias0.n18 ibias0.n50 0.972717
R225 ibias0.n46 ibias0.n44 0.955758
R226 ibias0.n58 ibias0.n15 0.955246
R227 ibias0.n56 ibias0.n55 0.922757
R228 ibias0.n40 ibias0.n38 0.363786
R229 ibias0.n81 ibias0.n80 0.90775
R230 ibias0.n83 ibias0.n22 0.90775
R231 ibias0.n84 ibias0.n22 0.90775
R232 ibias0.n96 ibias0.n85 0.90775
R233 ibias0.n87 ibias0.n36 0.90775
R234 ibias0.n78 ibias0.n36 0.90775
R235 ibias0.n89 ibias0.n33 0.88608
R236 ibias0.n90 ibias0.n26 0.80798
R237 ibias0.n102 ibias0.n57 0.80746
R238 ibias0.n93 ibias0.n41 0.761308
R239 ibias0.n92 ibias0.n19 0.75628
R240 ibias0.n50 ibias0.n1 1.45552
R241 ibias0.n49 ibias0.n7 1.45552
R242 trigger trigger.n18 43.7793
R243 trigger.n17 trigger.n2 11.1803
R244 trigger.n12 trigger.n11 9.00188
R245 trigger.n14 trigger.n17 9.0005
R246 trigger.n18 trigger.n15 9.0005
R247 trigger.n3 trigger.t24 5.76598
R248 trigger.n4 trigger.t28 5.76598
R249 trigger.n5 trigger.t20 5.76598
R250 trigger.n6 trigger.t16 5.76598
R251 trigger.n7 trigger.t12 5.76598
R252 trigger.n8 trigger.t8 5.76598
R253 trigger.n9 trigger.t4 5.76598
R254 trigger.n1 trigger.t0 5.76598
R255 trigger.n15 trigger.t27 4.95984
R256 trigger.n3 trigger.t26 4.95984
R257 trigger.n3 trigger.t25 4.95984
R258 trigger.n16 trigger.t31 4.95984
R259 trigger.n4 trigger.t30 4.95984
R260 trigger.n4 trigger.t29 4.95984
R261 trigger.n10 trigger.t23 4.95984
R262 trigger.n5 trigger.t22 4.95984
R263 trigger.n5 trigger.t21 4.95984
R264 trigger.n12 trigger.t19 4.95984
R265 trigger.n6 trigger.t18 4.95984
R266 trigger.n6 trigger.t17 4.95984
R267 trigger.n13 trigger.t15 4.95984
R268 trigger.n7 trigger.t14 4.95984
R269 trigger.n7 trigger.t13 4.95984
R270 trigger.n14 trigger.t11 4.95984
R271 trigger.n8 trigger.t10 4.95984
R272 trigger.n8 trigger.t9 4.95984
R273 trigger.n0 trigger.t7 4.95984
R274 trigger.n9 trigger.t6 4.95984
R275 trigger.n9 trigger.t5 4.95984
R276 trigger.n2 trigger.t3 4.95984
R277 trigger.n1 trigger.t2 4.95984
R278 trigger.n1 trigger.t1 4.95984
R279 trigger.n15 trigger.n10 3.89175
R280 trigger.n12 trigger.n13 3.88075
R281 trigger.n14 trigger.n0 3.86562
R282 trigger.n15 trigger.n16 3.727
R283 trigger.n10 trigger.n12 3.3005
R284 trigger.n13 trigger.n14 3.3005
R285 trigger.n2 trigger.n0 2.7835
R286 trigger.n2 trigger.n1 2.54754
R287 trigger.n18 trigger.n11 2.3743
R288 trigger.n17 trigger.n11 2.3677
R289 trigger.n0 trigger.n9 2.03054
R290 trigger.n14 trigger.n8 2.03054
R291 trigger.n13 trigger.n7 2.03054
R292 trigger.n12 trigger.n6 2.03054
R293 trigger.n10 trigger.n5 2.03054
R294 trigger.n15 trigger.n3 2.03054
R295 trigger.n16 trigger.n4 1.60405
R296 vctrl.n4 vctrl.t8 51.5583
R297 vctrl.n5 vctrl.t22 51.5583
R298 vctrl vctrl.n70 39.9566
R299 vctrl.n26 vctrl.t29 33.0026
R300 vctrl.n27 vctrl.t16 33.0026
R301 vctrl.n22 vctrl.t20 25.2237
R302 vctrl.n21 vctrl.t27 25.2237
R303 vctrl.n25 vctrl.t14 25.2237
R304 vctrl.n24 vctrl.t19 25.2237
R305 vctrl.n62 vctrl.t6 25.2171
R306 vctrl.n53 vctrl.t7 25.2171
R307 vctrl.n62 vctrl.t0 24.305
R308 vctrl.n6 vctrl.t15 24.305
R309 vctrl.n53 vctrl.t4 24.305
R310 vctrl.n8 vctrl.t31 24.305
R311 vctrl.n22 vctrl.t3 24.0005
R312 vctrl.n21 vctrl.t26 24.0005
R313 vctrl.n25 vctrl.t10 24.0005
R314 vctrl.n24 vctrl.t17 24.0005
R315 vctrl.n64 vctrl.n61 19.6822
R316 vctrl.n54 vctrl.n51 19.6822
R317 vctrl.n69 vctrl.n68 19.3788
R318 vctrl.n59 vctrl.n52 19.3788
R319 vctrl.n4 vctrl.n60 19.3201
R320 vctrl.n5 vctrl.n50 19.3201
R321 vctrl.n61 vctrl.n4 19.1595
R322 vctrl.n51 vctrl.n5 19.1595
R323 vctrl.n5 vctrl.t28 16.8892
R324 vctrl.n4 vctrl.t25 16.8892
R325 vctrl.n60 vctrl.t24 16.6747
R326 vctrl.n50 vctrl.t23 16.6747
R327 vctrl.n66 vctrl.t2 15.6924
R328 vctrl.n56 vctrl.t5 15.6924
R329 vctrl.n68 vctrl.t1 15.5461
R330 vctrl.n52 vctrl.t21 15.5461
R331 vctrl.t58 vctrl.n16 4.95984
R332 vctrl.n17 vctrl.t50 4.95984
R333 vctrl.t42 vctrl.n18 4.95984
R334 vctrl.n19 vctrl.t34 4.95984
R335 vctrl.n60 vctrl.t18 15.0005
R336 vctrl.n64 vctrl.t30 15.0005
R337 vctrl.n50 vctrl.t9 15.0005
R338 vctrl.n54 vctrl.t11 15.0005
R339 vctrl.n32 vctrl.n3 10.3217
R340 vctrl.n70 vctrl.n28 10.11
R341 vctrl.n43 vctrl.n30 9.193
R342 vctrl.n34 vctrl.n45 9.17925
R343 vctrl.n49 vctrl.n36 9.17375
R344 vctrl.n20 vctrl.n66 9.0005
R345 vctrl.n7 vctrl.n6 2.17854
R346 vctrl.n23 vctrl.n56 9.0005
R347 vctrl.n9 vctrl.n8 2.17854
R348 vctrl.n2 vctrl.n3 6.7505
R349 vctrl.n44 vctrl.n11 6.7505
R350 vctrl.n15 vctrl.n12 6.7505
R351 vctrl.n37 vctrl.t63 6.5653
R352 vctrl.n47 vctrl.t55 6.5653
R353 vctrl.n40 vctrl.t47 6.5653
R354 vctrl.n1 vctrl.t39 6.5653
R355 vctrl.n13 vctrl.t57 6.56117
R356 vctrl.n10 vctrl.t49 6.56117
R357 vctrl.n0 vctrl.t41 6.56117
R358 vctrl.n38 vctrl.t33 6.56117
R359 vctrl.n48 vctrl.t61 5.76367
R360 vctrl.n46 vctrl.t53 5.76367
R361 vctrl.n42 vctrl.t45 5.76367
R362 vctrl.n39 vctrl.t37 5.76367
R363 vctrl.n22 vctrl.n21 5.0341
R364 vctrl.n25 vctrl.n24 5.0341
R365 vctrl.n35 vctrl.t60 4.95984
R366 vctrl.n48 vctrl.t59 4.95984
R367 vctrl.n37 vctrl.t62 4.95984
R368 vctrl.n13 vctrl.t56 4.95984
R369 vctrl.n47 vctrl.t54 4.95984
R370 vctrl.n33 vctrl.t52 4.95984
R371 vctrl.n46 vctrl.t51 4.95984
R372 vctrl.n10 vctrl.t48 4.95984
R373 vctrl.n40 vctrl.t46 4.95984
R374 vctrl.n29 vctrl.t44 4.95984
R375 vctrl.n42 vctrl.t43 4.95984
R376 vctrl.n0 vctrl.t40 4.95984
R377 vctrl.n1 vctrl.t38 4.95984
R378 vctrl.n31 vctrl.t36 4.95984
R379 vctrl.n39 vctrl.t35 4.95984
R380 vctrl.n38 vctrl.t32 4.95984
R381 vctrl.n19 vctrl.n38 4.50559
R382 vctrl.n16 vctrl.n37 3.69984
R383 vctrl.n70 vctrl.n49 3.52798
R384 vctrl.n16 vctrl.n15 3.2895
R385 vctrl.n14 vctrl.n17 3.2895
R386 vctrl.n17 vctrl.n11 3.2895
R387 vctrl.n18 vctrl.n41 3.2895
R388 vctrl.n18 vctrl.n2 3.2895
R389 vctrl.n2 vctrl.n19 3.2895
R390 vctrl.n68 vctrl.n67 3.0005
R391 vctrl.n57 vctrl.n52 3.0005
R392 vctrl.n28 vctrl.n61 2.87458
R393 vctrl.n28 vctrl.n51 2.87458
R394 vctrl.n65 vctrl.n64 2.4986
R395 vctrl.n55 vctrl.n54 2.4986
R396 vctrl.n23 vctrl.n8 1.79658
R397 vctrl.n69 vctrl.n63 1.56709
R398 vctrl.n59 vctrl.n58 1.56709
R399 vctrl.n67 vctrl.n63 1.50926
R400 vctrl.n58 vctrl.n57 1.50926
R401 vctrl.n26 vctrl.n69 1.35306
R402 vctrl.n27 vctrl.n59 1.35306
R403 vctrl.n24 vctrl.n23 1.25274
R404 vctrl.n21 vctrl.n20 1.25274
R405 vctrl.n43 vctrl.n3 1.21446
R406 vctrl.n45 vctrl.n44 1.21006
R407 vctrl.n49 vctrl.n12 1.20918
R408 vctrl.n45 vctrl.n12 1.16166
R409 vctrl.n44 vctrl.n43 1.15462
R410 vctrl.n57 vctrl.n25 0.9421
R411 vctrl.n67 vctrl.n22 0.9421
R412 vctrl.n66 vctrl.n65 0.9157
R413 vctrl.n56 vctrl.n55 0.9157
R414 vctrl.n41 vctrl.n11 0.841804
R415 vctrl.n15 vctrl.n14 0.830517
R416 vctrl.n65 vctrl.n7 0.91821
R417 vctrl.n55 vctrl.n9 0.91821
R418 vctrl.n35 vctrl.n48 0.80021
R419 vctrl.n33 vctrl.n46 0.80021
R420 vctrl.n29 vctrl.n42 0.80021
R421 vctrl.n31 vctrl.n39 0.80021
R422 vctrl.n15 vctrl.n13 0.781604
R423 vctrl.n36 vctrl.n35 0.760442
R424 vctrl.n34 vctrl.n33 0.760442
R425 vctrl.n30 vctrl.n29 0.760442
R426 vctrl.n32 vctrl.n31 0.760442
R427 vctrl.n11 vctrl.n10 0.759891
R428 vctrl.n2 vctrl.n0 0.720016
R429 vctrl.n28 vctrl.n27 0.691652
R430 vctrl.n63 vctrl.n62 0.526526
R431 vctrl.n58 vctrl.n53 0.526526
R432 vctrl.n19 vctrl.n32 0.457481
R433 vctrl.n30 vctrl.n18 0.457481
R434 vctrl.n17 vctrl.n34 0.457481
R435 vctrl.n36 vctrl.n16 0.457481
R436 vctrl.n28 vctrl.n26 0.42378
R437 vctrl.n14 vctrl.n47 0.410837
R438 vctrl.n41 vctrl.n40 0.410837
R439 vctrl.n7 vctrl.t12 16.5074
R440 vctrl.n9 vctrl.t13 16.5074
R441 vctrl.n20 vctrl.n6 1.79658
R442 vctrl.n2 vctrl.n1 1.27689
R443 ibias1 ibias1.n103 75.9128
R444 ibias1.t28 ibias1.n49 2.19376
R445 ibias1.t62 ibias1.n48 2.21734
R446 ibias1.t44 ibias1.n47 2.21734
R447 ibias1.n46 ibias1.t34 2.21734
R448 ibias1.n52 ibias1.n95 6.88138
R449 ibias1.n103 ibias1.n30 6.0005
R450 ibias1.n55 ibias1.n54 6.0005
R451 ibias1.n40 ibias1.n100 6.0005
R452 ibias1.n101 ibias1.n26 6.0005
R453 ibias1.n74 ibias1.n102 6.0005
R454 ibias1.n92 ibias1.n91 6.0005
R455 ibias1.n93 ibias1.n44 6.0005
R456 ibias1.n89 ibias1.n88 6.0005
R457 ibias1.n95 ibias1.n94 6.0005
R458 ibias1.n53 ibias1.n36 0.572908
R459 ibias1.t26 ibias1.n53 4.96805
R460 ibias1.n51 ibias1.n49 0.573518
R461 ibias1.n51 ibias1.t18 4.96805
R462 ibias1.n68 ibias1.t32 4.96805
R463 ibias1.n58 ibias1.t2 5.06482
R464 ibias1.n58 ibias1.t52 4.96805
R465 ibias1.n68 ibias1.t40 4.96805
R466 ibias1.n68 ibias1.t60 4.96805
R467 ibias1.n58 ibias1.n48 0.579673
R468 ibias1.n4 ibias1.t4 2.12712
R469 ibias1.n56 ibias1.t50 4.96805
R470 ibias1.n57 ibias1.t8 5.06482
R471 ibias1.t6 ibias1.n57 4.96805
R472 ibias1.t48 ibias1.n56 4.96805
R473 ibias1.n56 ibias1.t16 4.96805
R474 ibias1.n57 ibias1.n47 0.579673
R475 ibias1.n7 ibias1.t30 2.12712
R476 ibias1.n26 ibias1.t12 4.96805
R477 ibias1.t58 ibias1.n26 4.96805
R478 ibias1.n26 ibias1.n61 0.698072
R479 ibias1.n26 ibias1.n33 0.580541
R480 ibias1.n10 ibias1.t36 2.12712
R481 ibias1.n43 ibias1.t20 4.96805
R482 ibias1.n43 ibias1.t54 4.96805
R483 ibias1.n50 ibias1.n60 0.698072
R484 ibias1.n36 ibias1.t42 2.19672
R485 ibias1.n44 ibias1.t40 4.95855
R486 ibias1.n37 ibias1.t48 4.95855
R487 ibias1.n64 ibias1.t56 2.13398
R488 ibias1.t0 ibias1.n63 2.13398
R489 ibias1.t38 ibias1.n61 2.13398
R490 ibias1.n60 ibias1.t10 2.13398
R491 ibias1.t2 ibias1.n16 4.95753
R492 ibias1.n18 ibias1.t8 4.95753
R493 ibias1.n67 ibias1.t14 2.19647
R494 ibias1.n66 ibias1.t46 2.19647
R495 ibias1.t52 ibias1.n14 4.92968
R496 ibias1.t32 ibias1.n16 4.92968
R497 ibias1.n18 ibias1.t50 4.92968
R498 ibias1.n23 ibias1.t6 4.92968
R499 ibias1.n24 ibias1.t12 4.92968
R500 ibias1.n29 ibias1.t58 4.92968
R501 ibias1.n31 ibias1.t20 4.92968
R502 ibias1.n35 ibias1.t54 4.92968
R503 ibias1.n13 ibias1.t26 4.92968
R504 ibias1.n0 ibias1.t18 4.92968
R505 ibias1.t60 ibias1.n20 4.92968
R506 ibias1.n3 ibias1.n4 0.694361
R507 ibias1.t16 ibias1.n25 4.92968
R508 ibias1.n7 ibias1.n6 0.694361
R509 ibias1.n33 ibias1.t24 2.21307
R510 ibias1.n10 ibias1.n9 0.694361
R511 ibias1.n0 ibias1.t29 2.56873
R512 ibias1.n3 ibias1.t63 2.56873
R513 ibias1.n6 ibias1.t45 2.56873
R514 ibias1.n9 ibias1.t35 2.56873
R515 ibias1.n65 ibias1.t57 2.53664
R516 ibias1.n69 ibias1.t53 2.53664
R517 ibias1.n16 ibias1.t3 2.53664
R518 ibias1.n71 ibias1.t33 2.53664
R519 ibias1.n72 ibias1.t51 2.53664
R520 ibias1.n62 ibias1.t1 2.53664
R521 ibias1.n82 ibias1.t7 2.53664
R522 ibias1.n18 ibias1.t9 2.53664
R523 ibias1.n75 ibias1.t13 2.53664
R524 ibias1.n28 ibias1.t39 2.53664
R525 ibias1.n85 ibias1.t59 2.53664
R526 ibias1.n24 ibias1.t15 2.53664
R527 ibias1.n55 ibias1.t21 2.53664
R528 ibias1.n59 ibias1.t11 2.53664
R529 ibias1.n87 ibias1.t55 2.53664
R530 ibias1.n31 ibias1.t47 2.53664
R531 ibias1.n102 ibias1.n99 2.53314
R532 ibias1.n79 ibias1.t27 2.52538
R533 ibias1.n70 ibias1.t19 2.52538
R534 ibias1.n81 ibias1.t61 2.52538
R535 ibias1.n73 ibias1.t5 2.52538
R536 ibias1.n84 ibias1.t17 2.52538
R537 ibias1.n76 ibias1.t31 2.52538
R538 ibias1.n77 ibias1.t25 2.52538
R539 ibias1.n78 ibias1.t37 2.52538
R540 ibias1.n12 ibias1.t43 2.52299
R541 ibias1.n44 ibias1.t41 2.52299
R542 ibias1.n37 ibias1.t49 2.52299
R543 ibias1.n41 ibias1.t23 2.52299
R544 ibias1.n93 ibias1.n91 2.38882
R545 ibias1.n88 ibias1.n93 2.15738
R546 ibias1.n53 ibias1.n51 1.93146
R547 ibias1.n99 ibias1.n91 1.82298
R548 ibias1.n95 ibias1.n88 1.65402
R549 ibias1.n51 ibias1.n2 0.490555
R550 ibias1.n65 ibias1.n64 0.696597
R551 ibias1.n62 ibias1.n63 0.696597
R552 ibias1.n28 ibias1.n61 0.696597
R553 ibias1.n60 ibias1.n59 0.696597
R554 ibias1.n17 ibias1.n68 0.462804
R555 ibias1.n26 ibias1.n74 1.61796
R556 ibias1.n56 ibias1.n19 0.460837
R557 ibias1.n101 ibias1.n100 1.45426
R558 ibias1.n31 ibias1.n30 1.41848
R559 ibias1.n45 ibias1.n90 0.449131
R560 ibias1.n85 ibias1.n8 0.376415
R561 ibias1.n39 ibias1.n75 0.44795
R562 ibias1.n82 ibias1.n5 0.376415
R563 ibias1.n81 ibias1.n72 1.36629
R564 ibias1.n1 ibias1.n69 0.376415
R565 ibias1.n2 ibias1.n0 0.517319
R566 ibias1.n20 ibias1.n3 1.3625
R567 ibias1.n6 ibias1.n25 1.3625
R568 ibias1.n32 ibias1.n9 1.3625
R569 ibias1.n102 ibias1.n101 1.33722
R570 ibias1.n103 ibias1.n54 1.3293
R571 ibias1.n70 ibias1.n65 1.3095
R572 ibias1.n16 ibias1.n79 1.3095
R573 ibias1.n97 ibias1.n96 1.3095
R574 ibias1.n69 ibias1.n14 1.3095
R575 ibias1.n73 ibias1.n62 1.3095
R576 ibias1.n81 ibias1.n18 1.3095
R577 ibias1.n92 ibias1.n72 1.3095
R578 ibias1.n80 ibias1.n21 1.3095
R579 ibias1.n23 ibias1.n82 1.3095
R580 ibias1.n76 ibias1.n28 1.3095
R581 ibias1.n84 ibias1.n24 1.3095
R582 ibias1.n75 ibias1.n74 1.3095
R583 ibias1.n83 ibias1.n98 1.3095
R584 ibias1.n29 ibias1.n85 1.3095
R585 ibias1.n59 ibias1.n78 1.3095
R586 ibias1.n77 ibias1.n31 1.3095
R587 ibias1.n86 ibias1.n34 1.3095
R588 ibias1.n87 ibias1.n35 1.3095
R589 ibias1.n79 ibias1.n12 1.2941
R590 ibias1.n96 ibias1.n13 1.2941
R591 ibias1.n1 ibias1.n0 0.563614
R592 ibias1.n90 ibias1.n81 1.2941
R593 ibias1.n72 ibias1.n44 1.2941
R594 ibias1.n80 ibias1.n20 1.2941
R595 ibias1.n5 ibias1.n3 0.563614
R596 ibias1.n39 ibias1.n84 0.44795
R597 ibias1.n37 ibias1.n39 0.424325
R598 ibias1.n83 ibias1.n25 1.2941
R599 ibias1.n8 ibias1.n6 0.563614
R600 ibias1.n77 ibias1.n41 1.2941
R601 ibias1.n86 ibias1.n32 1.2941
R602 ibias1.n11 ibias1.n9 0.591067
R603 ibias1.n17 ibias1.n16 0.462386
R604 ibias1.n36 ibias1.n12 0.571814
R605 ibias1.n15 ibias1.n58 0.412947
R606 ibias1.n13 ibias1.n2 0.41259
R607 ibias1.n15 ibias1.n14 0.468505
R608 ibias1.n19 ibias1.n18 0.4533
R609 ibias1.n45 ibias1.n68 0.42253
R610 ibias1.n57 ibias1.n22 0.412947
R611 ibias1.n20 ibias1.n58 1.2919
R612 ibias1.n23 ibias1.n22 0.468505
R613 ibias1.n38 ibias1.n56 0.41928
R614 ibias1.n27 ibias1.n26 0.412947
R615 ibias1.n29 ibias1.n27 0.468505
R616 ibias1.n42 ibias1.n41 0.429007
R617 ibias1.n43 ibias1.n34 1.2919
R618 ibias1.n33 ibias1.n32 0.565076
R619 ibias1.n50 ibias1.n35 1.2919
R620 ibias1.n45 ibias1.n44 0.448908
R621 ibias1.n43 ibias1.n50 1.28781
R622 ibias1.n40 ibias1.n55 1.24878
R623 ibias1.n26 ibias1.n46 1.24557
R624 ibias1.n42 ibias1.t22 2.60499
R625 ibias1.n37 ibias1.n25 1.41932
R626 ibias1.n43 ibias1.n66 1.21661
R627 ibias1.n26 ibias1.n42 0.414668
R628 ibias1.n71 ibias1.n89 1.1775
R629 ibias1.n64 ibias1.n58 1.17068
R630 ibias1.n57 ibias1.n63 1.17068
R631 ibias1.n87 ibias1.n11 0.331612
R632 ibias1.n94 ibias1.n71 1.12998
R633 ibias1.n86 ibias1.n87 1.12671
R634 ibias1.n55 ibias1.n77 1.12671
R635 ibias1.n79 ibias1.n71 1.12671
R636 ibias1.n99 ibias1.n38 6.29848
R637 ibias1.n1 ibias1.n70 0.595011
R638 ibias1.n5 ibias1.n73 0.595011
R639 ibias1.n8 ibias1.n76 0.595011
R640 ibias1.n78 ibias1.n11 0.52412
R641 ibias1.n57 ibias1.n25 2.02451
R642 ibias1.n89 ibias1.n17 0.579665
R643 ibias1.n92 ibias1.n19 0.549391
R644 ibias1.n35 ibias1.n34 1.46607
R645 ibias1.n41 ibias1.n32 1.46607
R646 ibias1.n90 ibias1.n20 1.46607
R647 ibias1.n13 ibias1.n12 1.46607
R648 ibias1.n15 ibias1.n97 0.468505
R649 ibias1.n22 ibias1.n21 0.468505
R650 ibias1.n98 ibias1.n27 0.468505
R651 ibias1.n52 ibias1.n12 1.38377
R652 ibias1.n66 ibias1.n31 1.30436
R653 ibias1.n67 ibias1.n24 1.30436
R654 ibias1.n49 ibias1.n0 1.304
R655 ibias1.n46 ibias1.n9 1.29912
R656 ibias1.n6 ibias1.n47 1.29912
R657 ibias1.n48 ibias1.n3 1.29912
R658 ibias1.n65 ibias1.n14 1.05584
R659 ibias1.n62 ibias1.n23 1.05584
R660 ibias1.n29 ibias1.n28 1.05584
R661 ibias1.n59 ibias1.n35 1.05584
R662 ibias1.n97 ibias1.n16 1.03522
R663 ibias1.n18 ibias1.n21 1.03522
R664 ibias1.n98 ibias1.n24 1.03522
R665 ibias1.n34 ibias1.n31 1.03522
R666 ibias1.n55 ibias1.n30 0.9971
R667 ibias1.n67 ibias1.n26 0.972717
R668 ibias1.n30 ibias1.n43 0.955758
R669 ibias1.n41 ibias1.n40 0.955246
R670 ibias1.n53 ibias1.n52 0.922757
R671 ibias1.n38 ibias1.n37 0.363882
R672 ibias1.n96 ibias1.n79 0.90775
R673 ibias1.n96 ibias1.n69 0.90775
R674 ibias1.n81 ibias1.n80 0.90775
R675 ibias1.n80 ibias1.n82 0.90775
R676 ibias1.n84 ibias1.n83 0.90775
R677 ibias1.n83 ibias1.n85 0.90775
R678 ibias1.n77 ibias1.n86 0.90775
R679 ibias1.n57 ibias1.n56 0.837435
R680 ibias1.n68 ibias1.n58 0.837435
R681 ibias1.n100 ibias1.n54 0.80746
R682 ibias1.n94 ibias1.n12 0.761646
R683 ibias1.n74 ibias1.n24 0.75628
R684 ibias1.n58 ibias1.n4 1.45552
R685 ibias1.n57 ibias1.n7 1.45552
R686 ibias1.n10 ibias1.n26 1.45552
R687 threshold threshold.n21 33.5697
R688 threshold.n13 threshold.t28 4.95984
R689 threshold.t20 threshold.n12 4.95984
R690 threshold.t12 threshold.n11 4.95984
R691 threshold.t4 threshold.n10 4.95984
R692 threshold.n13 threshold.n20 10.3217
R693 threshold.n19 threshold.n12 9.193
R694 threshold.n17 threshold.n11 9.17925
R695 threshold.n21 threshold.n10 9.17375
R696 threshold.n5 threshold.n14 6.7505
R697 threshold.n18 threshold.n7 6.7505
R698 threshold.n20 threshold.n9 6.7505
R699 threshold.n8 threshold.t25 6.5653
R700 threshold.n6 threshold.t17 6.5653
R701 threshold.n4 threshold.t9 6.5653
R702 threshold.n15 threshold.t1 6.5653
R703 threshold.n16 threshold.t31 6.56117
R704 threshold.n9 threshold.t23 6.56117
R705 threshold.n7 threshold.t15 6.56117
R706 threshold.n5 threshold.t7 6.56117
R707 threshold.n0 threshold.t27 5.76367
R708 threshold.n1 threshold.t19 5.76367
R709 threshold.n2 threshold.t11 5.76367
R710 threshold.n3 threshold.t3 5.76367
R711 threshold.n0 threshold.t29 4.95984
R712 threshold.n0 threshold.t26 4.95984
R713 threshold.n16 threshold.t30 4.95984
R714 threshold.n8 threshold.t24 4.95984
R715 threshold.n9 threshold.t22 4.95984
R716 threshold.n1 threshold.t21 4.95984
R717 threshold.n1 threshold.t18 4.95984
R718 threshold.n6 threshold.t16 4.95984
R719 threshold.n7 threshold.t14 4.95984
R720 threshold.n2 threshold.t13 4.95984
R721 threshold.n2 threshold.t10 4.95984
R722 threshold.n4 threshold.t8 4.95984
R723 threshold.n5 threshold.t6 4.95984
R724 threshold.n3 threshold.t5 4.95984
R725 threshold.n3 threshold.t2 4.95984
R726 threshold.n15 threshold.t0 4.95984
R727 threshold.n13 threshold.n16 4.50559
R728 threshold.n10 threshold.n15 3.69984
R729 threshold.n8 threshold.n13 3.2895
R730 threshold.n12 threshold.n9 3.2895
R731 threshold.n6 threshold.n12 3.2895
R732 threshold.n11 threshold.n7 3.2895
R733 threshold.n4 threshold.n11 3.2895
R734 threshold.n10 threshold.n5 3.2895
R735 threshold.n5 threshold.n4 2.02196
R736 threshold.n10 threshold.n3 2.01713
R737 threshold.n11 threshold.n2 2.01713
R738 threshold.n12 threshold.n1 2.01713
R739 threshold.n13 threshold.n0 2.01713
R740 threshold.n7 threshold.n6 2.01153
R741 threshold.n9 threshold.n8 1.99641
R742 threshold.n20 threshold.n19 1.21446
R743 threshold.n18 threshold.n17 1.21006
R744 threshold.n21 threshold.n14 1.20918
R745 threshold.n17 threshold.n14 1.16166
R746 threshold.n19 threshold.n18 1.15462
R747 AVDD.n38 AVDD.n33 0.0347015
R748 AVDD.n41 AVDD.n33 0.073815
R749 AVDD.t4 AVDD.n41 0.0471077
R750 AVDD.t4 AVDD.n38 0.0275138
R751 AVDD.n41 AVDD.n36 0.0169644
R752 AVDD.n38 AVDD.n34 0.0732746
R753 AVDD.n206 AVDD.t0 1.79744
R754 AVDD.n90 AVDD.n1 0.113345
R755 AVDD.t3 AVDD.n53 1.44114
R756 AVDD.n20 AVDD.n84 0.0565017
R757 AVDD.n39 AVDD.n31 3.55407
R758 AVDD.n31 AVDD.n257 1.46961
R759 AVDD.n42 AVDD.n33 0.0249822
R760 AVDD.n268 AVDD.n37 1.522
R761 AVDD.n21 AVDD.n95 6.7512
R762 AVDD.t25 AVDD.n22 6.47664
R763 AVDD.n94 AVDD.t8 5.94546
R764 AVDD.n94 AVDD.t37 5.75538
R765 AVDD.t7 AVDD.n95 6.95669
R766 AVDD.n47 AVDD.n36 0.79229
R767 AVDD.n303 AVDD.n33 5.61281
R768 AVDD.n199 AVDD.t116 5.47994
R769 AVDD.n175 AVDD.t77 5.47994
R770 AVDD.n178 AVDD.t118 5.47994
R771 AVDD.n171 AVDD.t122 5.47994
R772 AVDD.n172 AVDD.t123 5.47994
R773 AVDD.n167 AVDD.t78 5.47994
R774 AVDD.n166 AVDD.t119 5.47994
R775 AVDD.n201 AVDD.t117 5.47994
R776 AVDD.n218 AVDD.t91 5.47994
R777 AVDD.n155 AVDD.t41 5.47994
R778 AVDD.n154 AVDD.t108 5.47994
R779 AVDD.n220 AVDD.t149 5.47994
R780 AVDD.n113 AVDD.t150 5.47994
R781 AVDD.n115 AVDD.t42 5.47994
R782 AVDD.n228 AVDD.t109 5.47994
R783 AVDD.n112 AVDD.t92 5.47994
R784 AVDD.n243 AVDD.t43 5.47994
R785 AVDD.n146 AVDD.t1 5.47994
R786 AVDD.n149 AVDD.t67 5.47994
R787 AVDD.n103 AVDD.t11 5.47994
R788 AVDD.n246 AVDD.t12 5.47994
R789 AVDD.n145 AVDD.t2 5.47994
R790 AVDD.n116 AVDD.t68 5.47994
R791 AVDD.n102 AVDD.t44 5.47994
R792 AVDD.n121 AVDD.t65 5.47994
R793 AVDD.n122 AVDD.t148 5.47994
R794 AVDD.n124 AVDD.t14 5.47994
R795 AVDD.n128 AVDD.t90 5.47994
R796 AVDD.n123 AVDD.t66 5.47994
R797 AVDD.n120 AVDD.t13 5.47994
R798 AVDD.n118 AVDD.t89 5.47994
R799 AVDD.n134 AVDD.t147 5.47994
R800 AVDD.n179 AVDD.t81 5.4798
R801 AVDD.n180 AVDD.t74 5.4798
R802 AVDD.n184 AVDD.t133 5.4798
R803 AVDD.n185 AVDD.t27 5.4798
R804 AVDD.n174 AVDD.t28 5.4798
R805 AVDD.n176 AVDD.t75 5.4798
R806 AVDD.n193 AVDD.t82 5.4798
R807 AVDD.n173 AVDD.t134 5.4798
R808 AVDD.n160 AVDD.t131 5.4798
R809 AVDD.n163 AVDD.t126 5.4798
R810 AVDD.n210 AVDD.t64 5.4798
R811 AVDD.n161 AVDD.t9 5.4798
R812 AVDD.n159 AVDD.t10 5.4798
R813 AVDD.n162 AVDD.t127 5.4798
R814 AVDD.n165 AVDD.t63 5.4798
R815 AVDD.n216 AVDD.t132 5.4798
R816 AVDD.n234 AVDD.t15 5.4798
R817 AVDD.n114 AVDD.t31 5.4798
R818 AVDD.n153 AVDD.t120 5.4798
R819 AVDD.n111 AVDD.t110 5.4798
R820 AVDD.n106 AVDD.t111 5.4798
R821 AVDD.n109 AVDD.t32 5.4798
R822 AVDD.n151 AVDD.t121 5.4798
R823 AVDD.n105 AVDD.t16 5.4798
R824 AVDD.n99 AVDD.t85 5.4798
R825 AVDD.n101 AVDD.t84 5.4798
R826 AVDD.n119 AVDD.t33 5.4798
R827 AVDD.n140 AVDD.t80 5.4798
R828 AVDD.n100 AVDD.t86 5.4798
R829 AVDD.n117 AVDD.t34 5.4798
R830 AVDD.n142 AVDD.t79 5.4798
R831 AVDD.n249 AVDD.t83 5.4798
R832 AVDD.n40 AVDD.n302 2.85461
R833 AVDD.n302 AVDD.n257 2.84889
R834 AVDD.n300 AVDD.n268 2.84878
R835 AVDD.t3 AVDD.n43 0.235846
R836 AVDD.n59 AVDD.n14 1.53156
R837 AVDD.n68 AVDD.n6 1.52789
R838 AVDD.n89 AVDD.n52 1.51032
R839 AVDD.n65 AVDD.n11 2.14045
R840 AVDD.n74 AVDD.n3 2.10185
R841 AVDD.n75 AVDD.n8 2.13402
R842 AVDD.n91 AVDD.n52 1.44823
R843 AVDD.n93 AVDD.n92 1.44823
R844 AVDD.n70 AVDD.n5 1.4386
R845 AVDD.n63 AVDD.n12 1.43677
R846 AVDD.n72 AVDD.n4 1.43439
R847 AVDD.n61 AVDD.n13 1.4331
R848 AVDD.n44 AVDD.n9 1.42775
R849 AVDD.n73 AVDD.n26 0.0565121
R850 AVDD.n77 AVDD.n10 1.42421
R851 AVDD.n81 AVDD.n17 1.36496
R852 AVDD.n46 AVDD.t3 0.235598
R853 AVDD.n57 AVDD.n14 1.42169
R854 AVDD.n88 AVDD.n87 1.42049
R855 AVDD.n66 AVDD.n6 1.41986
R856 AVDD.n7 AVDD.n56 1.41942
R857 AVDD.n54 AVDD.n15 1.41942
R858 AVDD.n86 AVDD.n85 1.41682
R859 AVDD.t3 AVDD.n45 0.234388
R860 AVDD.n16 AVDD.t3 0.90056
R861 AVDD.n89 AVDD.n88 1.4024
R862 AVDD.n87 AVDD.n86 1.3969
R863 AVDD.n66 AVDD.n7 1.38727
R864 AVDD.n57 AVDD.n15 1.38543
R865 AVDD.n67 AVDD.t3 1.44279
R866 AVDD.n27 AVDD.t3 0.667854
R867 AVDD.n77 AVDD.n9 1.37581
R868 AVDD.n17 AVDD.t3 0.168102
R869 AVDD.n68 AVDD.n5 1.37359
R870 AVDD.n61 AVDD.n12 1.37359
R871 AVDD.n71 AVDD.n27 0.111117
R872 AVDD.n79 AVDD.n10 1.37215
R873 AVDD.n59 AVDD.n13 1.36992
R874 AVDD.n92 AVDD.n91 1.36915
R875 AVDD.n70 AVDD.n4 1.36853
R876 AVDD.n26 AVDD.t3 0.890471
R877 AVDD.n8 AVDD.n44 1.29504
R878 AVDD.n182 AVDD.n179 1.19026
R879 AVDD.n186 AVDD.n184 1.19026
R880 AVDD.n125 AVDD.n122 1.19026
R881 AVDD.n128 AVDD.n127 1.19026
R882 AVDD.t49 AVDD.t115 1.19026
R883 AVDD.t54 AVDD.t35 1.19026
R884 AVDD.t107 AVDD.t30 1.19026
R885 AVDD.t45 AVDD.t20 1.19026
R886 AVDD.n85 AVDD.n30 1.31014
R887 AVDD.n72 AVDD.n3 1.2956
R888 AVDD.n63 AVDD.n11 1.29304
R889 AVDD.n188 AVDD.t0 3.48201
R890 AVDD.n28 AVDD.n43 2.01994
R891 AVDD.n82 AVDD.n45 2.05724
R892 AVDD.n51 AVDD.n25 0.0694179
R893 AVDD.n51 AVDD.n46 2.01721
R894 AVDD.n46 AVDD.n56 1.21039
R895 AVDD.n54 AVDD.n45 1.2116
R896 AVDD.n25 AVDD.t3 0.91893
R897 AVDD.n260 AVDD.t101 0.96146
R898 AVDD.n271 AVDD.t114 0.96146
R899 AVDD.t24 AVDD.n275 0.96146
R900 AVDD.t145 AVDD.n280 0.96146
R901 AVDD.n287 AVDD.t136 0.96146
R902 AVDD.n286 AVDD.t105 0.96146
R903 AVDD.t97 AVDD.n282 0.96146
R904 AVDD.t53 AVDD.n284 0.96146
R905 AVDD.t103 AVDD.n258 0.96146
R906 AVDD.t125 AVDD.n277 0.96146
R907 AVDD.t143 AVDD.n276 0.96146
R908 AVDD.t130 AVDD.n274 0.96146
R909 AVDD.t50 AVDD.n272 0.96146
R910 AVDD.t36 AVDD.n270 0.96146
R911 AVDD.t55 AVDD.n265 0.96146
R912 AVDD.t5 AVDD.n262 0.96146
R913 AVDD.t72 AVDD.n262 0.95706
R914 AVDD.t59 AVDD.n265 0.95706
R915 AVDD.n271 AVDD.t57 0.95706
R916 AVDD.n274 AVDD.t61 0.95706
R917 AVDD.n286 AVDD.t29 0.95706
R918 AVDD.t46 AVDD.n284 0.95706
R919 AVDD.t19 AVDD.n282 0.95706
R920 AVDD.n287 AVDD.t106 0.95706
R921 AVDD.t98 AVDD.n276 0.95706
R922 AVDD.t47 AVDD.n277 0.95706
R923 AVDD.n258 AVDD.t112 0.95706
R924 AVDD.n280 AVDD.t18 0.95706
R925 AVDD.n275 AVDD.t70 0.95706
R926 AVDD.n272 AVDD.t39 0.95706
R927 AVDD.n270 AVDD.t94 0.95706
R928 AVDD.n260 AVDD.t21 0.95706
R929 AVDD.n188 AVDD.n187 0.94626
R930 AVDD.n297 AVDD.n23 0.94626
R931 AVDD.t22 AVDD.t21 0.90866
R932 AVDD.t57 AVDD.t58 0.90866
R933 AVDD.t70 AVDD.t71 0.90866
R934 AVDD.t61 AVDD.t62 0.90866
R935 AVDD.t18 AVDD.t17 0.90866
R936 AVDD.t19 AVDD.t20 0.90866
R937 AVDD.t106 AVDD.t107 0.90866
R938 AVDD.t52 AVDD.t98 0.90866
R939 AVDD.t48 AVDD.t47 0.90866
R940 AVDD.t112 AVDD.t113 0.90866
R941 AVDD.t39 AVDD.t23 0.90866
R942 AVDD.t94 AVDD.t95 0.90866
R943 AVDD.t59 AVDD.t6 0.90866
R944 AVDD.t72 AVDD.t73 0.90866
R945 AVDD.t5 AVDD.t6 0.90778
R946 AVDD.t35 AVDD.t36 0.90778
R947 AVDD.t49 AVDD.t50 0.90778
R948 AVDD.t58 AVDD.t130 0.90778
R949 AVDD.t62 AVDD.t143 0.90778
R950 AVDD.t145 AVDD.t73 0.90778
R951 AVDD.t52 AVDD.t53 0.90778
R952 AVDD.t48 AVDD.t97 0.90778
R953 AVDD.t113 AVDD.t136 0.90778
R954 AVDD.t17 AVDD.t105 0.90778
R955 AVDD.t125 AVDD.t71 0.90778
R956 AVDD.t24 AVDD.t23 0.90778
R957 AVDD.t95 AVDD.t101 0.90778
R958 AVDD.t22 AVDD.t103 0.90778
R959 AVDD.n22 AVDD.n21 0.9005
R960 AVDD.n126 AVDD.n22 0.9005
R961 AVDD.n131 AVDD.n22 0.9005
R962 AVDD.n137 AVDD.n22 0.9005
R963 AVDD.n253 AVDD.n252 0.9005
R964 AVDD.n104 AVDD.n96 0.9005
R965 AVDD.n240 AVDD.n239 0.9005
R966 AVDD.n238 AVDD.n237 0.9005
R967 AVDD.n225 AVDD.n224 0.9005
R968 AVDD.n223 AVDD.n222 0.9005
R969 AVDD.n213 AVDD.n157 0.9005
R970 AVDD.n205 AVDD.n204 0.9005
R971 AVDD.n196 AVDD.n169 0.9005
R972 AVDD.n190 AVDD.n189 0.9005
R973 AVDD.n23 AVDD.t76 0.9005
R974 AVDD.n299 AVDD.n298 0.9005
R975 AVDD.n269 AVDD.n23 0.9005
R976 AVDD.n273 AVDD.n23 0.9005
R977 AVDD.n267 AVDD.n264 0.9005
R978 AVDD.n266 AVDD.n259 0.9005
R979 AVDD.n261 AVDD.n255 0.9005
R980 AVDD.n278 AVDD.n256 0.9005
R981 AVDD.n279 AVDD.n296 0.9005
R982 AVDD.n295 AVDD.n294 0.9005
R983 AVDD.n283 AVDD.n293 0.9005
R984 AVDD.n292 AVDD.n291 0.9005
R985 AVDD.n288 AVDD.n285 0.9005
R986 AVDD.n289 AVDD.n290 0.9005
R987 AVDD.n187 AVDD.n182 0.8013
R988 AVDD.n297 AVDD.t49 0.8013
R989 AVDD.n126 AVDD.n125 0.75906
R990 AVDD.n289 AVDD.t107 0.75906
R991 AVDD.n127 AVDD.n126 0.75554
R992 AVDD.t20 AVDD.n289 0.75554
R993 AVDD.n29 AVDD.n28 0.754304
R994 AVDD.n93 AVDD.n48 0.7505
R995 AVDD.n91 AVDD.n90 0.7505
R996 AVDD.n24 AVDD.n89 0.7505
R997 AVDD.n87 AVDD.n53 0.7505
R998 AVDD.n85 AVDD.n84 0.7505
R999 AVDD.n73 AVDD.n72 0.7505
R1000 AVDD.n71 AVDD.n70 0.7505
R1001 AVDD.n69 AVDD.n68 0.7505
R1002 AVDD.n67 AVDD.n66 0.7505
R1003 AVDD.n56 AVDD.n50 0.7505
R1004 AVDD.n64 AVDD.n63 0.7505
R1005 AVDD.n62 AVDD.n61 0.7505
R1006 AVDD.n60 AVDD.n59 0.7505
R1007 AVDD.n58 AVDD.n57 0.7505
R1008 AVDD.n55 AVDD.n54 0.7505
R1009 AVDD.n80 AVDD.n79 0.7505
R1010 AVDD.n78 AVDD.n77 0.7505
R1011 AVDD.n76 AVDD.n44 0.7505
R1012 AVDD.n241 AVDD.n103 0.74762
R1013 AVDD.n243 AVDD.n242 0.74762
R1014 AVDD.n221 AVDD.n220 0.74762
R1015 AVDD.n219 AVDD.n218 0.74762
R1016 AVDD.n197 AVDD.n171 0.74762
R1017 AVDD.n199 AVDD.n198 0.74762
R1018 AVDD.n195 AVDD.n175 0.74762
R1019 AVDD.n194 AVDD.n178 0.74762
R1020 AVDD.n158 AVDD.n155 0.74762
R1021 AVDD.n164 AVDD.n154 0.74762
R1022 AVDD.n146 AVDD.n107 0.74762
R1023 AVDD.n150 AVDD.n149 0.74762
R1024 AVDD.n135 AVDD.n134 0.74762
R1025 AVDD.n136 AVDD.n121 0.74762
R1026 AVDD.n138 AVDD.n120 0.74762
R1027 AVDD.n139 AVDD.n118 0.74762
R1028 AVDD.n250 AVDD.n249 0.74674
R1029 AVDD.n236 AVDD.n111 0.74674
R1030 AVDD.n235 AVDD.n234 0.74674
R1031 AVDD.n214 AVDD.n161 0.74674
R1032 AVDD.n215 AVDD.n160 0.74674
R1033 AVDD.n185 AVDD.n181 0.74674
R1034 AVDD.n192 AVDD.n179 0.74674
R1035 AVDD.n191 AVDD.n180 0.74674
R1036 AVDD.n184 AVDD.n183 0.74674
R1037 AVDD.n212 AVDD.n163 0.74674
R1038 AVDD.n211 AVDD.n210 0.74674
R1039 AVDD.n114 AVDD.n110 0.74674
R1040 AVDD.n153 AVDD.n152 0.74674
R1041 AVDD.n251 AVDD.n99 0.74674
R1042 AVDD.n117 AVDD.n98 0.74674
R1043 AVDD.n142 AVDD.n141 0.74674
R1044 AVDD.t29 AVDD.t30 0.74674
R1045 AVDD.t46 AVDD.t45 0.74674
R1046 AVDD.n244 AVDD.n102 0.74586
R1047 AVDD.n246 AVDD.n245 0.74586
R1048 AVDD.n217 AVDD.n112 0.74586
R1049 AVDD.n156 AVDD.n113 0.74586
R1050 AVDD.n202 AVDD.n201 0.74586
R1051 AVDD.n203 AVDD.n172 0.74586
R1052 AVDD.n170 AVDD.n167 0.74586
R1053 AVDD.n177 AVDD.n166 0.74586
R1054 AVDD.n226 AVDD.n115 0.74586
R1055 AVDD.n228 AVDD.n227 0.74586
R1056 AVDD.n147 AVDD.n145 0.74586
R1057 AVDD.n148 AVDD.n116 0.74586
R1058 AVDD.n132 AVDD.n123 0.74586
R1059 AVDD.n133 AVDD.n122 0.74586
R1060 AVDD.n130 AVDD.n124 0.74586
R1061 AVDD.n129 AVDD.n128 0.74586
R1062 AVDD.t114 AVDD.t115 0.74586
R1063 AVDD.t55 AVDD.t54 0.74586
R1064 AVDD.n242 AVDD.n105 0.7441
R1065 AVDD.n241 AVDD.n106 0.7441
R1066 AVDD.n219 AVDD.n216 0.7441
R1067 AVDD.n221 AVDD.n159 0.7441
R1068 AVDD.n198 AVDD.n173 0.7441
R1069 AVDD.n197 AVDD.n174 0.7441
R1070 AVDD.n195 AVDD.n176 0.7441
R1071 AVDD.n194 AVDD.n193 0.7441
R1072 AVDD.n162 AVDD.n158 0.7441
R1073 AVDD.n165 AVDD.n164 0.7441
R1074 AVDD.n109 AVDD.n107 0.7441
R1075 AVDD.n151 AVDD.n150 0.7441
R1076 AVDD.n136 AVDD.n100 0.7441
R1077 AVDD.n135 AVDD.n101 0.7441
R1078 AVDD.n138 AVDD.n119 0.7441
R1079 AVDD.n140 AVDD.n139 0.7441
R1080 AVDD.n187 AVDD.n186 0.7133
R1081 AVDD.t35 AVDD.n297 0.7133
R1082 AVDD.n60 AVDD.n58 0.541172
R1083 AVDD.n81 AVDD.n80 0.541172
R1084 AVDD.n64 AVDD.n62 0.527444
R1085 AVDD.n78 AVDD.n76 0.527444
R1086 AVDD.n58 AVDD.n55 0.526916
R1087 AVDD.t3 AVDD.n0 0.626723
R1088 AVDD.n16 AVDD.n81 0.603942
R1089 AVDD.n62 AVDD.n60 0.52674
R1090 AVDD.n80 AVDD.n78 0.52674
R1091 AVDD.n245 AVDD.n244 0.51442
R1092 AVDD.n148 AVDD.n147 0.51442
R1093 AVDD.n242 AVDD.n241 0.51442
R1094 AVDD.n150 AVDD.n107 0.51442
R1095 AVDD.n236 AVDD.n235 0.51442
R1096 AVDD.n152 AVDD.n110 0.51442
R1097 AVDD.n217 AVDD.n156 0.51442
R1098 AVDD.n227 AVDD.n226 0.51442
R1099 AVDD.n221 AVDD.n219 0.51442
R1100 AVDD.n164 AVDD.n158 0.51442
R1101 AVDD.n215 AVDD.n214 0.51442
R1102 AVDD.n212 AVDD.n211 0.51442
R1103 AVDD.n203 AVDD.n202 0.51442
R1104 AVDD.n177 AVDD.n170 0.51442
R1105 AVDD.n198 AVDD.n197 0.51442
R1106 AVDD.n195 AVDD.n194 0.51442
R1107 AVDD.n183 AVDD.n181 0.51442
R1108 AVDD.n192 AVDD.n191 0.51442
R1109 AVDD.n251 AVDD.n250 0.51442
R1110 AVDD.n141 AVDD.n98 0.51442
R1111 AVDD.n136 AVDD.n135 0.51442
R1112 AVDD.n139 AVDD.n138 0.51442
R1113 AVDD.n133 AVDD.n132 0.51442
R1114 AVDD.n130 AVDD.n129 0.51442
R1115 AVDD.t94 AVDD.t59 0.51442
R1116 AVDD.t57 AVDD.t39 0.51442
R1117 AVDD.n265 AVDD.n270 0.51442
R1118 AVDD.n272 AVDD.n271 0.51442
R1119 AVDD.t36 AVDD.t55 0.51442
R1120 AVDD.t114 AVDD.t50 0.51442
R1121 AVDD.t101 AVDD.t5 0.51442
R1122 AVDD.t130 AVDD.t24 0.51442
R1123 AVDD.n262 AVDD.n260 0.51442
R1124 AVDD.n275 AVDD.n274 0.51442
R1125 AVDD.t21 AVDD.t72 0.51442
R1126 AVDD.t61 AVDD.t70 0.51442
R1127 AVDD.t103 AVDD.t145 0.51442
R1128 AVDD.t143 AVDD.t125 0.51442
R1129 AVDD.n280 AVDD.n258 0.51442
R1130 AVDD.n276 AVDD.n277 0.51442
R1131 AVDD.t112 AVDD.t18 0.51442
R1132 AVDD.t98 AVDD.t47 0.51442
R1133 AVDD.t105 AVDD.t136 0.51442
R1134 AVDD.t53 AVDD.t97 0.51442
R1135 AVDD.n287 AVDD.n286 0.51442
R1136 AVDD.n284 AVDD.n282 0.51442
R1137 AVDD.t29 AVDD.t106 0.51442
R1138 AVDD.t19 AVDD.t46 0.51442
R1139 AVDD.n93 AVDD.n43 1.20483
R1140 AVDD.n82 AVDD.n0 0.496116
R1141 AVDD.n49 AVDD.n18 0.496116
R1142 AVDD.n83 AVDD.n30 2.09575
R1143 AVDD.n254 AVDD.n97 0.4505
R1144 AVDD.n231 AVDD.n108 0.4505
R1145 AVDD.n207 AVDD.n206 0.4505
R1146 AVDD.n263 AVDD.n300 0.4505
R1147 AVDD.n302 AVDD.n301 0.4505
R1148 AVDD.n281 AVDD.n39 0.4505
R1149 AVDD.n132 AVDD.n131 0.38066
R1150 AVDD.n273 AVDD.t36 0.38066
R1151 AVDD.n245 AVDD.n104 0.37978
R1152 AVDD.n241 AVDD.n240 0.37978
R1153 AVDD.n237 AVDD.n236 0.37978
R1154 AVDD.n225 AVDD.n156 0.37978
R1155 AVDD.n222 AVDD.n221 0.37978
R1156 AVDD.n214 AVDD.n213 0.37978
R1157 AVDD.n204 AVDD.n203 0.37978
R1158 AVDD.n197 AVDD.n196 0.37978
R1159 AVDD.n190 AVDD.n181 0.37978
R1160 AVDD.n252 AVDD.n251 0.37978
R1161 AVDD.n137 AVDD.n136 0.37978
R1162 AVDD.n298 AVDD.t94 0.37978
R1163 AVDD.n270 AVDD.n269 0.37978
R1164 AVDD.t101 AVDD.n264 0.37978
R1165 AVDD.n260 AVDD.n259 0.37978
R1166 AVDD.t21 AVDD.n261 0.37978
R1167 AVDD.n278 AVDD.t103 0.37978
R1168 AVDD.n258 AVDD.n279 0.37978
R1169 AVDD.n294 AVDD.t112 0.37978
R1170 AVDD.n283 AVDD.t136 0.37978
R1171 AVDD.n291 AVDD.n287 0.37978
R1172 AVDD.t106 AVDD.n288 0.37978
R1173 AVDD.n147 AVDD.n104 0.37802
R1174 AVDD.n240 AVDD.n107 0.37802
R1175 AVDD.n237 AVDD.n110 0.37802
R1176 AVDD.n226 AVDD.n225 0.37802
R1177 AVDD.n222 AVDD.n158 0.37802
R1178 AVDD.n213 AVDD.n212 0.37802
R1179 AVDD.n204 AVDD.n170 0.37802
R1180 AVDD.n196 AVDD.n195 0.37802
R1181 AVDD.n191 AVDD.n190 0.37802
R1182 AVDD.n252 AVDD.n98 0.37802
R1183 AVDD.n138 AVDD.n137 0.37802
R1184 AVDD.n298 AVDD.t39 0.37802
R1185 AVDD.n269 AVDD.n272 0.37802
R1186 AVDD.t24 AVDD.n264 0.37802
R1187 AVDD.n275 AVDD.n259 0.37802
R1188 AVDD.t70 AVDD.n261 0.37802
R1189 AVDD.t125 AVDD.n278 0.37802
R1190 AVDD.n279 AVDD.n277 0.37802
R1191 AVDD.n294 AVDD.t47 0.37802
R1192 AVDD.t97 AVDD.n283 0.37802
R1193 AVDD.n291 AVDD.n282 0.37802
R1194 AVDD.n288 AVDD.t19 0.37802
R1195 AVDD.n131 AVDD.n130 0.37714
R1196 AVDD.t50 AVDD.n273 0.37714
R1197 AVDD.n19 AVDD.n48 0.0778029
R1198 AVDD.n33 AVDD.n32 0.0309988
R1199 AVDD.n51 AVDD.n49 0.3613
R1200 AVDD.n82 AVDD.n51 0.3613
R1201 AVDD.n83 AVDD.n0 0.3613
R1202 AVDD.n19 AVDD.t3 0.452218
R1203 AVDD.n74 AVDD.n65 0.3613
R1204 AVDD.n83 AVDD.n18 0.3613
R1205 AVDD.n28 AVDD.n2 0.959654
R1206 AVDD.n75 AVDD.n74 0.3613
R1207 AVDD.n20 AVDD.t3 0.890313
R1208 AVDD.n33 AVDD.n31 0.0486567
R1209 AVDD.n42 AVDD.n47 2.31464
R1210 AVDD.n37 AVDD.t76 2.52918
R1211 AVDD.n32 AVDD.n40 1.45209
R1212 AVDD.n35 AVDD.n303 1.65428
R1213 AVDD.n30 AVDD.t3 0.146578
R1214 AVDD.t3 AVDD.n11 0.146536
R1215 AVDD.t3 AVDD.n3 0.145816
R1216 AVDD.t3 AVDD.n8 0.144702
R1217 AVDD.n65 AVDD.n64 0.278052
R1218 AVDD.n76 AVDD.n75 0.278052
R1219 AVDD.n2 AVDD.n18 0.626483
R1220 AVDD.n303 AVDD.n40 0.275759
R1221 AVDD.n108 AVDD.t0 1.79947
R1222 AVDD.t3 AVDD.n1 0.668051
R1223 AVDD.n34 AVDD.n35 0.00966064
R1224 AVDD.n36 AVDD.n34 0.0756078
R1225 AVDD.n37 AVDD.n36 0.0303223
R1226 AVDD.n257 AVDD.n42 1.53102
R1227 AVDD.n1 AVDD.n24 0.115746
R1228 AVDD.n69 AVDD.n67 0.246916
R1229 AVDD.n24 AVDD.n53 0.240974
R1230 AVDD.n27 AVDD.n69 0.112882
R1231 AVDD.n90 AVDD.n48 0.240734
R1232 AVDD.n67 AVDD.n50 0.240734
R1233 AVDD.n84 AVDD.n53 0.240573
R1234 AVDD.n73 AVDD.n71 0.240573
R1235 AVDD.n245 AVDD.n103 0.21434
R1236 AVDD.n244 AVDD.n243 0.21434
R1237 AVDD.n220 AVDD.n156 0.21434
R1238 AVDD.n218 AVDD.n217 0.21434
R1239 AVDD.n203 AVDD.n171 0.21434
R1240 AVDD.n202 AVDD.n199 0.21434
R1241 AVDD.n175 AVDD.n170 0.21434
R1242 AVDD.n178 AVDD.n177 0.21434
R1243 AVDD.n226 AVDD.n155 0.21434
R1244 AVDD.n227 AVDD.n154 0.21434
R1245 AVDD.n147 AVDD.n146 0.21434
R1246 AVDD.n149 AVDD.n148 0.21434
R1247 AVDD.n134 AVDD.n133 0.21434
R1248 AVDD.n132 AVDD.n121 0.21434
R1249 AVDD.n130 AVDD.n120 0.21434
R1250 AVDD.n129 AVDD.n118 0.21434
R1251 AVDD.n235 AVDD.n105 0.21346
R1252 AVDD.n236 AVDD.n106 0.21346
R1253 AVDD.n216 AVDD.n215 0.21346
R1254 AVDD.n214 AVDD.n159 0.21346
R1255 AVDD.n183 AVDD.n173 0.21346
R1256 AVDD.n181 AVDD.n174 0.21346
R1257 AVDD.n191 AVDD.n176 0.21346
R1258 AVDD.n193 AVDD.n192 0.21346
R1259 AVDD.n212 AVDD.n162 0.21346
R1260 AVDD.n211 AVDD.n165 0.21346
R1261 AVDD.n110 AVDD.n109 0.21346
R1262 AVDD.n152 AVDD.n151 0.21346
R1263 AVDD.n251 AVDD.n100 0.21346
R1264 AVDD.n250 AVDD.n101 0.21346
R1265 AVDD.n119 AVDD.n98 0.21346
R1266 AVDD.n141 AVDD.n140 0.21346
R1267 AVDD.n82 AVDD.n55 0.210996
R1268 AVDD.n16 AVDD.n49 0.123047
R1269 AVDD.n29 AVDD.t25 0.18464
R1270 AVDD.n290 AVDD.n33 3.52484
R1271 AVDD.n249 AVDD.n248 0.16242
R1272 AVDD.n248 AVDD.n102 0.16242
R1273 AVDD.n247 AVDD.n246 0.16242
R1274 AVDD.n232 AVDD.n111 0.16242
R1275 AVDD.n234 AVDD.n233 0.16242
R1276 AVDD.n233 AVDD.n112 0.16242
R1277 AVDD.n232 AVDD.n113 0.16242
R1278 AVDD.n168 AVDD.n161 0.16242
R1279 AVDD.n200 AVDD.n160 0.16242
R1280 AVDD.n201 AVDD.n200 0.16242
R1281 AVDD.n172 AVDD.n168 0.16242
R1282 AVDD.n186 AVDD.n185 0.16242
R1283 AVDD.n182 AVDD.n180 0.16242
R1284 AVDD.n208 AVDD.n167 0.16242
R1285 AVDD.n209 AVDD.n166 0.16242
R1286 AVDD.n208 AVDD.n163 0.16242
R1287 AVDD.n210 AVDD.n209 0.16242
R1288 AVDD.n230 AVDD.n115 0.16242
R1289 AVDD.n229 AVDD.n228 0.16242
R1290 AVDD.n230 AVDD.n114 0.16242
R1291 AVDD.n229 AVDD.n153 0.16242
R1292 AVDD.n145 AVDD.n144 0.16242
R1293 AVDD.n143 AVDD.n116 0.16242
R1294 AVDD.n247 AVDD.n99 0.16242
R1295 AVDD.n125 AVDD.n123 0.16242
R1296 AVDD.n127 AVDD.n124 0.16242
R1297 AVDD.n144 AVDD.n117 0.16242
R1298 AVDD.n143 AVDD.n142 0.16242
R1299 AVDD.n248 AVDD.n247 0.148178
R1300 AVDD.n144 AVDD.n143 0.148178
R1301 AVDD.n233 AVDD.n232 0.148178
R1302 AVDD.n230 AVDD.n229 0.148178
R1303 AVDD.n200 AVDD.n168 0.148178
R1304 AVDD.n209 AVDD.n208 0.148178
R1305 AVDD.t6 AVDD.t95 0.148178
R1306 AVDD.t58 AVDD.t23 0.148178
R1307 AVDD.t22 AVDD.t73 0.148178
R1308 AVDD.t62 AVDD.t71 0.148178
R1309 AVDD.t17 AVDD.t113 0.148178
R1310 AVDD.t48 AVDD.t52 0.148178
R1311 AVDD.n20 AVDD.n83 0.0864641
R1312 AVDD.n74 AVDD.n26 0.0864537
R1313 AVDD.n32 AVDD.n39 3.58033
R1314 AVDD.n205 AVDD.n169 0.13162
R1315 AVDD.n224 AVDD.n223 0.13162
R1316 AVDD.n239 AVDD.n96 0.13162
R1317 AVDD.n293 AVDD.n292 0.13162
R1318 AVDD.n296 AVDD.n256 0.13162
R1319 AVDD.n267 AVDD.n266 0.13162
R1320 AVDD.n189 AVDD.n169 0.13107
R1321 AVDD.n223 AVDD.n157 0.13107
R1322 AVDD.n239 AVDD.n238 0.13107
R1323 AVDD.n292 AVDD.n285 0.13107
R1324 AVDD.n296 AVDD.n295 0.13107
R1325 AVDD.n266 AVDD.n255 0.13107
R1326 AVDD.n189 AVDD.n188 0.12491
R1327 AVDD.n290 AVDD.n285 0.12491
R1328 AVDD.n25 AVDD.n50 0.0449268
R1329 AVDD.n28 AVDD.n19 0.03508
R1330 AVDD.n247 AVDD.n97 0.109489
R1331 AVDD.n232 AVDD.n231 0.109489
R1332 AVDD.n207 AVDD.n168 0.109489
R1333 AVDD.t95 AVDD.n263 0.109489
R1334 AVDD.n301 AVDD.t22 0.109489
R1335 AVDD.t113 AVDD.n281 0.109489
R1336 AVDD.n144 AVDD.n97 0.108983
R1337 AVDD.n231 AVDD.n230 0.108983
R1338 AVDD.n208 AVDD.n207 0.108983
R1339 AVDD.n263 AVDD.t23 0.108983
R1340 AVDD.n301 AVDD.t71 0.108983
R1341 AVDD.n281 AVDD.t48 0.108983
R1342 AVDD.n254 AVDD.n96 0.09884
R1343 AVDD.n300 AVDD.n267 0.09884
R1344 AVDD.n206 AVDD.n205 0.09565
R1345 AVDD.n293 AVDD.n39 0.09565
R1346 AVDD.n238 AVDD.n108 0.09466
R1347 AVDD.n302 AVDD.n255 0.09466
R1348 AVDD.n224 AVDD.n108 0.09455
R1349 AVDD.n302 AVDD.n256 0.09455
R1350 AVDD.n206 AVDD.n157 0.09367
R1351 AVDD.n295 AVDD.n39 0.09367
R1352 AVDD.n254 AVDD.n253 0.09037
R1353 AVDD.n300 AVDD.n299 0.09037
R1354 AVDD.n21 AVDD.t0 2.61569
R1355 AVDD.n254 AVDD.t0 1.82175
R1356 AVDD.n86 AVDD.t3 0.073002
R1357 AVDD.n88 AVDD.t3 0.073002
R1358 AVDD.n52 AVDD.t3 0.073002
R1359 AVDD.n92 AVDD.t3 0.073002
R1360 AVDD.t3 AVDD.n15 0.0704766
R1361 AVDD.t3 AVDD.n13 0.0704766
R1362 AVDD.t3 AVDD.n12 0.0704766
R1363 AVDD.t3 AVDD.n7 0.0704766
R1364 AVDD.t3 AVDD.n5 0.0704766
R1365 AVDD.t3 AVDD.n14 0.0700182
R1366 AVDD.t3 AVDD.n6 0.0700182
R1367 AVDD.t3 AVDD.n4 0.0700182
R1368 AVDD.t3 AVDD.n10 0.0687585
R1369 AVDD.n95 AVDD.n94 0.0654
R1370 AVDD.n47 AVDD.n268 0.845749
R1371 AVDD.n35 AVDD.n300 3.57893
R1372 AVDD.n29 AVDD.n23 1.30777
R1373 AVDD.t3 AVDD.n2 0.433775
R1374 AVDD.n299 AVDD.n23 0.41828
R1375 AVDD.n253 AVDD.n22 0.41828
R1376 AVDD.t3 AVDD.n9 0.398914
R1377 AVDD.n17 AVDD.n79 1.69567
R1378 AVDD AVDD.n0 0.0005
R1379 AVSS.n399 AVSS.n398 30105.9
R1380 AVSS.n399 AVSS.n42 30105.9
R1381 AVSS.n8 AVSS.n121 9897.7
R1382 AVSS.n42 AVSS.n350 1850.14
R1383 AVSS.n398 AVSS.n350 1848.34
R1384 AVSS.t28 AVSS.t26 1030.48
R1385 AVSS.t140 AVSS.t158 1030.48
R1386 AVSS.t27 AVSS.t25 1026.96
R1387 AVSS.t95 AVSS.t89 1026.96
R1388 AVSS.t89 AVSS.t96 1026.96
R1389 AVSS.t139 AVSS.t157 1026.96
R1390 AVSS.t189 AVSS.t190 1026.96
R1391 AVSS.t190 AVSS.t191 1026.96
R1392 AVSS.t26 AVSS.t27 1021.69
R1393 AVSS.t158 AVSS.t139 1021.69
R1394 AVSS.n6 AVSS.t25 927.409
R1395 AVSS.t157 AVSS.n8 927.409
R1396 AVSS.t191 AVSS.n4 879.928
R1397 AVSS.n397 AVSS.t95 877.491
R1398 AVSS.n397 AVSS.t189 877.491
R1399 AVSS.t87 AVSS.n40 875.734
R1400 AVSS.t188 AVSS.n396 875.734
R1401 AVSS.n20 AVSS.n42 851.688
R1402 AVSS.n123 AVSS.t28 830.013
R1403 AVSS.n395 AVSS.t140 830.013
R1404 AVSS.n398 AVSS.n4 825.308
R1405 AVSS.n123 AVSS.n40 302.462
R1406 AVSS.n396 AVSS.n395 302.462
R1407 AVSS.n380 AVSS.n379 184.365
R1408 AVSS.n397 AVSS.t87 149.472
R1409 AVSS.n397 AVSS.t188 149.472
R1410 AVSS.n6 AVSS.n20 45.0939
R1411 AVSS.t29 AVSS.n58 0.160916
R1412 AVSS.n43 AVSS.t137 0.155631
R1413 AVSS.n4 AVSS.n8 43.6943
R1414 AVSS.n14 AVSS.n6 0.0557763
R1415 AVSS.t93 AVSS.n66 8.36473
R1416 AVSS.t165 AVSS.n4 8.24273
R1417 AVSS.t103 AVSS.n20 9.57294
R1418 AVSS.t167 AVSS.n4 9.38712
R1419 AVSS.n32 AVSS.n8 20.3933
R1420 AVSS.n399 AVSS.n135 19.3263
R1421 AVSS.n400 AVSS.n399 19.3263
R1422 AVSS.t30 AVSS.n29 9.71539
R1423 AVSS.n397 AVSS.n66 18.1745
R1424 AVSS.t138 AVSS.n8 9.54977
R1425 AVSS.n4 AVSS.n23 2.8575
R1426 AVSS.n74 AVSS.n8 1.07367
R1427 AVSS.n8 AVSS.n64 0.654668
R1428 AVSS.n68 AVSS.n8 1.07368
R1429 AVSS.n73 AVSS.n8 1.07423
R1430 AVSS.n70 AVSS.n8 1.3406
R1431 AVSS.n118 AVSS.n8 1.71672
R1432 AVSS.n44 AVSS.n8 0.654294
R1433 AVSS.n439 AVSS.n8 17.0005
R1434 AVSS.n445 AVSS.n8 17.0005
R1435 AVSS.n449 AVSS.n8 17.0005
R1436 AVSS.n455 AVSS.n8 17.0005
R1437 AVSS.n457 AVSS.n8 17.0005
R1438 AVSS.n465 AVSS.n8 17.0005
R1439 AVSS.n4 AVSS.n65 0.65415
R1440 AVSS.n4 AVSS.n486 17.0005
R1441 AVSS.n4 AVSS.n194 17.0005
R1442 AVSS.n4 AVSS.n222 17.0005
R1443 AVSS.n4 AVSS.n196 17.0005
R1444 AVSS.n4 AVSS.n219 17.0005
R1445 AVSS.n4 AVSS.n199 17.0005
R1446 AVSS.n4 AVSS.n217 17.0005
R1447 AVSS.n4 AVSS.n200 17.0005
R1448 AVSS.n4 AVSS.n216 17.0005
R1449 AVSS.n4 AVSS.n140 17.0005
R1450 AVSS.n104 AVSS.n378 5.47081
R1451 AVSS.n108 AVSS.n374 4.77796
R1452 AVSS.n46 AVSS.n103 2.88405
R1453 AVSS.n103 AVSS.n366 2.73594
R1454 AVSS.n46 AVSS.n142 8.49861
R1455 AVSS.n107 AVSS.n371 5.95115
R1456 AVSS.n46 AVSS.n105 2.88405
R1457 AVSS.n105 AVSS.n370 5.47081
R1458 AVSS.n106 AVSS.n367 2.73594
R1459 AVSS.n46 AVSS.n141 8.49836
R1460 AVSS.n46 AVSS.n102 2.88405
R1461 AVSS.n102 AVSS.n368 5.47081
R1462 AVSS.n364 AVSS.n111 6.00451
R1463 AVSS.n46 AVSS.n109 4.30658
R1464 AVSS.n51 AVSS.n361 5.47081
R1465 AVSS.n54 AVSS.n359 4.77796
R1466 AVSS.n47 AVSS.n49 2.88405
R1467 AVSS.n49 AVSS.n349 2.73594
R1468 AVSS.n53 AVSS.n357 5.47081
R1469 AVSS.n47 AVSS.n48 2.2975
R1470 AVSS.n48 AVSS.n356 6.64388
R1471 AVSS.n47 AVSS.n52 2.88405
R1472 AVSS.n52 AVSS.n355 5.47081
R1473 AVSS.n47 AVSS.n138 8.49776
R1474 AVSS.n47 AVSS.n50 2.88405
R1475 AVSS.n50 AVSS.n353 5.47081
R1476 AVSS.n55 AVSS.n363 6.00451
R1477 AVSS.n47 AVSS.n136 8.49925
R1478 AVSS.n47 AVSS.n137 8.49801
R1479 AVSS.n6 AVSS.n434 17.0005
R1480 AVSS.n6 AVSS.n440 17.0005
R1481 AVSS.n6 AVSS.n444 17.0005
R1482 AVSS.n6 AVSS.n450 17.0005
R1483 AVSS.n6 AVSS.n454 17.0005
R1484 AVSS.n6 AVSS.n458 17.0005
R1485 AVSS.n485 AVSS.n20 17.0005
R1486 AVSS.n20 AVSS.n239 17.0005
R1487 AVSS.n20 AVSS.n242 17.0005
R1488 AVSS.n20 AVSS.n244 17.0005
R1489 AVSS.n20 AVSS.n248 17.0005
R1490 AVSS.n20 AVSS.n251 17.0005
R1491 AVSS.n20 AVSS.n140 17.0005
R1492 AVSS.n20 AVSS.n254 17.0005
R1493 AVSS.n6 AVSS.n15 1.71715
R1494 AVSS.n117 AVSS.n6 1.34058
R1495 AVSS.n4 AVSS.n139 1.71723
R1496 AVSS.n430 AVSS.n6 17.0005
R1497 AVSS.n6 AVSS.n21 0.206452
R1498 AVSS.n115 AVSS.n6 1.34058
R1499 AVSS.n20 AVSS.n119 6.13465
R1500 AVSS.t91 AVSS.n119 4.32574
R1501 AVSS.t135 AVSS.n8 9.35247
R1502 AVSS.n58 AVSS.n29 9.08037
R1503 AVSS.n8 AVSS.n43 8.92324
R1504 AVSS.t102 AVSS.n20 8.17438
R1505 AVSS.n29 AVSS.t32 8.16631
R1506 AVSS.n23 AVSS.t163 6.46505
R1507 AVSS.n8 AVSS.t136 8.05562
R1508 AVSS.t166 AVSS.n4 8.05497
R1509 AVSS.n397 AVSS.n119 14.6569
R1510 AVSS.n397 AVSS.n23 6.66031
R1511 AVSS.n377 AVSS.t132 9.75972
R1512 AVSS.n362 AVSS.t4 9.75755
R1513 AVSS.n401 AVSS.n350 9.24842
R1514 AVSS.n257 AVSS.n3 8.70472
R1515 AVSS.n380 AVSS.n4 0.107057
R1516 AVSS.n379 AVSS.n46 0.737984
R1517 AVSS.n400 AVSS.n47 0.737417
R1518 AVSS.n401 AVSS.n47 0.738226
R1519 AVSS.t96 AVSS.n20 879.929
R1520 AVSS.n29 AVSS.n121 0.196315
R1521 AVSS.n377 AVSS.n375 8.5005
R1522 AVSS.n377 AVSS.n366 8.5005
R1523 AVSS.n377 AVSS.n372 8.5005
R1524 AVSS.n377 AVSS.n367 8.5005
R1525 AVSS.n377 AVSS.n365 8.5005
R1526 AVSS.n362 AVSS.n360 8.5005
R1527 AVSS.n362 AVSS.n349 8.5005
R1528 AVSS.n362 AVSS.n352 8.5005
R1529 AVSS.n30 AVSS.n8 0.654244
R1530 AVSS.n61 AVSS.n8 0.543845
R1531 AVSS.n470 AVSS.n61 1.06592
R1532 AVSS.n471 AVSS.n64 0.98292
R1533 AVSS.n72 AVSS.n8 1.34066
R1534 AVSS.n476 AVSS.n72 0.633722
R1535 AVSS.n479 AVSS.n68 0.692363
R1536 AVSS.n59 AVSS.n8 1.34094
R1537 AVSS.n73 AVSS.n481 0.759943
R1538 AVSS.n394 AVSS.n26 0.601504
R1539 AVSS.n26 AVSS.n76 0.631804
R1540 AVSS.n76 AVSS.n70 0.605683
R1541 AVSS.n69 AVSS.n389 0.834401
R1542 AVSS.n385 AVSS.n17 1.10294
R1543 AVSS.n89 AVSS.n19 1.76875
R1544 AVSS.n4 AVSS.n16 0.560985
R1545 AVSS.n386 AVSS.n67 1.10137
R1546 AVSS.n387 AVSS.n45 0.836914
R1547 AVSS.n65 AVSS.n388 0.985029
R1548 AVSS.n488 AVSS.n5 1.66058
R1549 AVSS.n179 AVSS.n5 4.09958
R1550 AVSS.n15 AVSS.n323 0.59808
R1551 AVSS.n6 AVSS.n116 1.5114
R1552 AVSS.n422 AVSS.n27 3.91662
R1553 AVSS.n427 AVSS.n24 0.699237
R1554 AVSS.n24 AVSS.n6 1.34056
R1555 AVSS.n429 AVSS.n114 0.833641
R1556 AVSS.n270 AVSS.n62 0.984829
R1557 AVSS.n6 AVSS.n62 0.654089
R1558 AVSS.n433 AVSS.n14 1.49324
R1559 AVSS.n71 AVSS.n29 0.027615
R1560 AVSS.n458 AVSS.n457 8.06279
R1561 AVSS.n450 AVSS.n449 8.06279
R1562 AVSS.n440 AVSS.n439 8.06279
R1563 AVSS.n251 AVSS.n200 8.06279
R1564 AVSS.n248 AVSS.n219 8.06279
R1565 AVSS.n242 AVSS.n222 8.06279
R1566 AVSS.n486 AVSS.n485 8.06279
R1567 AVSS.n246 AVSS.n198 7.58986
R1568 AVSS.n452 AVSS.n451 7.58986
R1569 AVSS.n247 AVSS.n198 7.58986
R1570 AVSS.t24 AVSS.n7 12.7028
R1571 AVSS.n244 AVSS.t53 7.58853
R1572 AVSS.n217 AVSS.t57 7.35141
R1573 AVSS.n435 AVSS.n8 6.87176
R1574 AVSS.n437 AVSS.n8 6.87176
R1575 AVSS.n441 AVSS.n8 6.87176
R1576 AVSS.n443 AVSS.n8 6.87176
R1577 AVSS.n447 AVSS.n8 6.87176
R1578 AVSS.n453 AVSS.n8 6.87176
R1579 AVSS.n459 AVSS.n8 6.87176
R1580 AVSS.n461 AVSS.n8 6.87176
R1581 AVSS.n463 AVSS.n8 6.87176
R1582 AVSS.n4 AVSS.n225 6.87176
R1583 AVSS.n4 AVSS.n224 6.87176
R1584 AVSS.n4 AVSS.n223 6.87176
R1585 AVSS.n4 AVSS.n195 6.87176
R1586 AVSS.n4 AVSS.n221 6.87176
R1587 AVSS.n4 AVSS.n220 6.87176
R1588 AVSS.n4 AVSS.n197 6.87176
R1589 AVSS.n4 AVSS.n218 6.87176
R1590 AVSS.n4 AVSS.n201 6.87176
R1591 AVSS.n4 AVSS.n202 6.87176
R1592 AVSS.n4 AVSS.n203 6.87176
R1593 AVSS.n4 AVSS.n204 6.87176
R1594 AVSS.n4 AVSS.n205 6.87176
R1595 AVSS.n46 AVSS.n112 4.30658
R1596 AVSS.n46 AVSS.n110 4.30658
R1597 AVSS.n46 AVSS.n104 2.88405
R1598 AVSS.n46 AVSS.n108 4.30658
R1599 AVSS.n46 AVSS.n107 4.30658
R1600 AVSS.n46 AVSS.n106 2.88405
R1601 AVSS.n46 AVSS.n111 4.30658
R1602 AVSS.n47 AVSS.n56 4.30658
R1603 AVSS.n47 AVSS.n57 4.30658
R1604 AVSS.n47 AVSS.n51 2.88405
R1605 AVSS.n47 AVSS.n54 4.30658
R1606 AVSS.n47 AVSS.n53 2.88405
R1607 AVSS.n47 AVSS.n55 4.30658
R1608 AVSS.n6 AVSS.n436 6.87176
R1609 AVSS.n6 AVSS.n438 6.87176
R1610 AVSS.n6 AVSS.n442 6.87176
R1611 AVSS.n6 AVSS.n446 6.87176
R1612 AVSS.n6 AVSS.n448 6.87176
R1613 AVSS.n6 AVSS.n452 6.87176
R1614 AVSS.n6 AVSS.n456 6.87176
R1615 AVSS.n6 AVSS.n460 6.87176
R1616 AVSS.n6 AVSS.n462 6.87176
R1617 AVSS.n6 AVSS.n464 6.87176
R1618 AVSS.n6 AVSS.n9 0.139616
R1619 AVSS.n20 AVSS.n237 6.87176
R1620 AVSS.n20 AVSS.n238 6.87176
R1621 AVSS.n20 AVSS.n240 6.87176
R1622 AVSS.n20 AVSS.n241 6.87176
R1623 AVSS.n20 AVSS.n243 6.87176
R1624 AVSS.n20 AVSS.n245 6.87176
R1625 AVSS.n20 AVSS.n246 6.87176
R1626 AVSS.n20 AVSS.n247 6.87176
R1627 AVSS.n20 AVSS.n249 6.87176
R1628 AVSS.n20 AVSS.n250 6.87176
R1629 AVSS.n20 AVSS.n252 6.87176
R1630 AVSS.n20 AVSS.n253 6.87176
R1631 AVSS.n20 AVSS.n255 6.87176
R1632 AVSS.n20 AVSS.n256 6.87176
R1633 AVSS.n20 AVSS.n257 6.87176
R1634 AVSS.n463 AVSS.n462 6.51845
R1635 AVSS.n9 AVSS.n8 0.139317
R1636 AVSS.n245 AVSS.n197 6.51845
R1637 AVSS.n464 AVSS.n463 6.51845
R1638 AVSS.n462 AVSS.n461 6.51845
R1639 AVSS.n461 AVSS.n460 6.51845
R1640 AVSS.n460 AVSS.n459 6.51845
R1641 AVSS.n453 AVSS.n452 6.51845
R1642 AVSS.n448 AVSS.n447 6.51845
R1643 AVSS.n447 AVSS.n446 6.51845
R1644 AVSS.n443 AVSS.n442 6.51845
R1645 AVSS.n442 AVSS.n441 6.51845
R1646 AVSS.n438 AVSS.n437 6.51845
R1647 AVSS.n437 AVSS.n436 6.51845
R1648 AVSS.n436 AVSS.n435 6.51845
R1649 AVSS.n7 AVSS.n6 0.127821
R1650 AVSS.n257 AVSS.n205 6.51845
R1651 AVSS.n256 AVSS.n205 6.51845
R1652 AVSS.n256 AVSS.n204 6.51845
R1653 AVSS.n255 AVSS.n204 6.51845
R1654 AVSS.n255 AVSS.n203 6.51845
R1655 AVSS.n253 AVSS.n202 6.51845
R1656 AVSS.n252 AVSS.n202 6.51845
R1657 AVSS.n252 AVSS.n201 6.51845
R1658 AVSS.n249 AVSS.n218 6.51845
R1659 AVSS.n246 AVSS.n197 6.51845
R1660 AVSS.n243 AVSS.n220 6.51845
R1661 AVSS.n243 AVSS.n221 6.51845
R1662 AVSS.n241 AVSS.n195 6.51845
R1663 AVSS.n240 AVSS.n195 6.51845
R1664 AVSS.n238 AVSS.n223 6.51845
R1665 AVSS.n238 AVSS.n224 6.51845
R1666 AVSS.n237 AVSS.n224 6.51845
R1667 AVSS.n237 AVSS.n225 6.51845
R1668 AVSS.n451 AVSS.n8 6.33606
R1669 AVSS.n4 AVSS.n198 6.33606
R1670 AVSS.n9 AVSS.t21 11.1558
R1671 AVSS.n123 AVSS.n6 0.679624
R1672 AVSS.n6 AVSS.n121 0.46999
R1673 AVSS.n18 AVSS.n8 1.19693
R1674 AVSS.n477 AVSS.n18 0.741409
R1675 AVSS.n69 AVSS.n8 0.967334
R1676 AVSS.n22 AVSS.n8 1.34069
R1677 AVSS.n389 AVSS.n22 0.598175
R1678 AVSS.n17 AVSS.n8 0.347885
R1679 AVSS.n19 AVSS.n8 0.187747
R1680 AVSS.n67 AVSS.n4 0.347631
R1681 AVSS.n25 AVSS.n4 1.34062
R1682 AVSS.n4 AVSS.n45 0.967198
R1683 AVSS.n5 AVSS.n4 0.00848036
R1684 AVSS.n63 AVSS.n6 0.347836
R1685 AVSS.n63 AVSS.n427 1.10483
R1686 AVSS.n114 AVSS.n6 0.967291
R1687 AVSS.n14 AVSS.n29 0.00226112
R1688 AVSS.n71 AVSS.n430 1.48514
R1689 AVSS.n113 AVSS.n8 1.06385
R1690 AVSS.t131 AVSS.n141 5.57296
R1691 AVSS.n138 AVSS.t3 5.57296
R1692 AVSS.t55 AVSS.n140 5.4544
R1693 AVSS.n8 AVSS.n7 0.127883
R1694 AVSS.n486 AVSS.n33 5.44575
R1695 AVSS.n389 AVSS.n125 5.4005
R1696 AVSS.n124 AVSS.n381 5.4005
R1697 AVSS.n94 AVSS.n390 5.4005
R1698 AVSS.n75 AVSS.n93 5.4005
R1699 AVSS.n77 AVSS.n76 5.4005
R1700 AVSS.n387 AVSS.n125 5.4005
R1701 AVSS.n124 AVSS.n388 5.4005
R1702 AVSS.n382 AVSS.n94 5.4005
R1703 AVSS.n75 AVSS.n391 5.4005
R1704 AVSS.n77 AVSS.n392 5.4005
R1705 AVSS.n384 AVSS.n90 5.4005
R1706 AVSS.n386 AVSS.n90 5.4005
R1707 AVSS.n484 AVSS.n134 5.4005
R1708 AVSS.n482 AVSS.n481 5.4005
R1709 AVSS.n480 AVSS.n81 5.4005
R1710 AVSS.n479 AVSS.n83 5.4005
R1711 AVSS.n82 AVSS.n477 5.4005
R1712 AVSS.n87 AVSS.n471 5.4005
R1713 AVSS.n470 AVSS.n86 5.4005
R1714 AVSS.n469 AVSS.n132 5.4005
R1715 AVSS.n101 AVSS.n467 5.4005
R1716 AVSS.n120 AVSS.n334 5.4005
R1717 AVSS.n80 AVSS.n332 5.4005
R1718 AVSS.n79 AVSS.n330 5.4005
R1719 AVSS.n128 AVSS.n329 5.4005
R1720 AVSS.n127 AVSS.n326 5.4005
R1721 AVSS.n120 AVSS.n335 5.4005
R1722 AVSS.n80 AVSS.n333 5.4005
R1723 AVSS.n79 AVSS.n331 5.4005
R1724 AVSS.n328 AVSS.n327 5.4005
R1725 AVSS.n127 AVSS.n325 5.4005
R1726 AVSS.n85 AVSS.n340 5.4005
R1727 AVSS.n97 AVSS.n345 5.4005
R1728 AVSS.n96 AVSS.n343 5.4005
R1729 AVSS.n95 AVSS.n341 5.4005
R1730 AVSS.n97 AVSS.n346 5.4005
R1731 AVSS.n96 AVSS.n344 5.4005
R1732 AVSS.n95 AVSS.n342 5.4005
R1733 AVSS.n85 AVSS.n339 5.4005
R1734 AVSS.n78 AVSS.n324 5.4005
R1735 AVSS.n99 AVSS.n98 5.4005
R1736 AVSS.n323 AVSS.n143 5.4005
R1737 AVSS.n129 AVSS.n270 5.4005
R1738 AVSS.n429 AVSS.n131 5.4005
R1739 AVSS.n425 AVSS.n92 5.4005
R1740 AVSS.n426 AVSS.n269 5.4005
R1741 AVSS.n92 AVSS.n272 5.4005
R1742 AVSS.n78 AVSS.n320 5.4005
R1743 AVSS.n99 AVSS.n321 5.4005
R1744 AVSS.n143 AVSS.n322 5.4005
R1745 AVSS.n129 AVSS.n271 5.4005
R1746 AVSS.n131 AVSS.n428 5.4005
R1747 AVSS.n87 AVSS.n472 5.4005
R1748 AVSS.n86 AVSS.n261 5.4005
R1749 AVSS.n132 AVSS.n468 5.4005
R1750 AVSS.n101 AVSS.n100 5.4005
R1751 AVSS.n134 AVSS.n258 5.4005
R1752 AVSS.n133 AVSS.n483 5.4005
R1753 AVSS.n81 AVSS.n259 5.4005
R1754 AVSS.n83 AVSS.n478 5.4005
R1755 AVSS.n82 AVSS.n260 5.4005
R1756 AVSS.t23 AVSS.n454 5.33584
R1757 AVSS.t59 AVSS.n194 5.21727
R1758 AVSS.n397 AVSS.n140 4.62446
R1759 AVSS.t22 AVSS.n444 4.50589
R1760 AVSS.n451 AVSS.n450 4.33089
R1761 AVSS.n395 AVSS.n8 0.679196
R1762 AVSS.n46 AVSS.n135 0.739363
R1763 AVSS.t4 AVSS.n348 4.20617
R1764 AVSS.n402 AVSS.t159 4.20617
R1765 AVSS.n26 AVSS.n8 1.51123
R1766 AVSS.n433 AVSS.n432 4.16014
R1767 AVSS.n366 AVSS.t40 4.15021
R1768 AVSS.t5 AVSS.n349 4.15021
R1769 AVSS.n376 AVSS.n104 6.69777
R1770 AVSS.t40 AVSS.n142 3.91308
R1771 AVSS.n136 AVSS.t5 3.91308
R1772 AVSS.n371 AVSS.n105 6.6444
R1773 AVSS.n445 AVSS.t22 3.55739
R1774 AVSS.t132 AVSS.n348 3.52087
R1775 AVSS.n402 AVSS.t41 3.52087
R1776 AVSS.n397 AVSS.n216 3.43883
R1777 AVSS.n432 AVSS.n431 3.3755
R1778 AVSS.n435 AVSS.n434 3.25947
R1779 AVSS.n441 AVSS.n440 3.25947
R1780 AVSS.n459 AVSS.n458 3.25947
R1781 AVSS.n485 AVSS.n225 3.25947
R1782 AVSS.n242 AVSS.n221 3.25947
R1783 AVSS.n248 AVSS.n218 3.25947
R1784 AVSS.n251 AVSS.n201 3.25947
R1785 AVSS.n254 AVSS.n203 3.25947
R1786 AVSS.n372 AVSS.n109 4.08537
R1787 AVSS.n375 AVSS.n108 4.08537
R1788 AVSS.n372 AVSS.n107 4.08537
R1789 AVSS.n370 AVSS.n106 5.47122
R1790 AVSS.n111 AVSS.n365 4.08537
R1791 AVSS.n360 AVSS.n54 4.08537
R1792 AVSS.n352 AVSS.n55 4.08537
R1793 AVSS.n439 AVSS.n438 3.25947
R1794 AVSS.n446 AVSS.n445 3.25947
R1795 AVSS.n449 AVSS.n448 3.25947
R1796 AVSS.n457 AVSS.n456 3.25947
R1797 AVSS.n465 AVSS.n464 3.25947
R1798 AVSS.n240 AVSS.n194 3.25947
R1799 AVSS.n241 AVSS.n222 3.25947
R1800 AVSS.n250 AVSS.n200 3.25947
R1801 AVSS.n456 AVSS.n455 3.25947
R1802 AVSS.n454 AVSS.n453 3.25947
R1803 AVSS.n444 AVSS.n443 3.25947
R1804 AVSS.n253 AVSS.n216 3.25947
R1805 AVSS.n250 AVSS.n217 3.25947
R1806 AVSS.n249 AVSS.n199 3.25947
R1807 AVSS.n247 AVSS.n219 3.25947
R1808 AVSS.n245 AVSS.n196 3.25947
R1809 AVSS.n244 AVSS.n220 3.25947
R1810 AVSS.n239 AVSS.n223 3.25947
R1811 AVSS.n365 AVSS.n110 4.08537
R1812 AVSS.n109 AVSS.n373 4.77796
R1813 AVSS.n375 AVSS.n112 4.08537
R1814 AVSS.n57 AVSS.n352 4.08537
R1815 AVSS.n50 AVSS.n354 5.47122
R1816 AVSS.n52 AVSS.n356 5.47122
R1817 AVSS.n53 AVSS.n358 5.47122
R1818 AVSS.n56 AVSS.n360 4.08537
R1819 AVSS.n51 AVSS.n351 6.69777
R1820 AVSS.n418 AVSS.n27 3.76795
R1821 AVSS.n88 AVSS.n385 3.01029
R1822 AVSS.n394 AVSS.n393 3.01029
R1823 AVSS.n476 AVSS.n475 3.01029
R1824 AVSS.n84 AVSS.n338 3.01029
R1825 AVSS.n126 AVSS.n319 3.01029
R1826 AVSS.n130 AVSS.n427 3.01029
R1827 AVSS.n499 AVSS.n4 3.72392
R1828 AVSS.n383 AVSS.n147 3.0005
R1829 AVSS.n489 AVSS.n488 3.0005
R1830 AVSS.n406 AVSS.n122 3.58295
R1831 AVSS.n337 AVSS.n336 3.0005
R1832 AVSS.n424 AVSS.n423 3.0005
R1833 AVSS.n295 AVSS.n294 3.0005
R1834 AVSS.n474 AVSS.n473 3.0005
R1835 AVSS.n213 AVSS.n170 3.0005
R1836 AVSS.n378 AVSS.n377 2.88382
R1837 AVSS.n377 AVSS.n374 2.88382
R1838 AVSS.n377 AVSS.n373 2.88382
R1839 AVSS.n377 AVSS.n370 2.88382
R1840 AVSS.n377 AVSS.n369 2.88382
R1841 AVSS.n377 AVSS.n368 2.88382
R1842 AVSS.n362 AVSS.n361 2.88382
R1843 AVSS.n362 AVSS.n359 2.88382
R1844 AVSS.n362 AVSS.n358 2.88382
R1845 AVSS.n362 AVSS.n357 2.88382
R1846 AVSS.n362 AVSS.n356 2.88382
R1847 AVSS.n362 AVSS.n355 2.88382
R1848 AVSS.n362 AVSS.n354 2.88382
R1849 AVSS.n362 AVSS.n353 2.88382
R1850 AVSS.n239 AVSS.t59 2.84601
R1851 AVSS AVSS.n499 2.81782
R1852 AVSS.n378 AVSS.n112 4.77796
R1853 AVSS.n369 AVSS.n141 2.73536
R1854 AVSS.n368 AVSS.n110 4.77796
R1855 AVSS.n361 AVSS.n56 4.77796
R1856 AVSS.n355 AVSS.n137 2.73536
R1857 AVSS.n353 AVSS.n57 4.77796
R1858 AVSS.n369 AVSS.n102 5.47122
R1859 AVSS.n373 AVSS.n142 2.73536
R1860 AVSS.n374 AVSS.n103 5.47122
R1861 AVSS.n354 AVSS.n138 2.73536
R1862 AVSS.n357 AVSS.n48 6.64436
R1863 AVSS.n358 AVSS.n136 2.73536
R1864 AVSS.n359 AVSS.n49 5.47122
R1865 AVSS.n455 AVSS.t23 2.72745
R1866 AVSS.n254 AVSS.t55 2.60889
R1867 AVSS.n367 AVSS.t131 2.49032
R1868 AVSS.t3 AVSS.n137 2.49032
R1869 AVSS.n377 AVSS.n371 2.29722
R1870 AVSS.n507 AVSS.n506 2.26572
R1871 AVSS.n518 AVSS.n517 2.25801
R1872 AVSS.n510 AVSS.n509 2.2505
R1873 AVSS.n512 AVSS.n511 2.2505
R1874 AVSS.n502 AVSS.n501 2.2505
R1875 AVSS.n508 AVSS.n504 2.2505
R1876 AVSS.n509 AVSS.n503 2.2505
R1877 AVSS.n513 AVSS.n512 2.2505
R1878 AVSS.n514 AVSS.n502 2.2505
R1879 AVSS.n517 AVSS.n516 2.2505
R1880 AVSS.t145 AVSS.n465 1.89751
R1881 AVSS.n20 AVSS.n231 1.71792
R1882 AVSS.n20 AVSS.n227 1.51242
R1883 AVSS.n20 AVSS.n234 1.51242
R1884 AVSS.n4 AVSS.n207 1.5116
R1885 AVSS.n4 AVSS.n214 1.51113
R1886 AVSS.n27 AVSS.n20 0.00300147
R1887 AVSS.n91 AVSS.n41 5.67431
R1888 AVSS.n122 AVSS.n20 0.169783
R1889 AVSS.n304 AVSS.n20 3.89018
R1890 AVSS AVSS.n519 1.37422
R1891 AVSS.n20 AVSS.n229 1.34214
R1892 AVSS.n20 AVSS.n233 1.34214
R1893 AVSS.n4 AVSS.n210 1.34098
R1894 AVSS.n4 AVSS.n215 1.34098
R1895 AVSS.n20 AVSS.n232 1.34098
R1896 AVSS.n20 AVSS.n41 0.564397
R1897 AVSS.n6 AVSS.n267 1.34078
R1898 AVSS.n6 AVSS.n264 1.34061
R1899 AVSS.n46 AVSS.t41 9.75816
R1900 AVSS.t141 AVSS.t142 1.3205
R1901 AVSS.t241 AVSS.t242 1.3205
R1902 AVSS.t1 AVSS.t2 1.3205
R1903 AVSS.t47 AVSS.t48 1.3205
R1904 AVSS.t151 AVSS.t150 1.3205
R1905 AVSS.t155 AVSS.t154 1.3205
R1906 AVSS.t128 AVSS.t127 1.3205
R1907 AVSS.t13 AVSS.t12 1.3205
R1908 AVSS.t239 AVSS.t240 1.3205
R1909 AVSS.t51 AVSS.t52 1.3205
R1910 AVSS.t49 AVSS.t50 1.3205
R1911 AVSS.t35 AVSS.t36 1.3205
R1912 AVSS.t236 AVSS.t235 1.3205
R1913 AVSS.t10 AVSS.t9 1.3205
R1914 AVSS.t233 AVSS.t232 1.3205
R1915 AVSS.t126 AVSS.t125 1.3205
R1916 AVSS.n316 AVSS.t60 1.21892
R1917 AVSS.t77 AVSS.n302 1.21892
R1918 AVSS.t97 AVSS.n290 1.21892
R1919 AVSS.t226 AVSS.n186 1.21892
R1920 AVSS.n189 AVSS.t224 1.21892
R1921 AVSS.n178 AVSS.t210 1.21892
R1922 AVSS.n152 AVSS.t193 1.21892
R1923 AVSS.n150 AVSS.t172 1.21892
R1924 AVSS.n281 AVSS.t117 1.21452
R1925 AVSS.t82 AVSS.n302 1.21452
R1926 AVSS.n290 AVSS.t99 1.21452
R1927 AVSS.n280 AVSS.t118 1.21452
R1928 AVSS.n150 AVSS.t168 1.21452
R1929 AVSS.n163 AVSS.t169 1.21452
R1930 AVSS.t187 AVSS.n160 1.21452
R1931 AVSS.t180 AVSS.n152 1.21452
R1932 AVSS.n404 AVSS.n348 1.21013
R1933 AVSS.n403 AVSS.n402 1.21013
R1934 AVSS.t17 AVSS.t11 1.19723
R1935 AVSS.t39 AVSS.t38 1.19723
R1936 AVSS.t43 AVSS.t42 1.19723
R1937 AVSS.t46 AVSS.t45 1.19723
R1938 AVSS.t20 AVSS.t237 1.19723
R1939 AVSS.t18 AVSS.t19 1.19723
R1940 AVSS.t152 AVSS.t153 1.19723
R1941 AVSS.t143 AVSS.t144 1.19723
R1942 AVSS.t148 AVSS.t147 1.19723
R1943 AVSS.t162 AVSS.t161 1.19723
R1944 AVSS.t8 AVSS.t7 1.19723
R1945 AVSS.t15 AVSS.t234 1.19723
R1946 AVSS.t129 AVSS.t130 1.19723
R1947 AVSS.t33 AVSS.t34 1.19723
R1948 AVSS.t133 AVSS.t134 1.19723
R1949 AVSS.t44 AVSS.t6 1.19723
R1950 AVSS.n6 AVSS.n266 1.19684
R1951 AVSS.n507 AVSS.n500 1.12187
R1952 AVSS.n487 AVSS.n100 1.11406
R1953 AVSS.n488 AVSS.n487 1.10944
R1954 AVSS.n272 AVSS.n37 1.10527
R1955 AVSS.n519 AVSS.n500 1.10419
R1956 AVSS.n423 AVSS.n37 1.10104
R1957 AVSS.n519 AVSS.n518 1.1005
R1958 AVSS.n20 AVSS.n226 1.07564
R1959 AVSS.n20 AVSS.n228 1.07564
R1960 AVSS.n20 AVSS.n236 1.07564
R1961 AVSS.n20 AVSS.n235 1.07564
R1962 AVSS.n20 AVSS.n230 1.07564
R1963 AVSS.n4 AVSS.n211 1.07451
R1964 AVSS.n4 AVSS.n212 1.07427
R1965 AVSS.n4 AVSS.n208 1.07427
R1966 AVSS.n4 AVSS.n206 1.07427
R1967 AVSS.n4 AVSS.n209 1.07408
R1968 AVSS.n6 AVSS.n268 1.07404
R1969 AVSS.n6 AVSS.n265 1.07374
R1970 AVSS.n6 AVSS.n263 1.07373
R1971 AVSS.n339 AVSS.n35 1.07306
R1972 AVSS.n341 AVSS.n12 1.06593
R1973 AVSS.n472 AVSS.n1 1.06464
R1974 AVSS.n6 AVSS.n262 1.06388
R1975 AVSS.n261 AVSS.n1 1.01239
R1976 AVSS.n342 AVSS.n35 1.00575
R1977 AVSS.n498 AVSS.n497 1.0005
R1978 AVSS.n164 AVSS.n149 1.0005
R1979 AVSS.n165 AVSS.n166 1.0005
R1980 AVSS.t164 AVSS.n144 1.0005
R1981 AVSS.n28 AVSS.n146 1.0005
R1982 AVSS.n28 AVSS.n148 1.0005
R1983 AVSS.t228 AVSS.n192 1.0005
R1984 AVSS.n191 AVSS.n188 1.0005
R1985 AVSS.n491 AVSS.n490 1.0005
R1986 AVSS.n185 AVSS.n492 1.0005
R1987 AVSS.n308 AVSS.n409 1.0005
R1988 AVSS.n408 AVSS.n407 1.0005
R1989 AVSS.n315 AVSS.n313 1.0005
R1990 AVSS.t56 AVSS.n318 1.0005
R1991 AVSS.n305 AVSS.n304 1.0005
R1992 AVSS.n309 AVSS.n304 1.0005
R1993 AVSS.n418 AVSS.t121 1.0005
R1994 AVSS.n283 AVSS.n419 1.0005
R1995 AVSS.n279 AVSS.n276 1.0005
R1996 AVSS.n421 AVSS.n420 1.0005
R1997 AVSS.n422 AVSS.n274 1.0005
R1998 AVSS.n422 AVSS.n275 1.0005
R1999 AVSS.n414 AVSS.n413 1.0005
R2000 AVSS.n414 AVSS.n293 1.0005
R2001 AVSS.n298 AVSS.n292 1.0005
R2002 AVSS.n303 AVSS.n412 1.0005
R2003 AVSS.n411 AVSS.n410 1.0005
R2004 AVSS.n291 AVSS.n416 1.0005
R2005 AVSS.n415 AVSS.n288 1.0005
R2006 AVSS.n285 AVSS.n273 1.0005
R2007 AVSS.n183 AVSS.n179 1.0005
R2008 AVSS.n180 AVSS.n179 1.0005
R2009 AVSS.n31 AVSS.n496 1.0005
R2010 AVSS.n157 AVSS.n31 1.0005
R2011 AVSS.n169 AVSS.n156 1.0005
R2012 AVSS.n168 AVSS.n155 1.0005
R2013 AVSS.n154 AVSS.n145 1.0005
R2014 AVSS.n173 AVSS.n167 1.0005
R2015 AVSS.n177 AVSS.n495 1.0005
R2016 AVSS.n494 AVSS.n493 1.0005
R2017 AVSS.n271 AVSS.n39 0.987021
R2018 AVSS.n340 AVSS.n12 0.986574
R2019 AVSS.n340 AVSS.n13 0.982778
R2020 AVSS.n20 AVSS.n38 0.967806
R2021 AVSS.n0 AVSS.n100 0.967422
R2022 AVSS.n346 AVSS.n34 0.962318
R2023 AVSS.n153 AVSS.t194 0.96146
R2024 AVSS.t213 AVSS.n174 0.96146
R2025 AVSS.t114 AVSS.n280 0.96146
R2026 AVSS.n281 AVSS.t116 0.96146
R2027 AVSS.t75 AVSS.n300 0.96146
R2028 AVSS.t62 AVSS.n311 0.96146
R2029 AVSS.t54 AVSS.n310 0.96146
R2030 AVSS.t61 AVSS.n314 0.96146
R2031 AVSS.t76 AVSS.n299 0.96146
R2032 AVSS.t78 AVSS.n301 0.96146
R2033 AVSS.t101 AVSS.n287 0.96146
R2034 AVSS.n286 AVSS.t100 0.96146
R2035 AVSS.t98 AVSS.n289 0.96146
R2036 AVSS.n282 AVSS.t115 0.96146
R2037 AVSS.t113 AVSS.n278 0.96146
R2038 AVSS.t227 AVSS.n184 0.96146
R2039 AVSS.n190 AVSS.t225 0.96146
R2040 AVSS.t212 AVSS.n172 0.96146
R2041 AVSS.n175 AVSS.t211 0.96146
R2042 AVSS.t192 AVSS.n158 0.96146
R2043 AVSS.t176 AVSS.n163 0.96146
R2044 AVSS.n162 AVSS.t174 0.96146
R2045 AVSS.n160 AVSS.t195 0.96146
R2046 AVSS.n151 AVSS.t173 0.96146
R2047 AVSS.n338 AVSS.n13 0.961074
R2048 AVSS.t209 AVSS.n178 0.95706
R2049 AVSS.n189 AVSS.t220 0.95706
R2050 AVSS.t104 AVSS.n289 0.95706
R2051 AVSS.n314 AVSS.t65 0.95706
R2052 AVSS.n316 AVSS.t63 0.95706
R2053 AVSS.n310 AVSS.t66 0.95706
R2054 AVSS.n311 AVSS.t64 0.95706
R2055 AVSS.n301 AVSS.t81 0.95706
R2056 AVSS.n299 AVSS.t80 0.95706
R2057 AVSS.n300 AVSS.t79 0.95706
R2058 AVSS.n286 AVSS.t105 0.95706
R2059 AVSS.n287 AVSS.t106 0.95706
R2060 AVSS.n282 AVSS.t120 0.95706
R2061 AVSS.n278 AVSS.t119 0.95706
R2062 AVSS.n190 AVSS.t221 0.95706
R2063 AVSS.t222 AVSS.n184 0.95706
R2064 AVSS.t223 AVSS.n186 0.95706
R2065 AVSS.t208 AVSS.n175 0.95706
R2066 AVSS.t207 AVSS.n172 0.95706
R2067 AVSS.t203 AVSS.n174 0.95706
R2068 AVSS.t171 AVSS.n151 0.95706
R2069 AVSS.t170 AVSS.n162 0.95706
R2070 AVSS.t186 AVSS.n158 0.95706
R2071 AVSS.t185 AVSS.n153 0.95706
R2072 AVSS.n336 AVSS.n36 0.943731
R2073 AVSS.n472 AVSS.n2 0.939944
R2074 AVSS.n473 AVSS.n2 0.936159
R2075 AVSS.n345 AVSS.n11 0.934528
R2076 AVSS.n339 AVSS.n36 0.933992
R2077 AVSS.n344 AVSS.n34 0.932141
R2078 AVSS.n345 AVSS.n10 1.13979
R2079 AVSS.n468 AVSS.n0 0.925831
R2080 AVSS.t117 AVSS.t121 0.90564
R2081 AVSS.t164 AVSS.t169 0.90564
R2082 AVSS.t56 AVSS.n317 0.9052
R2083 AVSS.t226 AVSS.t228 0.9052
R2084 AVSS.n343 AVSS.n11 0.903138
R2085 AVSS.n322 AVSS.n39 0.887824
R2086 AVSS.t159 AVSS.n47 9.75296
R2087 AVSS.n428 AVSS.n38 0.838601
R2088 AVSS.n483 AVSS.n211 0.798438
R2089 AVSS.n327 AVSS.n235 0.794495
R2090 AVSS.n326 AVSS.n263 0.793586
R2091 AVSS.n343 AVSS.n268 0.78951
R2092 AVSS.n478 AVSS.n209 0.768632
R2093 AVSS.n333 AVSS.n236 0.765162
R2094 AVSS.n330 AVSS.n265 0.762304
R2095 AVSS.t121 AVSS.t118 0.76132
R2096 AVSS.t164 AVSS.t168 0.76132
R2097 AVSS.t56 AVSS.t60 0.76088
R2098 AVSS.t224 AVSS.t228 0.76088
R2099 AVSS.n329 AVSS.n263 0.760066
R2100 AVSS.n342 AVSS.n226 0.754353
R2101 AVSS.n271 AVSS.n38 0.751739
R2102 AVSS.n294 AVSS.n230 0.750686
R2103 AVSS.n261 AVSS.n206 0.750156
R2104 AVSS.n258 AVSS.n212 0.746808
R2105 AVSS.n213 AVSS.n212 0.746489
R2106 AVSS.n319 AVSS.n262 0.745543
R2107 AVSS.n332 AVSS.n266 0.743584
R2108 AVSS.n325 AVSS.n230 0.743162
R2109 AVSS.n334 AVSS.n266 0.74194
R2110 AVSS.n325 AVSS.n235 0.74152
R2111 AVSS.n258 AVSS.n211 0.737055
R2112 AVSS.n326 AVSS.n262 0.737006
R2113 AVSS.n260 AVSS.n208 0.730308
R2114 AVSS.n468 AVSS.n206 0.728475
R2115 AVSS.n335 AVSS.n228 0.726662
R2116 AVSS.n344 AVSS.n226 0.724828
R2117 AVSS.n20 AVSS.n34 0.721708
R2118 AVSS.n4 AVSS.n0 0.719769
R2119 AVSS.n333 AVSS.n228 0.71952
R2120 AVSS.n6 AVSS.n10 0.340326
R2121 AVSS.n478 AVSS.n208 0.715322
R2122 AVSS.t57 AVSS.n199 0.711878
R2123 AVSS.n331 AVSS.n236 0.70302
R2124 AVSS.n423 AVSS.n232 0.700296
R2125 AVSS.n259 AVSS.n209 0.698977
R2126 AVSS.n341 AVSS.n268 0.694392
R2127 AVSS.n332 AVSS.n265 0.69231
R2128 AVSS.n259 AVSS.n210 0.687462
R2129 AVSS.n331 AVSS.n229 0.684614
R2130 AVSS.n396 AVSS.n4 0.681
R2131 AVSS.n20 AVSS.n40 0.6805
R2132 AVSS.n20 AVSS.n39 0.655112
R2133 AVSS.n6 AVSS.n13 0.65451
R2134 AVSS.n6 AVSS.n11 0.654269
R2135 AVSS.n320 AVSS.n234 0.653587
R2136 AVSS.n392 AVSS.n214 0.651192
R2137 AVSS.n41 AVSS.n272 0.954914
R2138 AVSS.n473 AVSS.n207 0.641396
R2139 AVSS.n336 AVSS.n227 0.638691
R2140 AVSS.n338 AVSS.n267 0.633542
R2141 AVSS.n329 AVSS.n264 0.626298
R2142 AVSS.n330 AVSS.n264 0.62419
R2143 AVSS.n335 AVSS.n227 0.607754
R2144 AVSS.n321 AVSS.n233 0.606592
R2145 AVSS.n260 AVSS.n207 0.604804
R2146 AVSS.n391 AVSS.n215 0.603409
R2147 AVSS.n214 AVSS.n213 0.602292
R2148 AVSS.n322 AVSS.n231 0.601611
R2149 AVSS.n294 AVSS.n234 0.600191
R2150 AVSS.n20 AVSS.n36 0.598873
R2151 AVSS.n4 AVSS.n2 0.596775
R2152 AVSS.n334 AVSS.n267 0.596714
R2153 AVSS.n428 AVSS.n232 0.594242
R2154 AVSS.n327 AVSS.n229 0.591925
R2155 AVSS.n483 AVSS.n210 0.588742
R2156 AVSS.n392 AVSS.n215 0.586629
R2157 AVSS.n320 AVSS.n233 0.583781
R2158 AVSS.n321 AVSS.n231 0.578114
R2159 AVSS.n20 AVSS.n35 0.546671
R2160 AVSS.n432 AVSS.n269 0.544984
R2161 AVSS.n4 AVSS.n1 0.544719
R2162 AVSS.n6 AVSS.n12 0.543672
R2163 AVSS.n391 AVSS.n139 0.580483
R2164 AVSS.n300 AVSS.n299 0.51442
R2165 AVSS.n302 AVSS.n301 0.51442
R2166 AVSS.n314 AVSS.n316 0.51442
R2167 AVSS.n311 AVSS.n310 0.51442
R2168 AVSS.n289 AVSS.n290 0.51442
R2169 AVSS.n287 AVSS.n286 0.51442
R2170 AVSS.n280 AVSS.n278 0.51442
R2171 AVSS.n282 AVSS.n281 0.51442
R2172 AVSS.n152 AVSS.n153 0.51442
R2173 AVSS.n158 AVSS.n160 0.51442
R2174 AVSS.n151 AVSS.n150 0.51442
R2175 AVSS.n163 AVSS.n162 0.51442
R2176 AVSS.n178 AVSS.n175 0.51442
R2177 AVSS.n174 AVSS.n172 0.51442
R2178 AVSS.n190 AVSS.n189 0.51442
R2179 AVSS.n186 AVSS.n184 0.51442
R2180 AVSS.n324 AVSS.n116 0.630683
R2181 AVSS.n434 AVSS.t24 0.474752
R2182 AVSS.t53 AVSS.n196 0.474752
R2183 AVSS.t181 AVSS.t180 0.45508
R2184 AVSS.t108 AVSS.n284 0.45508
R2185 AVSS.t99 AVSS.t94 0.45508
R2186 AVSS.t83 AVSS.n297 0.45508
R2187 AVSS.t82 AVSS.t85 0.45508
R2188 AVSS.t69 AVSS.n307 0.45508
R2189 AVSS.n312 AVSS.t67 0.45508
R2190 AVSS.t187 AVSS.t183 0.45508
R2191 AVSS.t202 AVSS.n171 0.45508
R2192 AVSS.n176 AVSS.t200 0.45508
R2193 AVSS.t204 AVSS.n182 0.45508
R2194 AVSS.n187 AVSS.t217 0.45508
R2195 AVSS.t172 AVSS.t175 0.45464
R2196 AVSS.t193 AVSS.t198 0.45464
R2197 AVSS.t196 AVSS.n159 0.45464
R2198 AVSS.t178 AVSS.n161 0.45464
R2199 AVSS.t210 AVSS.t215 0.45464
R2200 AVSS.t205 AVSS.n181 0.45464
R2201 AVSS.n306 AVSS.t71 0.45464
R2202 AVSS.t92 AVSS.n277 0.45464
R2203 AVSS.t88 AVSS.t97 0.45464
R2204 AVSS.t90 AVSS.n296 0.45464
R2205 AVSS.t73 AVSS.t77 0.45464
R2206 AVSS.t111 AVSS.n417 0.45464
R2207 AVSS.t85 AVSS.n293 0.45106
R2208 AVSS.n298 AVSS.t81 0.45106
R2209 AVSS.n410 AVSS.t78 0.45106
R2210 AVSS.n305 AVSS.t73 0.45106
R2211 AVSS.t69 AVSS.n309 0.45106
R2212 AVSS.t66 AVSS.n308 0.45106
R2213 AVSS.n407 AVSS.n310 0.45106
R2214 AVSS.n315 AVSS.t54 0.45106
R2215 AVSS.n413 AVSS.t90 0.45106
R2216 AVSS.n291 AVSS.t100 0.45106
R2217 AVSS.n286 AVSS.n288 0.45106
R2218 AVSS.t105 AVSS.n285 0.45106
R2219 AVSS.t108 AVSS.n275 0.45106
R2220 AVSS.t111 AVSS.n274 0.45106
R2221 AVSS.n420 AVSS.t115 0.45106
R2222 AVSS.n279 AVSS.n282 0.45106
R2223 AVSS.t120 AVSS.n283 0.45106
R2224 AVSS.n157 AVSS.t196 0.45106
R2225 AVSS.t192 AVSS.n156 0.45106
R2226 AVSS.n158 AVSS.n155 0.45106
R2227 AVSS.t186 AVSS.n154 0.45106
R2228 AVSS.t183 AVSS.n146 0.45106
R2229 AVSS.t178 AVSS.n148 0.45106
R2230 AVSS.n497 AVSS.t174 0.45106
R2231 AVSS.n162 AVSS.n164 0.45106
R2232 AVSS.n165 AVSS.t170 0.45106
R2233 AVSS.n496 AVSS.t202 0.45106
R2234 AVSS.t207 AVSS.n173 0.45106
R2235 AVSS.n493 AVSS.t212 0.45106
R2236 AVSS.n180 AVSS.t205 0.45106
R2237 AVSS.t204 AVSS.n183 0.45106
R2238 AVSS.t222 AVSS.n185 0.45106
R2239 AVSS.n490 AVSS.n184 0.45106
R2240 AVSS.n191 AVSS.t227 0.45106
R2241 AVSS.n301 AVSS.n303 0.45018
R2242 AVSS.n177 AVSS.n172 0.45018
R2243 AVSS.n95 AVSS.n85 0.430443
R2244 AVSS.n87 AVSS.n86 0.430443
R2245 AVSS.n515 AVSS.t16 0.393445
R2246 AVSS.n505 AVSS.t14 0.392334
R2247 AVSS.n515 AVSS.t37 0.390702
R2248 AVSS.n505 AVSS.t0 0.390702
R2249 AVSS.n90 AVSS.n88 0.3899
R2250 AVSS.n130 AVSS.n92 0.3899
R2251 AVSS.n124 AVSS.n94 0.380786
R2252 AVSS.n143 AVSS.n129 0.380786
R2253 AVSS.n319 AVSS.n116 0.602698
R2254 AVSS.n414 AVSS.n20 3.88326
R2255 AVSS.n74 AVSS.n469 0.789466
R2256 AVSS.n97 AVSS.n96 0.373871
R2257 AVSS.n132 AVSS.n101 0.373871
R2258 AVSS.n377 AVSS.n376 0.364127
R2259 AVSS.n377 AVSS.n364 0.364127
R2260 AVSS.n362 AVSS.n351 0.364127
R2261 AVSS.n363 AVSS.n362 0.364127
R2262 AVSS.n122 AVSS.n346 1.22591
R2263 AVSS.n20 AVSS.n37 0.348842
R2264 AVSS.n376 AVSS.n135 0.345427
R2265 AVSS.n379 AVSS.n364 0.345427
R2266 AVSS.n400 AVSS.n363 0.345427
R2267 AVSS.n401 AVSS.n351 0.345427
R2268 AVSS.n487 AVSS.n4 0.325852
R2269 AVSS.n45 AVSS.n388 0.75311
R2270 AVSS.n60 AVSS.n466 5.83893
R2271 AVSS.n30 AVSS.n469 0.902227
R2272 AVSS.n59 AVSS.n480 0.624206
R2273 AVSS.n113 AVSS.n484 0.736895
R2274 AVSS.n4 AVSS.n28 3.8796
R2275 AVSS.n63 AVSS.n425 1.11145
R2276 AVSS.n303 AVSS.n299 0.30762
R2277 AVSS.n175 AVSS.n177 0.30762
R2278 AVSS.t83 AVSS.n293 0.30674
R2279 AVSS.t80 AVSS.n298 0.30674
R2280 AVSS.n410 AVSS.t76 0.30674
R2281 AVSS.t71 AVSS.n305 0.30674
R2282 AVSS.n309 AVSS.t67 0.30674
R2283 AVSS.n308 AVSS.t65 0.30674
R2284 AVSS.n407 AVSS.n314 0.30674
R2285 AVSS.t61 AVSS.n315 0.30674
R2286 AVSS.n413 AVSS.t88 0.30674
R2287 AVSS.t98 AVSS.n291 0.30674
R2288 AVSS.n289 AVSS.n288 0.30674
R2289 AVSS.n285 AVSS.t104 0.30674
R2290 AVSS.t94 AVSS.n275 0.30674
R2291 AVSS.t92 AVSS.n274 0.30674
R2292 AVSS.n420 AVSS.t113 0.30674
R2293 AVSS.n278 AVSS.n279 0.30674
R2294 AVSS.n283 AVSS.t119 0.30674
R2295 AVSS.t198 AVSS.n157 0.30674
R2296 AVSS.t194 AVSS.n156 0.30674
R2297 AVSS.n153 AVSS.n155 0.30674
R2298 AVSS.t185 AVSS.n154 0.30674
R2299 AVSS.t181 AVSS.n146 0.30674
R2300 AVSS.t175 AVSS.n148 0.30674
R2301 AVSS.n497 AVSS.t173 0.30674
R2302 AVSS.n164 AVSS.n151 0.30674
R2303 AVSS.t171 AVSS.n165 0.30674
R2304 AVSS.n496 AVSS.t200 0.30674
R2305 AVSS.n173 AVSS.t208 0.30674
R2306 AVSS.n493 AVSS.t211 0.30674
R2307 AVSS.t215 AVSS.n180 0.30674
R2308 AVSS.n183 AVSS.t217 0.30674
R2309 AVSS.n185 AVSS.t221 0.30674
R2310 AVSS.n490 AVSS.n190 0.30674
R2311 AVSS.t225 AVSS.n191 0.30674
R2312 AVSS.n125 AVSS.n124 0.301586
R2313 AVSS.n131 AVSS.n129 0.301586
R2314 AVSS.n328 AVSS.n127 0.2865
R2315 AVSS.n134 AVSS.n133 0.2865
R2316 AVSS.n80 AVSS.n79 0.272671
R2317 AVSS.n83 AVSS.n81 0.272671
R2318 AVSS.n58 AVSS.t146 0.0999172
R2319 AVSS.n404 AVSS.n403 0.25933
R2320 AVSS.t79 AVSS.n297 0.25796
R2321 AVSS.n306 AVSS.t75 0.25796
R2322 AVSS.t63 AVSS.n312 0.25796
R2323 AVSS.t64 AVSS.n307 0.25796
R2324 AVSS.t106 AVSS.n284 0.25796
R2325 AVSS.t195 AVSS.n159 0.25796
R2326 AVSS.t176 AVSS.n161 0.25796
R2327 AVSS.t213 AVSS.n181 0.25796
R2328 AVSS.n171 AVSS.t203 0.25796
R2329 AVSS.t209 AVSS.n176 0.25796
R2330 AVSS.n182 AVSS.t223 0.25796
R2331 AVSS.t220 AVSS.n187 0.25796
R2332 AVSS.n277 AVSS.t114 0.25796
R2333 AVSS.n296 AVSS.t101 0.25796
R2334 AVSS.t62 AVSS.n317 0.25796
R2335 AVSS.t116 AVSS.n417 0.25796
R2336 AVSS.t156 AVSS.n43 0.0972061
R2337 AVSS.n93 AVSS.n70 0.595268
R2338 AVSS.n347 AVSS.n10 5.84027
R2339 AVSS.n16 AVSS.n386 0.956384
R2340 AVSS.n383 AVSS.n67 1.10277
R2341 AVSS.n118 AVSS.n93 0.588595
R2342 AVSS.n390 AVSS.n44 0.890472
R2343 AVSS.n381 AVSS.n69 0.752113
R2344 AVSS.n115 AVSS.n426 0.682562
R2345 AVSS.n117 AVSS.n98 0.594648
R2346 AVSS.n384 AVSS.n19 1.29172
R2347 AVSS.t73 AVSS.t69 0.22402
R2348 AVSS.t71 AVSS.t67 0.22402
R2349 AVSS.t88 AVSS.t83 0.22402
R2350 AVSS.t94 AVSS.t92 0.22402
R2351 AVSS.t111 AVSS.t108 0.22402
R2352 AVSS.t85 AVSS.t90 0.22402
R2353 AVSS.t183 AVSS.t178 0.22402
R2354 AVSS.t175 AVSS.t181 0.22402
R2355 AVSS.t198 AVSS.t200 0.22402
R2356 AVSS.t215 AVSS.t217 0.22402
R2357 AVSS.t205 AVSS.t204 0.22402
R2358 AVSS.t202 AVSS.t196 0.22402
R2359 AVSS.n77 AVSS.n75 0.217043
R2360 AVSS.n99 AVSS.n78 0.217043
R2361 AVSS.n64 AVSS.n476 0.960945
R2362 AVSS.n24 AVSS.n429 0.598814
R2363 AVSS.n323 AVSS.n62 0.891019
R2364 AVSS.n65 AVSS.n382 0.889002
R2365 AVSS.n390 AVSS.n118 0.598217
R2366 AVSS.n394 AVSS.n113 0.745591
R2367 AVSS.n115 AVSS.n425 0.690694
R2368 AVSS.t117 AVSS.t120 0.165098
R2369 AVSS.t187 AVSS.t186 0.165098
R2370 AVSS.t170 AVSS.t169 0.165098
R2371 AVSS.t208 AVSS.n176 0.165098
R2372 AVSS.n171 AVSS.t207 0.165098
R2373 AVSS.n187 AVSS.t221 0.165098
R2374 AVSS.n182 AVSS.t222 0.165098
R2375 AVSS.t180 AVSS.t185 0.165098
R2376 AVSS.t168 AVSS.t171 0.165098
R2377 AVSS.t105 AVSS.n284 0.165098
R2378 AVSS.t104 AVSS.t99 0.165098
R2379 AVSS.t80 AVSS.n297 0.165098
R2380 AVSS.t81 AVSS.t82 0.165098
R2381 AVSS.t66 AVSS.n307 0.165098
R2382 AVSS.t65 AVSS.n312 0.165098
R2383 AVSS.t118 AVSS.t119 0.165098
R2384 AVSS.t77 AVSS.t78 0.165041
R2385 AVSS.t54 AVSS.n317 0.165041
R2386 AVSS.t97 AVSS.t98 0.165041
R2387 AVSS.n296 AVSS.t100 0.165041
R2388 AVSS.t113 AVSS.n277 0.165041
R2389 AVSS.n417 AVSS.t115 0.165041
R2390 AVSS.t224 AVSS.t225 0.165041
R2391 AVSS.t173 AVSS.t172 0.165041
R2392 AVSS.t194 AVSS.t193 0.165041
R2393 AVSS.t192 AVSS.n159 0.165041
R2394 AVSS.n161 AVSS.t174 0.165041
R2395 AVSS.t211 AVSS.t210 0.165041
R2396 AVSS.n181 AVSS.t212 0.165041
R2397 AVSS.t227 AVSS.t226 0.165041
R2398 AVSS.n306 AVSS.t76 0.165041
R2399 AVSS.t60 AVSS.t61 0.165041
R2400 AVSS.n44 AVSS.n381 0.985635
R2401 AVSS.t150 AVSS.t20 0.15532
R2402 AVSS.t6 AVSS.t126 0.15532
R2403 AVSS.t11 AVSS.t141 0.15532
R2404 AVSS.t36 AVSS.t15 0.15532
R2405 AVSS.n324 AVSS.n117 0.606273
R2406 AVSS.n28 AVSS.n147 0.14284
R2407 AVSS.n337 AVSS.n304 0.14284
R2408 AVSS.n424 AVSS.n422 0.14284
R2409 AVSS.n474 AVSS.n179 0.14284
R2410 AVSS.n414 AVSS.n295 0.14251
R2411 AVSS.n31 AVSS.n170 0.14251
R2412 AVSS.n387 AVSS.n25 0.595275
R2413 AVSS.n498 AVSS.n149 0.13162
R2414 AVSS.n408 AVSS.n313 0.13162
R2415 AVSS.n491 AVSS.n188 0.13162
R2416 AVSS.n421 AVSS.n276 0.13162
R2417 AVSS.n412 AVSS.n411 0.13162
R2418 AVSS.n416 AVSS.n415 0.13162
R2419 AVSS.n169 AVSS.n168 0.13162
R2420 AVSS.n495 AVSS.n494 0.13162
R2421 AVSS.n166 AVSS.n149 0.13107
R2422 AVSS.n409 AVSS.n408 0.13107
R2423 AVSS.n492 AVSS.n491 0.13107
R2424 AVSS.n419 AVSS.n276 0.13107
R2425 AVSS.n412 AVSS.n292 0.13107
R2426 AVSS.n415 AVSS.n273 0.13107
R2427 AVSS.n168 AVSS.n145 0.13107
R2428 AVSS.n495 AVSS.n167 0.13107
R2429 AVSS.n4 AVSS.n31 3.94022
R2430 AVSS.n60 AVSS.n8 0.33921
R2431 AVSS.n166 AVSS.n144 0.12502
R2432 AVSS.n419 AVSS.n418 0.12502
R2433 AVSS.n318 AVSS.n313 0.12491
R2434 AVSS.n192 AVSS.n188 0.12491
R2435 AVSS.n139 AVSS.n382 0.599082
R2436 AVSS.t21 AVSS.t145 0.119063
R2437 AVSS.n385 AVSS.n22 0.699945
R2438 AVSS.n25 AVSS.n383 0.699163
R2439 AVSS.n484 AVSS.n73 0.793642
R2440 AVSS.n479 AVSS.n18 0.744165
R2441 AVSS.n15 AVSS.n98 0.588773
R2442 AVSS.n20 AVSS.n32 0.11089
R2443 AVSS.n405 AVSS.n347 0.10786
R2444 AVSS.n466 AVSS.n193 0.10786
R2445 AVSS.t142 AVSS.t241 0.105307
R2446 AVSS.t242 AVSS.t1 0.105307
R2447 AVSS.t2 AVSS.t47 0.105307
R2448 AVSS.t154 AVSS.t151 0.105307
R2449 AVSS.t127 AVSS.t155 0.105307
R2450 AVSS.t12 AVSS.t128 0.105307
R2451 AVSS.t240 AVSS.t51 0.105307
R2452 AVSS.t52 AVSS.t49 0.105307
R2453 AVSS.t50 AVSS.t35 0.105307
R2454 AVSS.t9 AVSS.t236 0.105307
R2455 AVSS.t232 AVSS.t10 0.105307
R2456 AVSS.t125 AVSS.t233 0.105307
R2457 AVSS.n409 AVSS.n304 0.10082
R2458 AVSS.n492 AVSS.n179 0.10082
R2459 AVSS.n422 AVSS.n273 0.10082
R2460 AVSS.n28 AVSS.n145 0.10082
R2461 AVSS.n414 AVSS.n292 0.10049
R2462 AVSS.n31 AVSS.n167 0.10049
R2463 AVSS.n416 AVSS.n414 0.10038
R2464 AVSS.n31 AVSS.n169 0.10038
R2465 AVSS.n28 AVSS.n498 0.10005
R2466 AVSS.n422 AVSS.n421 0.10005
R2467 AVSS.n411 AVSS.n304 0.10005
R2468 AVSS.n494 AVSS.n179 0.10005
R2469 AVSS.t38 AVSS.t17 0.0955195
R2470 AVSS.t42 AVSS.t39 0.0955195
R2471 AVSS.t45 AVSS.t43 0.0955195
R2472 AVSS.t237 AVSS.t18 0.0955195
R2473 AVSS.t19 AVSS.t152 0.0955195
R2474 AVSS.t153 AVSS.t143 0.0955195
R2475 AVSS.t161 AVSS.t148 0.0955195
R2476 AVSS.t7 AVSS.t162 0.0955195
R2477 AVSS.t234 AVSS.t8 0.0955195
R2478 AVSS.t130 AVSS.t33 0.0955195
R2479 AVSS.t34 AVSS.t133 0.0955195
R2480 AVSS.t134 AVSS.t44 0.0955195
R2481 AVSS.n506 AVSS.n505 0.0946446
R2482 AVSS.n516 AVSS.n515 0.090914
R2483 AVSS.n431 AVSS.n21 1.30086
R2484 AVSS.n480 AVSS.n68 0.762162
R2485 AVSS.t0 AVSS.t48 0.0817017
R2486 AVSS.t37 AVSS.t13 0.0817017
R2487 AVSS.t14 AVSS.t239 0.0817017
R2488 AVSS.t16 AVSS.t235 0.0817017
R2489 AVSS.n406 AVSS.n405 0.07904
R2490 AVSS.n489 AVSS.n193 0.07904
R2491 AVSS.n477 AVSS.n72 0.596594
R2492 AVSS.n467 AVSS.n60 1.14034
R2493 AVSS.n4 AVSS.n3 0.07555
R2494 AVSS.n20 AVSS.n33 0.07555
R2495 AVSS.t0 AVSS.t46 0.0741187
R2496 AVSS.t37 AVSS.t144 0.0741187
R2497 AVSS.t14 AVSS.t147 0.0741187
R2498 AVSS.t16 AVSS.t129 0.0741187
R2499 AVSS.n89 AVSS.n16 5.67237
R2500 AVSS.n467 AVSS.n30 0.935198
R2501 AVSS.n481 AVSS.n59 0.626214
R2502 AVSS.n32 AVSS.n3 0.0363555
R2503 AVSS.n380 AVSS.n33 0.0363555
R2504 AVSS.n431 AVSS.n430 0.0353333
R2505 AVSS.n433 AVSS.n71 1.40432
R2506 AVSS.n405 AVSS.n404 0.0324
R2507 AVSS.n403 AVSS.n193 0.0324
R2508 AVSS.n499 AVSS.n144 0.03229
R2509 AVSS.n318 AVSS.n406 0.03174
R2510 AVSS.n192 AVSS.n489 0.03174
R2511 AVSS.n517 AVSS.n502 0.0300385
R2512 AVSS.n512 AVSS.n502 0.0300385
R2513 AVSS.n512 AVSS.n509 0.0300385
R2514 AVSS.n509 AVSS.n508 0.0300385
R2515 AVSS.n471 AVSS.n61 0.986136
R2516 AVSS.n114 AVSS.n270 0.752734
R2517 AVSS.n21 AVSS.n426 1.23477
R2518 AVSS.n17 AVSS.n384 1.11207
R2519 AVSS.n132 AVSS.n86 0.278957
R2520 AVSS.n96 AVSS.n95 0.278957
R2521 AVSS.n475 AVSS.n87 0.267014
R2522 AVSS.n85 AVSS.n84 0.267014
R2523 AVSS.n92 AVSS.n91 0.246271
R2524 AVSS.n90 AVSS.n89 0.246271
R2525 AVSS.n508 AVSS.n507 0.0156313
R2526 AVSS.n470 AVSS.n74 0.694464
R2527 AVSS.n83 AVSS.n82 0.273614
R2528 AVSS.n120 AVSS.n80 0.273614
R2529 AVSS.n511 AVSS.n501 0.013378
R2530 AVSS.n511 AVSS.n510 0.013378
R2531 AVSS.n510 AVSS.n500 0.013378
R2532 AVSS.n516 AVSS.n514 0.0110337
R2533 AVSS.n514 AVSS.n513 0.0110337
R2534 AVSS.n513 AVSS.n503 0.0110337
R2535 AVSS.n504 AVSS.n503 0.0110337
R2536 AVSS.n506 AVSS.n504 0.0110337
R2537 AVSS.n126 AVSS.n295 0.00985
R2538 AVSS.n393 AVSS.n170 0.00985
R2539 AVSS.n88 AVSS.n147 0.00952
R2540 AVSS.n84 AVSS.n337 0.00952
R2541 AVSS.n130 AVSS.n424 0.00952
R2542 AVSS.n475 AVSS.n474 0.00952
R2543 AVSS.n91 AVSS.n269 0.00615714
R2544 AVSS.n518 AVSS.n501 0.00586585
R2545 AVSS.n128 AVSS.n328 0.00427143
R2546 AVSS.n133 AVSS.n482 0.00427143
R2547 AVSS.n466 AVSS.n101 0.229929
R2548 AVSS.n347 AVSS.n97 0.229929
R2549 AVSS.n482 AVSS.n81 0.229614
R2550 AVSS.n79 AVSS.n128 0.229614
R2551 AVSS.n143 AVSS.n99 0.2117
R2552 AVSS.n75 AVSS.n94 0.2117
R2553 AVSS.n393 AVSS.n134 0.154814
R2554 AVSS.n127 AVSS.n126 0.154814
R2555 AVSS.n131 AVSS.n130 0.111443
R2556 AVSS.n88 AVSS.n125 0.111443
R2557 AVSS.n126 AVSS.n78 0.100129
R2558 AVSS.n393 AVSS.n77 0.100129
R2559 AVSS.n475 AVSS.n82 0.0998143
R2560 AVSS.n84 AVSS.n120 0.0998143
R2561 AVSS.n20 AVSS.n66 0.0337129
R2562 AVSS.n29 AVSS.t31 9.53182
R2563 comparator_slice_0.comparator_body_0.outx comparator_slice_0.comparator_body_0.outx.t0 5.77848
R2564 comparator_slice_0.comparator_body_0.outx comparator_slice_0.comparator_body_0.outx.n43 5.69938
R2565 comparator_slice_0.comparator_body_0.outx.n4 comparator_slice_0.comparator_body_0.outx 4.84798
R2566 comparator_slice_0.comparator_body_0.outx.t0 comparator_slice_0.comparator_body_0.outx 4.30825
R2567 comparator_slice_0.comparator_body_0.outx.n43 comparator_slice_0.comparator_body_0.outx.t67 4.1228
R2568 comparator_slice_0.comparator_body_0.outx.n42 comparator_slice_0.comparator_body_0.outx.t64 4.12103
R2569 comparator_slice_0.comparator_body_0.outx.n42 comparator_slice_0.comparator_body_0.outx.t65 4.11911
R2570 comparator_slice_0.comparator_body_0.outx.n43 comparator_slice_0.comparator_body_0.outx.t66 4.10479
R2571 comparator_slice_0.comparator_body_0.outx.n8 comparator_slice_0.comparator_body_0.outx.n11 2.82266
R2572 comparator_slice_0.comparator_body_0.outx.n9 comparator_slice_0.comparator_body_0.outx.n62 2.59122
R2573 comparator_slice_0.comparator_body_0.outx.n35 comparator_slice_0.comparator_body_0.outx.n61 2.57098
R2574 comparator_slice_0.comparator_body_0.outx comparator_slice_0.comparator_body_0.outx.t61 2.47695
R2575 comparator_slice_0.comparator_body_0.outx comparator_slice_0.comparator_body_0.outx.t16 2.47695
R2576 comparator_slice_0.comparator_body_0.outx comparator_slice_0.comparator_body_0.outx.t10 2.47695
R2577 comparator_slice_0.comparator_body_0.outx comparator_slice_0.comparator_body_0.outx.t59 2.47695
R2578 comparator_slice_0.comparator_body_0.outx comparator_slice_0.comparator_body_0.outx.t13 2.47695
R2579 comparator_slice_0.comparator_body_0.outx comparator_slice_0.comparator_body_0.outx.t5 2.47695
R2580 comparator_slice_0.comparator_body_0.outx comparator_slice_0.comparator_body_0.outx.t6 2.47695
R2581 comparator_slice_0.comparator_body_0.outx comparator_slice_0.comparator_body_0.outx.t54 2.47695
R2582 comparator_slice_0.comparator_body_0.outx comparator_slice_0.comparator_body_0.outx.t18 2.47695
R2583 comparator_slice_0.comparator_body_0.outx comparator_slice_0.comparator_body_0.outx.t15 2.47695
R2584 comparator_slice_0.comparator_body_0.outx comparator_slice_0.comparator_body_0.outx.t7 2.47695
R2585 comparator_slice_0.comparator_body_0.outx comparator_slice_0.comparator_body_0.outx.t17 2.47695
R2586 comparator_slice_0.comparator_body_0.outx comparator_slice_0.comparator_body_0.outx.t4 2.47695
R2587 comparator_slice_0.comparator_body_0.outx comparator_slice_0.comparator_body_0.outx.t60 2.47695
R2588 comparator_slice_0.comparator_body_0.outx comparator_slice_0.comparator_body_0.outx.t1 2.47695
R2589 comparator_slice_0.comparator_body_0.outx comparator_slice_0.comparator_body_0.outx.t57 2.47695
R2590 comparator_slice_0.comparator_body_0.outx comparator_slice_0.comparator_body_0.outx.t33 2.46703
R2591 comparator_slice_0.comparator_body_0.outx comparator_slice_0.comparator_body_0.outx.t31 2.46703
R2592 comparator_slice_0.comparator_body_0.outx comparator_slice_0.comparator_body_0.outx.t28 2.46703
R2593 comparator_slice_0.comparator_body_0.outx comparator_slice_0.comparator_body_0.outx.t21 2.46703
R2594 comparator_slice_0.comparator_body_0.outx comparator_slice_0.comparator_body_0.outx.t52 2.46703
R2595 comparator_slice_0.comparator_body_0.outx comparator_slice_0.comparator_body_0.outx.t38 2.46703
R2596 comparator_slice_0.comparator_body_0.outx comparator_slice_0.comparator_body_0.outx.t24 2.46703
R2597 comparator_slice_0.comparator_body_0.outx comparator_slice_0.comparator_body_0.outx.t34 2.46703
R2598 comparator_slice_0.comparator_body_0.outx comparator_slice_0.comparator_body_0.outx.t46 2.46703
R2599 comparator_slice_0.comparator_body_0.outx comparator_slice_0.comparator_body_0.outx.t42 2.46703
R2600 comparator_slice_0.comparator_body_0.outx comparator_slice_0.comparator_body_0.outx.t44 2.46703
R2601 comparator_slice_0.comparator_body_0.outx comparator_slice_0.comparator_body_0.outx.t26 2.46703
R2602 comparator_slice_0.comparator_body_0.outx comparator_slice_0.comparator_body_0.outx.t48 2.46703
R2603 comparator_slice_0.comparator_body_0.outx comparator_slice_0.comparator_body_0.outx.t23 2.46703
R2604 comparator_slice_0.comparator_body_0.outx comparator_slice_0.comparator_body_0.outx.t30 2.46703
R2605 comparator_slice_0.comparator_body_0.outx comparator_slice_0.comparator_body_0.outx.t45 2.46699
R2606 comparator_slice_0.comparator_body_0.outx comparator_slice_0.comparator_body_0.outx.t56 2.46234
R2607 comparator_slice_0.comparator_body_0.outx comparator_slice_0.comparator_body_0.outx.t14 2.46234
R2608 comparator_slice_0.comparator_body_0.outx comparator_slice_0.comparator_body_0.outx.t58 2.46234
R2609 comparator_slice_0.comparator_body_0.outx comparator_slice_0.comparator_body_0.outx.t55 2.46234
R2610 comparator_slice_0.comparator_body_0.outx comparator_slice_0.comparator_body_0.outx.t20 2.46234
R2611 comparator_slice_0.comparator_body_0.outx comparator_slice_0.comparator_body_0.outx.t63 2.46234
R2612 comparator_slice_0.comparator_body_0.outx comparator_slice_0.comparator_body_0.outx.t62 2.46234
R2613 comparator_slice_0.comparator_body_0.outx comparator_slice_0.comparator_body_0.outx.t11 2.46234
R2614 comparator_slice_0.comparator_body_0.outx comparator_slice_0.comparator_body_0.outx.t3 2.46234
R2615 comparator_slice_0.comparator_body_0.outx comparator_slice_0.comparator_body_0.outx.t19 2.46234
R2616 comparator_slice_0.comparator_body_0.outx comparator_slice_0.comparator_body_0.outx.t12 2.46234
R2617 comparator_slice_0.comparator_body_0.outx comparator_slice_0.comparator_body_0.outx.t9 2.46234
R2618 comparator_slice_0.comparator_body_0.outx comparator_slice_0.comparator_body_0.outx.t2 2.46234
R2619 comparator_slice_0.comparator_body_0.outx comparator_slice_0.comparator_body_0.outx.t8 2.46234
R2620 comparator_slice_0.comparator_body_0.outx comparator_slice_0.comparator_body_0.outx.t53 2.46234
R2621 comparator_slice_0.comparator_body_0.outx comparator_slice_0.comparator_body_0.outx.t49 2.45485
R2622 comparator_slice_0.comparator_body_0.outx comparator_slice_0.comparator_body_0.outx.t25 2.45485
R2623 comparator_slice_0.comparator_body_0.outx comparator_slice_0.comparator_body_0.outx.t51 2.45485
R2624 comparator_slice_0.comparator_body_0.outx comparator_slice_0.comparator_body_0.outx.t27 2.45485
R2625 comparator_slice_0.comparator_body_0.outx comparator_slice_0.comparator_body_0.outx.t41 2.45485
R2626 comparator_slice_0.comparator_body_0.outx comparator_slice_0.comparator_body_0.outx.t36 2.45485
R2627 comparator_slice_0.comparator_body_0.outx comparator_slice_0.comparator_body_0.outx.t50 2.45485
R2628 comparator_slice_0.comparator_body_0.outx comparator_slice_0.comparator_body_0.outx.t39 2.45485
R2629 comparator_slice_0.comparator_body_0.outx comparator_slice_0.comparator_body_0.outx.t35 2.45485
R2630 comparator_slice_0.comparator_body_0.outx comparator_slice_0.comparator_body_0.outx.t37 2.45485
R2631 comparator_slice_0.comparator_body_0.outx comparator_slice_0.comparator_body_0.outx.t43 2.45485
R2632 comparator_slice_0.comparator_body_0.outx comparator_slice_0.comparator_body_0.outx.t47 2.45485
R2633 comparator_slice_0.comparator_body_0.outx comparator_slice_0.comparator_body_0.outx.t40 2.45485
R2634 comparator_slice_0.comparator_body_0.outx comparator_slice_0.comparator_body_0.outx.t32 2.45485
R2635 comparator_slice_0.comparator_body_0.outx comparator_slice_0.comparator_body_0.outx.t22 2.45485
R2636 comparator_slice_0.comparator_body_0.outx comparator_slice_0.comparator_body_0.outx.t29 2.45485
R2637 comparator_slice_0.comparator_body_0.outx.n56 comparator_slice_0.comparator_body_0.outx 2.36282
R2638 comparator_slice_0.comparator_body_0.outx.n60 comparator_slice_0.comparator_body_0.outx 2.36282
R2639 comparator_slice_0.comparator_body_0.outx.n58 comparator_slice_0.comparator_body_0.outx 2.36282
R2640 comparator_slice_0.comparator_body_0.outx.n55 comparator_slice_0.comparator_body_0.outx 2.36282
R2641 comparator_slice_0.comparator_body_0.outx.n54 comparator_slice_0.comparator_body_0.outx 2.15733
R2642 comparator_slice_0.comparator_body_0.outx.n59 comparator_slice_0.comparator_body_0.outx 2.1569
R2643 comparator_slice_0.comparator_body_0.outx.n57 comparator_slice_0.comparator_body_0.outx 2.1569
R2644 comparator_slice_0.comparator_body_0.outx.n52 comparator_slice_0.comparator_body_0.outx 2.1569
R2645 comparator_slice_0.comparator_body_0.outx.n59 comparator_slice_0.comparator_body_0.outx 1.90287
R2646 comparator_slice_0.comparator_body_0.outx.n57 comparator_slice_0.comparator_body_0.outx 1.90287
R2647 comparator_slice_0.comparator_body_0.outx.n54 comparator_slice_0.comparator_body_0.outx 1.90287
R2648 comparator_slice_0.comparator_body_0.outx.n52 comparator_slice_0.comparator_body_0.outx 1.90287
R2649 comparator_slice_0.comparator_body_0.outx.n41 comparator_slice_0.comparator_body_0.outx 1.89114
R2650 comparator_slice_0.comparator_body_0.outx.n40 comparator_slice_0.comparator_body_0.outx 1.89114
R2651 comparator_slice_0.comparator_body_0.outx.n39 comparator_slice_0.comparator_body_0.outx 1.89114
R2652 comparator_slice_0.comparator_body_0.outx.n38 comparator_slice_0.comparator_body_0.outx 1.89114
R2653 comparator_slice_0.comparator_body_0.outx.n35 comparator_slice_0.comparator_body_0.outx.n39 1.84762
R2654 comparator_slice_0.comparator_body_0.outx.n30 comparator_slice_0.comparator_body_0.outx.n40 1.84762
R2655 comparator_slice_0.comparator_body_0.outx.n46 comparator_slice_0.comparator_body_0.outx 1.6922
R2656 comparator_slice_0.comparator_body_0.outx.n56 comparator_slice_0.comparator_body_0.outx 1.66263
R2657 comparator_slice_0.comparator_body_0.outx.n41 comparator_slice_0.comparator_body_0.outx 1.66263
R2658 comparator_slice_0.comparator_body_0.outx.n60 comparator_slice_0.comparator_body_0.outx 1.66263
R2659 comparator_slice_0.comparator_body_0.outx.n40 comparator_slice_0.comparator_body_0.outx 1.66263
R2660 comparator_slice_0.comparator_body_0.outx.n58 comparator_slice_0.comparator_body_0.outx 1.66263
R2661 comparator_slice_0.comparator_body_0.outx.n39 comparator_slice_0.comparator_body_0.outx 1.66263
R2662 comparator_slice_0.comparator_body_0.outx.n55 comparator_slice_0.comparator_body_0.outx 1.66263
R2663 comparator_slice_0.comparator_body_0.outx.n38 comparator_slice_0.comparator_body_0.outx 1.66263
R2664 comparator_slice_0.comparator_body_0.outx.n33 comparator_slice_0.comparator_body_0.outx 1.64914
R2665 comparator_slice_0.comparator_body_0.outx.n32 comparator_slice_0.comparator_body_0.outx 1.64914
R2666 comparator_slice_0.comparator_body_0.outx.n44 comparator_slice_0.comparator_body_0.outx 1.64914
R2667 comparator_slice_0.comparator_body_0.outx.n34 comparator_slice_0.comparator_body_0.outx 1.64914
R2668 comparator_slice_0.comparator_body_0.outx.n10 comparator_slice_0.comparator_body_0.outx 1.64456
R2669 comparator_slice_0.comparator_body_0.outx.n23 comparator_slice_0.comparator_body_0.outx 1.64369
R2670 comparator_slice_0.comparator_body_0.outx.n12 comparator_slice_0.comparator_body_0.outx 1.64369
R2671 comparator_slice_0.comparator_body_0.outx comparator_slice_0.comparator_body_0.outx.n24 1.53339
R2672 comparator_slice_0.comparator_body_0.outx.n20 comparator_slice_0.comparator_body_0.outx 1.52535
R2673 comparator_slice_0.comparator_body_0.outx.n47 comparator_slice_0.comparator_body_0.outx 1.52535
R2674 comparator_slice_0.comparator_body_0.outx.n45 comparator_slice_0.comparator_body_0.outx 1.52535
R2675 comparator_slice_0.comparator_body_0.outx.n9 comparator_slice_0.comparator_body_0.outx 1.52535
R2676 comparator_slice_0.comparator_body_0.outx.n27 comparator_slice_0.comparator_body_0.outx 1.51785
R2677 comparator_slice_0.comparator_body_0.outx.n3 comparator_slice_0.comparator_body_0.outx 1.51785
R2678 comparator_slice_0.comparator_body_0.outx.n16 comparator_slice_0.comparator_body_0.outx 1.51785
R2679 comparator_slice_0.comparator_body_0.outx.n6 comparator_slice_0.comparator_body_0.outx 1.51785
R2680 comparator_slice_0.comparator_body_0.outx.n20 comparator_slice_0.comparator_body_0.outx 1.51785
R2681 comparator_slice_0.comparator_body_0.outx.n21 comparator_slice_0.comparator_body_0.outx 1.51785
R2682 comparator_slice_0.comparator_body_0.outx.n48 comparator_slice_0.comparator_body_0.outx 1.51785
R2683 comparator_slice_0.comparator_body_0.outx.n4 comparator_slice_0.comparator_body_0.outx 1.51785
R2684 comparator_slice_0.comparator_body_0.outx.n2 comparator_slice_0.comparator_body_0.outx 1.51785
R2685 comparator_slice_0.comparator_body_0.outx.n0 comparator_slice_0.comparator_body_0.outx 1.51785
R2686 comparator_slice_0.comparator_body_0.outx.n51 comparator_slice_0.comparator_body_0.outx 1.51785
R2687 comparator_slice_0.comparator_body_0.outx.n28 comparator_slice_0.comparator_body_0.outx 1.51785
R2688 comparator_slice_0.comparator_body_0.outx.n12 comparator_slice_0.comparator_body_0.outx 1.51785
R2689 comparator_slice_0.comparator_body_0.outx.n36 comparator_slice_0.comparator_body_0.outx 1.50376
R2690 comparator_slice_0.comparator_body_0.outx.n37 comparator_slice_0.comparator_body_0.outx 1.50376
R2691 comparator_slice_0.comparator_body_0.outx.n53 comparator_slice_0.comparator_body_0.outx 1.50341
R2692 comparator_slice_0.comparator_body_0.outx.n3 comparator_slice_0.comparator_body_0.outx 1.50288
R2693 comparator_slice_0.comparator_body_0.outx.n0 comparator_slice_0.comparator_body_0.outx 1.50288
R2694 comparator_slice_0.comparator_body_0.outx.n6 comparator_slice_0.comparator_body_0.outx 1.50288
R2695 comparator_slice_0.comparator_body_0.outx.n4 comparator_slice_0.comparator_body_0.outx 1.50288
R2696 comparator_slice_0.comparator_body_0.outx.n17 comparator_slice_0.comparator_body_0.outx 1.50288
R2697 comparator_slice_0.comparator_body_0.outx.n21 comparator_slice_0.comparator_body_0.outx 1.50288
R2698 comparator_slice_0.comparator_body_0.outx.n24 comparator_slice_0.comparator_body_0.outx 1.50288
R2699 comparator_slice_0.comparator_body_0.outx.n15 comparator_slice_0.comparator_body_0.outx 1.50288
R2700 comparator_slice_0.comparator_body_0.outx.n12 comparator_slice_0.comparator_body_0.outx 1.50288
R2701 comparator_slice_0.comparator_body_0.outx.n50 comparator_slice_0.comparator_body_0.outx 1.50288
R2702 comparator_slice_0.comparator_body_0.outx.n12 comparator_slice_0.comparator_body_0.outx 1.50288
R2703 comparator_slice_0.comparator_body_0.outx.n34 comparator_slice_0.comparator_body_0.outx.n52 1.49914
R2704 comparator_slice_0.comparator_body_0.outx.n44 comparator_slice_0.comparator_body_0.outx.n54 1.49914
R2705 comparator_slice_0.comparator_body_0.outx.n32 comparator_slice_0.comparator_body_0.outx.n57 1.49914
R2706 comparator_slice_0.comparator_body_0.outx.n33 comparator_slice_0.comparator_body_0.outx.n59 1.49914
R2707 comparator_slice_0.comparator_body_0.outx.n61 comparator_slice_0.comparator_body_0.outx.n20 1.3997
R2708 comparator_slice_0.comparator_body_0.outx.n13 comparator_slice_0.comparator_body_0.outx.n28 0.288387
R2709 comparator_slice_0.comparator_body_0.outx.n10 comparator_slice_0.comparator_body_0.outx.n50 1.3557
R2710 comparator_slice_0.comparator_body_0.outx.n3 comparator_slice_0.comparator_body_0.outx.n2 1.3557
R2711 comparator_slice_0.comparator_body_0.outx.n15 comparator_slice_0.comparator_body_0.outx.n25 0.516071
R2712 comparator_slice_0.comparator_body_0.outx.n46 comparator_slice_0.comparator_body_0.outx.n22 0.302271
R2713 comparator_slice_0.comparator_body_0.outx.n51 comparator_slice_0.comparator_body_0.outx.n53 1.34909
R2714 comparator_slice_0.comparator_body_0.outx.n0 comparator_slice_0.comparator_body_0.outx.n6 1.27782
R2715 comparator_slice_0.comparator_body_0.outx.n4 comparator_slice_0.comparator_body_0.outx.n6 1.26902
R2716 comparator_slice_0.comparator_body_0.outx.n0 comparator_slice_0.comparator_body_0.outx.n51 1.25714
R2717 comparator_slice_0.comparator_body_0.outx.n62 comparator_slice_0.comparator_body_0.outx.n47 1.17266
R2718 comparator_slice_0.comparator_body_0.outx.n49 comparator_slice_0.comparator_body_0.outx.n48 0.309284
R2719 comparator_slice_0.comparator_body_0.outx.n19 comparator_slice_0.comparator_body_0.outx.n30 1.04418
R2720 comparator_slice_0.comparator_body_0.outx.n25 comparator_slice_0.comparator_body_0.outx.n24 0.288971
R2721 comparator_slice_0.comparator_body_0.outx.n22 comparator_slice_0.comparator_body_0.outx.n17 0.516071
R2722 comparator_slice_0.comparator_body_0.outx.n3 comparator_slice_0.comparator_body_0.outx.n14 0.455582
R2723 comparator_slice_0.comparator_body_0.outx.n12 comparator_slice_0.comparator_body_0.outx.n13 0.283535
R2724 comparator_slice_0.comparator_body_0.outx.n31 comparator_slice_0.comparator_body_0.outx.n50 0.855671
R2725 comparator_slice_0.comparator_body_0.outx.n28 comparator_slice_0.comparator_body_0.outx.n1 1.20233
R2726 comparator_slice_0.comparator_body_0.outx.n19 comparator_slice_0.comparator_body_0.outx.n49 0.867103
R2727 comparator_slice_0.comparator_body_0.outx.n20 comparator_slice_0.comparator_body_0.outx.n19 0.92362
R2728 comparator_slice_0.comparator_body_0.outx.n15 comparator_slice_0.comparator_body_0.outx.n14 0.362654
R2729 comparator_slice_0.comparator_body_0.outx.n18 comparator_slice_0.comparator_body_0.outx.n17 0.362654
R2730 comparator_slice_0.comparator_body_0.outx.n49 comparator_slice_0.comparator_body_0.outx.n21 1.23233
R2731 comparator_slice_0.comparator_body_0.outx.n10 comparator_slice_0.comparator_body_0.outx.n45 1.06596
R2732 comparator_slice_0.comparator_body_0.outx.n47 comparator_slice_0.comparator_body_0.outx.n23 0.92626
R2733 comparator_slice_0.comparator_body_0.outx.n45 comparator_slice_0.comparator_body_0.outx.n44 0.923681
R2734 comparator_slice_0.comparator_body_0.outx.n12 comparator_slice_0.comparator_body_0.outx.n11 0.88138
R2735 comparator_slice_0.comparator_body_0.outx.n61 comparator_slice_0.comparator_body_0.outx.n46 0.876583
R2736 comparator_slice_0.comparator_body_0.outx.n41 comparator_slice_0.comparator_body_0.outx.n9 2.09492
R2737 comparator_slice_0.comparator_body_0.outx.n11 comparator_slice_0.comparator_body_0.outx.n38 2.05435
R2738 comparator_slice_0.comparator_body_0.outx.n41 comparator_slice_0.comparator_body_0.outx.n56 2.0069
R2739 comparator_slice_0.comparator_body_0.outx.n40 comparator_slice_0.comparator_body_0.outx.n60 2.0069
R2740 comparator_slice_0.comparator_body_0.outx.n39 comparator_slice_0.comparator_body_0.outx.n58 2.0069
R2741 comparator_slice_0.comparator_body_0.outx.n38 comparator_slice_0.comparator_body_0.outx.n55 2.0069
R2742 comparator_slice_0.comparator_body_0.outx.n16 comparator_slice_0.comparator_body_0.outx.n4 1.70462
R2743 comparator_slice_0.comparator_body_0.outx.n6 comparator_slice_0.comparator_body_0.outx.n2 1.69494
R2744 comparator_slice_0.comparator_body_0.outx.n5 comparator_slice_0.comparator_body_0.outx.n4 0.405463
R2745 comparator_slice_0.comparator_body_0.outx.n6 comparator_slice_0.comparator_body_0.outx.n7 0.473975
R2746 comparator_slice_0.comparator_body_0.outx.n3 comparator_slice_0.comparator_body_0.outx.n1 0.472497
R2747 comparator_slice_0.comparator_body_0.outx.n9 comparator_slice_0.comparator_body_0.outx.n8 1.36966
R2748 comparator_slice_0.comparator_body_0.outx.n18 comparator_slice_0.comparator_body_0.outx.n24 0.455582
R2749 comparator_slice_0.comparator_body_0.outx.n51 comparator_slice_0.comparator_body_0.outx.n13 1.27352
R2750 comparator_slice_0.comparator_body_0.outx.n48 comparator_slice_0.comparator_body_0.outx.n5 1.85372
R2751 comparator_slice_0.comparator_body_0.outx.n26 comparator_slice_0.comparator_body_0.outx.n12 1.15084
R2752 comparator_slice_0.comparator_body_0.outx.n27 comparator_slice_0.comparator_body_0.outx.n14 0.310753
R2753 comparator_slice_0.comparator_body_0.outx.n18 comparator_slice_0.comparator_body_0.outx.n23 0.310753
R2754 comparator_slice_0.comparator_body_0.outx.n17 comparator_slice_0.comparator_body_0.outx.n16 1.10574
R2755 comparator_slice_0.comparator_body_0.outx.n2 comparator_slice_0.comparator_body_0.outx.n15 1.10574
R2756 comparator_slice_0.comparator_body_0.outx.n33 comparator_slice_0.comparator_body_0.outx.n29 0.31442
R2757 comparator_slice_0.comparator_body_0.outx.n5 comparator_slice_0.comparator_body_0.outx.n21 0.37494
R2758 comparator_slice_0.comparator_body_0.outx.n24 comparator_slice_0.comparator_body_0.outx.n7 0.251424
R2759 comparator_slice_0.comparator_body_0.outx.n31 comparator_slice_0.comparator_body_0.outx.n53 0.998404
R2760 comparator_slice_0.comparator_body_0.outx.n21 comparator_slice_0.comparator_body_0.outx.n20 1.08202
R2761 comparator_slice_0.comparator_body_0.outx.n29 comparator_slice_0.comparator_body_0.outx.n20 1.04725
R2762 comparator_slice_0.comparator_body_0.outx.n47 comparator_slice_0.comparator_body_0.outx.n32 1.04587
R2763 comparator_slice_0.comparator_body_0.outx.n27 comparator_slice_0.comparator_body_0.outx.n9 1.02482
R2764 comparator_slice_0.comparator_body_0.outx.n9 comparator_slice_0.comparator_body_0.outx.n34 1.00722
R2765 comparator_slice_0.comparator_body_0.outx.n8 comparator_slice_0.comparator_body_0.outx.n37 0.97906
R2766 comparator_slice_0.comparator_body_0.outx.n62 comparator_slice_0.comparator_body_0.outx.n36 0.97906
R2767 comparator_slice_0.comparator_body_0.outx.n45 comparator_slice_0.comparator_body_0.outx.n11 0.899971
R2768 comparator_slice_0.comparator_body_0.outx.n31 comparator_slice_0.comparator_body_0.outx.n12 0.899838
R2769 comparator_slice_0.comparator_body_0.outx.n43 comparator_slice_0.comparator_body_0.outx.n42 0.854615
R2770 comparator_slice_0.comparator_body_0.outx.n35 comparator_slice_0.comparator_body_0.outx.n32 0.360581
R2771 comparator_slice_0.comparator_body_0.outx.n30 comparator_slice_0.comparator_body_0.outx.n29 0.302254
R2772 comparator_slice_0.comparator_body_0.outx.n1 comparator_slice_0.comparator_body_0.outx.n0 0.331623
R2773 comparator_slice_0.comparator_body_0.outx.n22 comparator_slice_0.comparator_body_0.outx.n21 0.288971
R2774 comparator_slice_0.comparator_body_0.outx.n12 comparator_slice_0.comparator_body_0.outx.n10 0.75818
R2775 comparator_slice_0.comparator_body_0.outx.n37 comparator_slice_0.comparator_body_0.outx.n26 0.302271
R2776 comparator_slice_0.comparator_body_0.outx.n25 comparator_slice_0.comparator_body_0.outx.n36 0.302271
R2777 comparator_slice_0.comparator_body_0.outx.n16 comparator_slice_0.comparator_body_0.outx.n7 1.68613
R2778 comparator_slice_0.comparator_body_0.outx.n26 comparator_slice_0.comparator_body_0.outx.n3 1.04401
R2779 comparator_slice_0.comparator_body_0.m1_m2_diff_0.m1_m2_array_3/n1_2_4.S comparator_slice_0.comparator_body_0.mref_m5_diff_0.tail.t0 5.77518
R2780 comparator_slice_0.comparator_body_0.m1_m2_diff_0.m1_m2_array_3/n1_2_4.S comparator_slice_0.comparator_body_0.mref_m5_diff_0.tail.t0 4.33628
R2781 comparator_slice_0.comparator_body_0.mref_m5_diff_0.tail.n94 comparator_slice_0.comparator_body_0.mref_m5_diff_0.tail.n22 3.7177
R2782 comparator_slice_0.comparator_body_0.mref_m5_diff_0.tail.n77 comparator_slice_0.comparator_body_0.mref_m5_diff_0.tail.n0 3.7177
R2783 comparator_slice_0.comparator_body_0.mref_m5_diff_0.tail.n74 comparator_slice_0.comparator_body_0.mref_m5_diff_0.tail.n6 3.7177
R2784 comparator_slice_0.comparator_body_0.mref_m5_diff_0.tail.n10 comparator_slice_0.comparator_body_0.mref_m5_diff_0.tail.n93 3.7177
R2785 comparator_slice_0.comparator_body_0.mref_m5_diff_0.tail.n14 comparator_slice_0.comparator_body_0.mref_m5_diff_0.tail.n99 3.7177
R2786 comparator_slice_0.comparator_body_0.mref_m5_diff_0.tail.n100 comparator_slice_0.comparator_body_0.mref_m5_diff_0.tail.n3 3.7177
R2787 comparator_slice_0.comparator_body_0.mref_m5_diff_0.tail.n20 comparator_slice_0.comparator_body_0.mref_m5_diff_0.tail.n113 3.7177
R2788 comparator_slice_0.comparator_body_0.mref_m5_diff_0.tail.n23 comparator_slice_0.comparator_body_0.mref_m5_diff_0.tail.n50 3.7177
R2789 comparator_slice_0.comparator_body_0.mref_m5_diff_0.tail.n0 comparator_slice_0.comparator_body_0.m1_m2_diff_0.m1_m2_array_3/n1_2_1.S 3.01738
R2790 comparator_slice_0.comparator_body_0.mref_m5_diff_0.tail.n0 comparator_slice_0.comparator_body_0.m1_m2_diff_0.m1_m2_array_3/n1_2_6.S 3.01738
R2791 comparator_slice_0.comparator_body_0.mref_m5_diff_0.tail.n8 comparator_slice_0.comparator_body_0.m1_m2_diff_0.m1_m2_array_2/n1_2_1.S 3.01738
R2792 comparator_slice_0.comparator_body_0.mref_m5_diff_0.tail.n2 comparator_slice_0.comparator_body_0.m1_m2_diff_0.m1_m2_array_2/n1_2_6.S 3.01738
R2793 comparator_slice_0.comparator_body_0.mref_m5_diff_0.tail.n0 comparator_slice_0.comparator_body_0.m1_m2_diff_0.m1_m2_array_2/n1_2_9.S 3.01738
R2794 comparator_slice_0.comparator_body_0.mref_m5_diff_0.tail.n115 comparator_slice_0.comparator_body_0.m1_m2_diff_0.m1_m2_array_1/n1_2_13.S 3.01738
R2795 comparator_slice_0.comparator_body_0.mref_m5_diff_0.tail.n23 comparator_slice_0.comparator_body_0.m1_m2_diff_0.m1_m2_array_1/n1_2_5.S 3.01738
R2796 comparator_slice_0.comparator_body_0.mref_m5_diff_0.tail.n1 comparator_slice_0.comparator_body_0.m1_m2_diff_0.m1_m2_array_1/n1_2_2.S 3.01738
R2797 comparator_slice_0.comparator_body_0.mref_m5_diff_0.tail.n51 comparator_slice_0.comparator_body_0.m1_m2_diff_0.m1_m2_array_1/n1_2_8.S 3.01738
R2798 comparator_slice_0.comparator_body_0.mref_m5_diff_0.tail.n3 comparator_slice_0.comparator_body_0.m1_m2_diff_0.m1_m2_array_0/n1_2_5.S 3.01738
R2799 comparator_slice_0.comparator_body_0.mref_m5_diff_0.tail.n14 comparator_slice_0.comparator_body_0.m1_m2_diff_0.m1_m2_array_0/n1_2_2.S 3.01738
R2800 comparator_slice_0.comparator_body_0.mref_m5_diff_0.tail.n21 comparator_slice_0.comparator_body_0.m1_m2_diff_0.m1_m2_array_2/n1_2_13.S 3.01738
R2801 comparator_slice_0.comparator_body_0.mref_m5_diff_0.tail.n2 comparator_slice_0.comparator_body_0.m1_m2_diff_0.m1_m2_array_2/n1_2_5.S 3.01738
R2802 comparator_slice_0.comparator_body_0.mref_m5_diff_0.tail.n0 comparator_slice_0.comparator_body_0.m1_m2_diff_0.m1_m2_array_2/n1_2_2.S 3.01738
R2803 comparator_slice_0.comparator_body_0.mref_m5_diff_0.tail.n3 comparator_slice_0.comparator_body_0.m1_m2_diff_0.m1_m2_array_0/n1_2_1.S 3.01738
R2804 comparator_slice_0.comparator_body_0.mref_m5_diff_0.tail.n3 comparator_slice_0.comparator_body_0.m1_m2_diff_0.m1_m2_array_0/n1_2_6.S 3.01738
R2805 comparator_slice_0.comparator_body_0.mref_m5_diff_0.tail.n3 comparator_slice_0.comparator_body_0.m1_m2_diff_0.m1_m2_array_0/n1_2_14.S 3.01738
R2806 comparator_slice_0.comparator_body_0.mref_m5_diff_0.tail.n3 comparator_slice_0.comparator_body_0.m1_m2_diff_0.m1_m2_array_0/n1_2_9.S 3.01738
R2807 comparator_slice_0.comparator_body_0.mref_m5_diff_0.tail.n3 comparator_slice_0.comparator_body_0.m1_m2_diff_0.m1_m2_array_1/n1_2_1.S 3.01738
R2808 comparator_slice_0.comparator_body_0.mref_m5_diff_0.tail.n13 comparator_slice_0.comparator_body_0.m1_m2_diff_0.m1_m2_array_1/n1_2_6.S 3.01738
R2809 comparator_slice_0.comparator_body_0.mref_m5_diff_0.tail.n3 comparator_slice_0.comparator_body_0.m1_m2_diff_0.m1_m2_array_1/n1_2_9.S 3.01738
R2810 comparator_slice_0.comparator_body_0.mref_m5_diff_0.tail.n6 comparator_slice_0.comparator_body_0.m1_m2_diff_0.m1_m2_array_3/n1_2_13.S 3.01738
R2811 comparator_slice_0.comparator_body_0.mref_m5_diff_0.tail.n0 comparator_slice_0.comparator_body_0.m1_m2_diff_0.m1_m2_array_3/n1_2_5.S 3.01738
R2812 comparator_slice_0.comparator_body_0.mref_m5_diff_0.tail.n0 comparator_slice_0.comparator_body_0.m1_m2_diff_0.m1_m2_array_3/n1_2_2.S 3.12661
R2813 comparator_slice_0.comparator_body_0.mref_m5_diff_0.tail.n0 comparator_slice_0.comparator_body_0.m1_m2_diff_0.m1_m2_array_3/n1_2_9.S 3.16375
R2814 comparator_slice_0.comparator_body_0.mref_m5_diff_0.tail.n0 comparator_slice_0.comparator_body_0.m1_m2_diff_0.m1_m2_array_3/n1_2_12.S 3.00226
R2815 comparator_slice_0.comparator_body_0.mref_m5_diff_0.tail.n44 comparator_slice_0.comparator_body_0.m1_m2_diff_0.m1_m2_array_2/n1_2_11.S 3.00226
R2816 comparator_slice_0.comparator_body_0.mref_m5_diff_0.tail.n42 comparator_slice_0.comparator_body_0.m1_m2_diff_0.m1_m2_array_2/n1_2_0.S 3.00226
R2817 comparator_slice_0.comparator_body_0.mref_m5_diff_0.tail.n40 comparator_slice_0.comparator_body_0.m1_m2_diff_0.m1_m2_array_2/n1_2_10.S 3.00226
R2818 comparator_slice_0.comparator_body_0.mref_m5_diff_0.tail.n3 comparator_slice_0.comparator_body_0.m1_m2_diff_0.m1_m2_array_0/n1_2_12.S 3.00226
R2819 comparator_slice_0.comparator_body_0.mref_m5_diff_0.tail.n17 comparator_slice_0.comparator_body_0.m1_m2_diff_0.m1_m2_array_1/n1_2_12.S 3.00226
R2820 comparator_slice_0.comparator_body_0.mref_m5_diff_0.tail.n3 comparator_slice_0.comparator_body_0.m1_m2_diff_0.m1_m2_array_2/n1_2_12.S 3.00226
R2821 comparator_slice_0.comparator_body_0.mref_m5_diff_0.tail.n45 comparator_slice_0.comparator_body_0.m1_m2_diff_0.m1_m2_array_0/n1_2_0.S 3.00226
R2822 comparator_slice_0.comparator_body_0.mref_m5_diff_0.tail.n16 comparator_slice_0.comparator_body_0.m1_m2_diff_0.m1_m2_array_1/n1_2_15.S 3.00226
R2823 comparator_slice_0.comparator_body_0.mref_m5_diff_0.tail.n48 comparator_slice_0.comparator_body_0.m1_m2_diff_0.m1_m2_array_1/n1_2_11.S 3.00226
R2824 comparator_slice_0.comparator_body_0.mref_m5_diff_0.tail.n46 comparator_slice_0.comparator_body_0.m1_m2_diff_0.m1_m2_array_1/n1_2_0.S 3.00226
R2825 comparator_slice_0.comparator_body_0.m1_m2_diff_0.m1_m2_array_3/n1_2_7.S comparator_slice_0.comparator_body_0.mref_m5_diff_0.tail.t17 2.47757
R2826 comparator_slice_0.comparator_body_0.m1_m2_diff_0.m1_m2_array_3/n1_2_3.S comparator_slice_0.comparator_body_0.mref_m5_diff_0.tail.t84 2.47757
R2827 comparator_slice_0.comparator_body_0.m1_m2_diff_0.m1_m2_array_1/n1_2_10.S comparator_slice_0.comparator_body_0.mref_m5_diff_0.tail.t20 2.47757
R2828 comparator_slice_0.comparator_body_0.m1_m2_diff_0.m1_m2_array_1/n1_2_0.S comparator_slice_0.comparator_body_0.mref_m5_diff_0.tail.t90 2.47757
R2829 comparator_slice_0.comparator_body_0.m1_m2_diff_0.m1_m2_array_1/n1_2_11.S comparator_slice_0.comparator_body_0.mref_m5_diff_0.tail.t3 2.47757
R2830 comparator_slice_0.comparator_body_0.m1_m2_diff_0.m1_m2_array_1/n1_2_15.S comparator_slice_0.comparator_body_0.mref_m5_diff_0.tail.t86 2.47757
R2831 comparator_slice_0.comparator_body_0.m1_m2_diff_0.m1_m2_array_0/n1_2_10.S comparator_slice_0.comparator_body_0.mref_m5_diff_0.tail.t7 2.47757
R2832 comparator_slice_0.comparator_body_0.m1_m2_diff_0.m1_m2_array_0/n1_2_0.S comparator_slice_0.comparator_body_0.mref_m5_diff_0.tail.t93 2.47757
R2833 comparator_slice_0.comparator_body_0.m1_m2_diff_0.m1_m2_array_0/n1_2_11.S comparator_slice_0.comparator_body_0.mref_m5_diff_0.tail.t31 2.47757
R2834 comparator_slice_0.comparator_body_0.m1_m2_diff_0.m1_m2_array_0/n1_2_15.S comparator_slice_0.comparator_body_0.mref_m5_diff_0.tail.t82 2.47757
R2835 comparator_slice_0.comparator_body_0.m1_m2_diff_0.m1_m2_array_2/n1_2_3.S comparator_slice_0.comparator_body_0.mref_m5_diff_0.tail.t72 2.47757
R2836 comparator_slice_0.comparator_body_0.m1_m2_diff_0.m1_m2_array_2/n1_2_4.S comparator_slice_0.comparator_body_0.mref_m5_diff_0.tail.t11 2.47757
R2837 comparator_slice_0.comparator_body_0.m1_m2_diff_0.m1_m2_array_2/n1_2_12.S comparator_slice_0.comparator_body_0.mref_m5_diff_0.tail.t65 2.47757
R2838 comparator_slice_0.comparator_body_0.m1_m2_diff_0.m1_m2_array_2/n1_2_7.S comparator_slice_0.comparator_body_0.mref_m5_diff_0.tail.t27 2.47757
R2839 comparator_slice_0.comparator_body_0.m1_m2_diff_0.m1_m2_array_1/n1_2_7.S comparator_slice_0.comparator_body_0.mref_m5_diff_0.tail.t24 2.47757
R2840 comparator_slice_0.comparator_body_0.m1_m2_diff_0.m1_m2_array_1/n1_2_3.S comparator_slice_0.comparator_body_0.mref_m5_diff_0.tail.t75 2.47757
R2841 comparator_slice_0.comparator_body_0.m1_m2_diff_0.m1_m2_array_1/n1_2_4.S comparator_slice_0.comparator_body_0.mref_m5_diff_0.tail.t19 2.47757
R2842 comparator_slice_0.comparator_body_0.m1_m2_diff_0.m1_m2_array_1/n1_2_12.S comparator_slice_0.comparator_body_0.mref_m5_diff_0.tail.t83 2.47757
R2843 comparator_slice_0.comparator_body_0.m1_m2_diff_0.m1_m2_array_0/n1_2_7.S comparator_slice_0.comparator_body_0.mref_m5_diff_0.tail.t22 2.47757
R2844 comparator_slice_0.comparator_body_0.m1_m2_diff_0.m1_m2_array_0/n1_2_3.S comparator_slice_0.comparator_body_0.mref_m5_diff_0.tail.t80 2.47757
R2845 comparator_slice_0.comparator_body_0.m1_m2_diff_0.m1_m2_array_0/n1_2_4.S comparator_slice_0.comparator_body_0.mref_m5_diff_0.tail.t5 2.47757
R2846 comparator_slice_0.comparator_body_0.m1_m2_diff_0.m1_m2_array_0/n1_2_12.S comparator_slice_0.comparator_body_0.mref_m5_diff_0.tail.t78 2.47757
R2847 comparator_slice_0.comparator_body_0.m1_m2_diff_0.m1_m2_array_2/n1_2_10.S comparator_slice_0.comparator_body_0.mref_m5_diff_0.tail.t4 2.47757
R2848 comparator_slice_0.comparator_body_0.m1_m2_diff_0.m1_m2_array_2/n1_2_0.S comparator_slice_0.comparator_body_0.mref_m5_diff_0.tail.t92 2.47757
R2849 comparator_slice_0.comparator_body_0.m1_m2_diff_0.m1_m2_array_2/n1_2_11.S comparator_slice_0.comparator_body_0.mref_m5_diff_0.tail.t13 2.47757
R2850 comparator_slice_0.comparator_body_0.m1_m2_diff_0.m1_m2_array_2/n1_2_15.S comparator_slice_0.comparator_body_0.mref_m5_diff_0.tail.t68 2.47757
R2851 comparator_slice_0.comparator_body_0.m1_m2_diff_0.m1_m2_array_3/n1_2_12.S comparator_slice_0.comparator_body_0.mref_m5_diff_0.tail.t70 2.47757
R2852 comparator_slice_0.comparator_body_0.m1_m2_diff_0.m1_m2_array_3/n1_2_10.S comparator_slice_0.comparator_body_0.mref_m5_diff_0.tail.t30 2.47757
R2853 comparator_slice_0.comparator_body_0.m1_m2_diff_0.m1_m2_array_3/n1_2_0.S comparator_slice_0.comparator_body_0.mref_m5_diff_0.tail.t94 2.47757
R2854 comparator_slice_0.comparator_body_0.m1_m2_diff_0.m1_m2_array_3/n1_2_11.S comparator_slice_0.comparator_body_0.mref_m5_diff_0.tail.t8 2.47757
R2855 comparator_slice_0.comparator_body_0.m1_m2_diff_0.m1_m2_array_3/n1_2_15.S comparator_slice_0.comparator_body_0.mref_m5_diff_0.tail.t79 2.47757
R2856 comparator_slice_0.comparator_body_0.mref_m5_diff_0.mref_m5_array_2/n1_2$1_11.D comparator_slice_0.comparator_body_0.mref_m5_diff_0.tail.t41 2.46703
R2857 comparator_slice_0.comparator_body_0.mref_m5_diff_0.mref_m5_array_2/n1_2$1_3.D comparator_slice_0.comparator_body_0.mref_m5_diff_0.tail.t50 2.46703
R2858 comparator_slice_0.comparator_body_0.mref_m5_diff_0.mref_m5_array_2/n1_2$1_8.D comparator_slice_0.comparator_body_0.mref_m5_diff_0.tail.t63 2.46703
R2859 comparator_slice_0.comparator_body_0.mref_m5_diff_0.mref_m5_array_2/n1_2$1_2.D comparator_slice_0.comparator_body_0.mref_m5_diff_0.tail.t51 2.46703
R2860 comparator_slice_0.comparator_body_0.mref_m5_diff_0.mref_m5_array_3/n1_2$1_3.D comparator_slice_0.comparator_body_0.mref_m5_diff_0.tail.t56 2.46703
R2861 comparator_slice_0.comparator_body_0.mref_m5_diff_0.mref_m5_array_3/n1_2$1_11.D comparator_slice_0.comparator_body_0.mref_m5_diff_0.tail.t34 2.46703
R2862 comparator_slice_0.comparator_body_0.mref_m5_diff_0.mref_m5_array_1/n1_2$1_11.D comparator_slice_0.comparator_body_0.mref_m5_diff_0.tail.t54 2.46703
R2863 comparator_slice_0.comparator_body_0.mref_m5_diff_0.mref_m5_array_0/n1_2$1_11.D comparator_slice_0.comparator_body_0.mref_m5_diff_0.tail.t38 2.46703
R2864 comparator_slice_0.comparator_body_0.mref_m5_diff_0.mref_m5_array_0/n1_2$1_2.D comparator_slice_0.comparator_body_0.mref_m5_diff_0.tail.t62 2.46703
R2865 comparator_slice_0.comparator_body_0.mref_m5_diff_0.mref_m5_array_0/n1_2$1_8.D comparator_slice_0.comparator_body_0.mref_m5_diff_0.tail.t32 2.46703
R2866 comparator_slice_0.comparator_body_0.mref_m5_diff_0.mref_m5_array_0/n1_2$1_3.D comparator_slice_0.comparator_body_0.mref_m5_diff_0.tail.t37 2.46703
R2867 comparator_slice_0.comparator_body_0.mref_m5_diff_0.mref_m5_array_1/n1_2$1_2.D comparator_slice_0.comparator_body_0.mref_m5_diff_0.tail.t36 2.46703
R2868 comparator_slice_0.comparator_body_0.mref_m5_diff_0.mref_m5_array_1/n1_2$1_8.D comparator_slice_0.comparator_body_0.mref_m5_diff_0.tail.t43 2.46703
R2869 comparator_slice_0.comparator_body_0.mref_m5_diff_0.mref_m5_array_1/n1_2$1_3.D comparator_slice_0.comparator_body_0.mref_m5_diff_0.tail.t61 2.46703
R2870 comparator_slice_0.comparator_body_0.mref_m5_diff_0.mref_m5_array_3/n1_2$1_2.D comparator_slice_0.comparator_body_0.mref_m5_diff_0.tail.t53 2.46703
R2871 comparator_slice_0.comparator_body_0.mref_m5_diff_0.mref_m5_array_3/n1_2$1_8.D comparator_slice_0.comparator_body_0.mref_m5_diff_0.tail.t45 2.46703
R2872 comparator_slice_0.comparator_body_0.m1_m2_diff_0.m1_m2_array_3/n1_2_8.S comparator_slice_0.comparator_body_0.mref_m5_diff_0.tail.t95 2.46281
R2873 comparator_slice_0.comparator_body_0.m1_m2_diff_0.m1_m2_array_3/n1_2_2.S comparator_slice_0.comparator_body_0.mref_m5_diff_0.tail.t21 2.46281
R2874 comparator_slice_0.comparator_body_0.m1_m2_diff_0.m1_m2_array_3/n1_2_5.S comparator_slice_0.comparator_body_0.mref_m5_diff_0.tail.t64 2.46281
R2875 comparator_slice_0.comparator_body_0.m1_m2_diff_0.m1_m2_array_3/n1_2_13.S comparator_slice_0.comparator_body_0.mref_m5_diff_0.tail.t1 2.46281
R2876 comparator_slice_0.comparator_body_0.m1_m2_diff_0.m1_m2_array_1/n1_2_9.S comparator_slice_0.comparator_body_0.mref_m5_diff_0.tail.t87 2.46281
R2877 comparator_slice_0.comparator_body_0.m1_m2_diff_0.m1_m2_array_1/n1_2_14.S comparator_slice_0.comparator_body_0.mref_m5_diff_0.tail.t12 2.46281
R2878 comparator_slice_0.comparator_body_0.m1_m2_diff_0.m1_m2_array_1/n1_2_6.S comparator_slice_0.comparator_body_0.mref_m5_diff_0.tail.t85 2.46281
R2879 comparator_slice_0.comparator_body_0.m1_m2_diff_0.m1_m2_array_1/n1_2_1.S comparator_slice_0.comparator_body_0.mref_m5_diff_0.tail.t6 2.46281
R2880 comparator_slice_0.comparator_body_0.m1_m2_diff_0.m1_m2_array_0/n1_2_9.S comparator_slice_0.comparator_body_0.mref_m5_diff_0.tail.t67 2.46281
R2881 comparator_slice_0.comparator_body_0.m1_m2_diff_0.m1_m2_array_0/n1_2_14.S comparator_slice_0.comparator_body_0.mref_m5_diff_0.tail.t10 2.46281
R2882 comparator_slice_0.comparator_body_0.m1_m2_diff_0.m1_m2_array_0/n1_2_6.S comparator_slice_0.comparator_body_0.mref_m5_diff_0.tail.t81 2.46281
R2883 comparator_slice_0.comparator_body_0.m1_m2_diff_0.m1_m2_array_0/n1_2_1.S comparator_slice_0.comparator_body_0.mref_m5_diff_0.tail.t2 2.46281
R2884 comparator_slice_0.comparator_body_0.m1_m2_diff_0.m1_m2_array_2/n1_2_8.S comparator_slice_0.comparator_body_0.mref_m5_diff_0.tail.t73 2.46281
R2885 comparator_slice_0.comparator_body_0.m1_m2_diff_0.m1_m2_array_2/n1_2_2.S comparator_slice_0.comparator_body_0.mref_m5_diff_0.tail.t9 2.46281
R2886 comparator_slice_0.comparator_body_0.m1_m2_diff_0.m1_m2_array_2/n1_2_5.S comparator_slice_0.comparator_body_0.mref_m5_diff_0.tail.t66 2.46281
R2887 comparator_slice_0.comparator_body_0.m1_m2_diff_0.m1_m2_array_2/n1_2_13.S comparator_slice_0.comparator_body_0.mref_m5_diff_0.tail.t18 2.46281
R2888 comparator_slice_0.comparator_body_0.m1_m2_diff_0.m1_m2_array_0/n1_2_8.S comparator_slice_0.comparator_body_0.mref_m5_diff_0.tail.t89 2.46281
R2889 comparator_slice_0.comparator_body_0.m1_m2_diff_0.m1_m2_array_0/n1_2_2.S comparator_slice_0.comparator_body_0.mref_m5_diff_0.tail.t14 2.46281
R2890 comparator_slice_0.comparator_body_0.m1_m2_diff_0.m1_m2_array_0/n1_2_5.S comparator_slice_0.comparator_body_0.mref_m5_diff_0.tail.t77 2.46281
R2891 comparator_slice_0.comparator_body_0.m1_m2_diff_0.m1_m2_array_0/n1_2_13.S comparator_slice_0.comparator_body_0.mref_m5_diff_0.tail.t23 2.46281
R2892 comparator_slice_0.comparator_body_0.m1_m2_diff_0.m1_m2_array_1/n1_2_8.S comparator_slice_0.comparator_body_0.mref_m5_diff_0.tail.t91 2.46281
R2893 comparator_slice_0.comparator_body_0.m1_m2_diff_0.m1_m2_array_1/n1_2_2.S comparator_slice_0.comparator_body_0.mref_m5_diff_0.tail.t25 2.46281
R2894 comparator_slice_0.comparator_body_0.m1_m2_diff_0.m1_m2_array_1/n1_2_5.S comparator_slice_0.comparator_body_0.mref_m5_diff_0.tail.t69 2.46281
R2895 comparator_slice_0.comparator_body_0.m1_m2_diff_0.m1_m2_array_1/n1_2_13.S comparator_slice_0.comparator_body_0.mref_m5_diff_0.tail.t29 2.46281
R2896 comparator_slice_0.comparator_body_0.m1_m2_diff_0.m1_m2_array_2/n1_2_9.S comparator_slice_0.comparator_body_0.mref_m5_diff_0.tail.t74 2.46281
R2897 comparator_slice_0.comparator_body_0.m1_m2_diff_0.m1_m2_array_2/n1_2_14.S comparator_slice_0.comparator_body_0.mref_m5_diff_0.tail.t28 2.46281
R2898 comparator_slice_0.comparator_body_0.m1_m2_diff_0.m1_m2_array_2/n1_2_6.S comparator_slice_0.comparator_body_0.mref_m5_diff_0.tail.t76 2.46281
R2899 comparator_slice_0.comparator_body_0.m1_m2_diff_0.m1_m2_array_2/n1_2_1.S comparator_slice_0.comparator_body_0.mref_m5_diff_0.tail.t26 2.46281
R2900 comparator_slice_0.comparator_body_0.m1_m2_diff_0.m1_m2_array_3/n1_2_6.S comparator_slice_0.comparator_body_0.mref_m5_diff_0.tail.t71 2.46281
R2901 comparator_slice_0.comparator_body_0.m1_m2_diff_0.m1_m2_array_3/n1_2_1.S comparator_slice_0.comparator_body_0.mref_m5_diff_0.tail.t16 2.46281
R2902 comparator_slice_0.comparator_body_0.m1_m2_diff_0.m1_m2_array_3/n1_2_14.S comparator_slice_0.comparator_body_0.mref_m5_diff_0.tail.t15 2.46281
R2903 comparator_slice_0.comparator_body_0.m1_m2_diff_0.m1_m2_array_3/n1_2_9.S comparator_slice_0.comparator_body_0.mref_m5_diff_0.tail.t88 2.46277
R2904 comparator_slice_0.comparator_body_0.mref_m5_diff_0.mref_m5_array_2/n1_2$1_6.D comparator_slice_0.comparator_body_0.mref_m5_diff_0.tail.t40 2.45485
R2905 comparator_slice_0.comparator_body_0.mref_m5_diff_0.mref_m5_array_2/n1_2$1_15.D comparator_slice_0.comparator_body_0.mref_m5_diff_0.tail.t52 2.45485
R2906 comparator_slice_0.comparator_body_0.mref_m5_diff_0.mref_m5_array_2/n1_2$1_5.D comparator_slice_0.comparator_body_0.mref_m5_diff_0.tail.t60 2.45485
R2907 comparator_slice_0.comparator_body_0.mref_m5_diff_0.mref_m5_array_2/n1_2$1_12.D comparator_slice_0.comparator_body_0.mref_m5_diff_0.tail.t58 2.45485
R2908 comparator_slice_0.comparator_body_0.mref_m5_diff_0.mref_m5_array_3/n1_2$1_5.D comparator_slice_0.comparator_body_0.mref_m5_diff_0.tail.t42 2.45485
R2909 comparator_slice_0.comparator_body_0.mref_m5_diff_0.mref_m5_array_3/n1_2$1_15.D comparator_slice_0.comparator_body_0.mref_m5_diff_0.tail.t57 2.45485
R2910 comparator_slice_0.comparator_body_0.mref_m5_diff_0.mref_m5_array_3/n1_2$1_12.D comparator_slice_0.comparator_body_0.mref_m5_diff_0.tail.t49 2.45485
R2911 comparator_slice_0.comparator_body_0.mref_m5_diff_0.mref_m5_array_1/n1_2$1_5.D comparator_slice_0.comparator_body_0.mref_m5_diff_0.tail.t39 2.45485
R2912 comparator_slice_0.comparator_body_0.mref_m5_diff_0.mref_m5_array_1/n1_2$1_15.D comparator_slice_0.comparator_body_0.mref_m5_diff_0.tail.t46 2.45485
R2913 comparator_slice_0.comparator_body_0.mref_m5_diff_0.mref_m5_array_1/n1_2$1_12.D comparator_slice_0.comparator_body_0.mref_m5_diff_0.tail.t48 2.45485
R2914 comparator_slice_0.comparator_body_0.mref_m5_diff_0.mref_m5_array_0/n1_2$1_5.D comparator_slice_0.comparator_body_0.mref_m5_diff_0.tail.t59 2.45485
R2915 comparator_slice_0.comparator_body_0.mref_m5_diff_0.mref_m5_array_0/n1_2$1_15.D comparator_slice_0.comparator_body_0.mref_m5_diff_0.tail.t35 2.45485
R2916 comparator_slice_0.comparator_body_0.mref_m5_diff_0.mref_m5_array_0/n1_2$1_12.D comparator_slice_0.comparator_body_0.mref_m5_diff_0.tail.t55 2.45485
R2917 comparator_slice_0.comparator_body_0.mref_m5_diff_0.mref_m5_array_0/n1_2$1_6.D comparator_slice_0.comparator_body_0.mref_m5_diff_0.tail.t47 2.45485
R2918 comparator_slice_0.comparator_body_0.mref_m5_diff_0.mref_m5_array_1/n1_2$1_6.D comparator_slice_0.comparator_body_0.mref_m5_diff_0.tail.t33 2.45485
R2919 comparator_slice_0.comparator_body_0.mref_m5_diff_0.mref_m5_array_3/n1_2$1_6.D comparator_slice_0.comparator_body_0.mref_m5_diff_0.tail.t44 2.45485
R2920 comparator_slice_0.comparator_body_0.mref_m5_diff_0.tail.n55 comparator_slice_0.comparator_body_0.mref_m5_diff_0.mref_m5_array_0/n1_2$1_15.D 2.04455
R2921 comparator_slice_0.comparator_body_0.mref_m5_diff_0.tail.n108 comparator_slice_0.comparator_body_0.mref_m5_diff_0.mref_m5_array_1/n1_2$1_15.D 2.04455
R2922 comparator_slice_0.comparator_body_0.mref_m5_diff_0.tail.n83 comparator_slice_0.comparator_body_0.mref_m5_diff_0.mref_m5_array_3/n1_2$1_15.D 2.04455
R2923 comparator_slice_0.comparator_body_0.mref_m5_diff_0.tail.n82 comparator_slice_0.comparator_body_0.mref_m5_diff_0.mref_m5_array_2/n1_2$1_15.D 2.04455
R2924 comparator_slice_0.comparator_body_0.mref_m5_diff_0.tail.n62 comparator_slice_0.comparator_body_0.mref_m5_diff_0.mref_m5_array_0/n1_2$1_11.D 2.03194
R2925 comparator_slice_0.comparator_body_0.mref_m5_diff_0.tail.n106 comparator_slice_0.comparator_body_0.mref_m5_diff_0.mref_m5_array_1/n1_2$1_11.D 2.03194
R2926 comparator_slice_0.comparator_body_0.mref_m5_diff_0.tail.n86 comparator_slice_0.comparator_body_0.mref_m5_diff_0.mref_m5_array_3/n1_2$1_11.D 2.03194
R2927 comparator_slice_0.comparator_body_0.mref_m5_diff_0.tail.n71 comparator_slice_0.comparator_body_0.mref_m5_diff_0.mref_m5_array_2/n1_2$1_11.D 2.03194
R2928 comparator_slice_0.comparator_body_0.mref_m5_diff_0.tail.n94 comparator_slice_0.comparator_body_0.mref_m5_diff_0.mref_m5_array_3/n1_2$1_6.D 1.52623
R2929 comparator_slice_0.comparator_body_0.mref_m5_diff_0.tail.n100 comparator_slice_0.comparator_body_0.mref_m5_diff_0.mref_m5_array_1/n1_2$1_6.D 1.52623
R2930 comparator_slice_0.comparator_body_0.mref_m5_diff_0.tail.n50 comparator_slice_0.comparator_body_0.mref_m5_diff_0.mref_m5_array_0/n1_2$1_6.D 1.52623
R2931 comparator_slice_0.comparator_body_0.mref_m5_diff_0.tail.n74 comparator_slice_0.comparator_body_0.mref_m5_diff_0.mref_m5_array_2/n1_2$1_6.D 1.52623
R2932 comparator_slice_0.comparator_body_0.mref_m5_diff_0.tail.n59 comparator_slice_0.comparator_body_0.mref_m5_diff_0.mref_m5_array_0/n1_2$1_12.D 1.52535
R2933 comparator_slice_0.comparator_body_0.mref_m5_diff_0.tail.n60 comparator_slice_0.comparator_body_0.mref_m5_diff_0.mref_m5_array_0/n1_2$1_5.D 1.52535
R2934 comparator_slice_0.comparator_body_0.mref_m5_diff_0.tail.n54 comparator_slice_0.comparator_body_0.mref_m5_diff_0.mref_m5_array_1/n1_2$1_12.D 1.52535
R2935 comparator_slice_0.comparator_body_0.mref_m5_diff_0.tail.n32 comparator_slice_0.comparator_body_0.mref_m5_diff_0.mref_m5_array_1/n1_2$1_5.D 1.52535
R2936 comparator_slice_0.comparator_body_0.mref_m5_diff_0.tail.n67 comparator_slice_0.comparator_body_0.mref_m5_diff_0.mref_m5_array_3/n1_2$1_12.D 1.52535
R2937 comparator_slice_0.comparator_body_0.mref_m5_diff_0.tail.n84 comparator_slice_0.comparator_body_0.mref_m5_diff_0.mref_m5_array_3/n1_2$1_5.D 1.52535
R2938 comparator_slice_0.comparator_body_0.mref_m5_diff_0.tail.n70 comparator_slice_0.comparator_body_0.mref_m5_diff_0.mref_m5_array_2/n1_2$1_12.D 1.52535
R2939 comparator_slice_0.comparator_body_0.mref_m5_diff_0.tail.n80 comparator_slice_0.comparator_body_0.mref_m5_diff_0.mref_m5_array_2/n1_2$1_5.D 1.52535
R2940 comparator_slice_0.comparator_body_0.mref_m5_diff_0.tail.n99 comparator_slice_0.comparator_body_0.mref_m5_diff_0.mref_m5_array_1/n1_2$1_3.D 1.51362
R2941 comparator_slice_0.comparator_body_0.mref_m5_diff_0.tail.n113 comparator_slice_0.comparator_body_0.mref_m5_diff_0.mref_m5_array_0/n1_2$1_3.D 1.51362
R2942 comparator_slice_0.comparator_body_0.mref_m5_diff_0.tail.n93 comparator_slice_0.comparator_body_0.mref_m5_diff_0.mref_m5_array_3/n1_2$1_3.D 1.51362
R2943 comparator_slice_0.comparator_body_0.mref_m5_diff_0.tail.n77 comparator_slice_0.comparator_body_0.mref_m5_diff_0.mref_m5_array_2/n1_2$1_3.D 1.51362
R2944 comparator_slice_0.comparator_body_0.mref_m5_diff_0.tail.n26 comparator_slice_0.comparator_body_0.mref_m5_diff_0.mref_m5_array_3/n1_2$1_8.D 1.51274
R2945 comparator_slice_0.comparator_body_0.mref_m5_diff_0.tail.n87 comparator_slice_0.comparator_body_0.mref_m5_diff_0.mref_m5_array_3/n1_2$1_2.D 1.51274
R2946 comparator_slice_0.comparator_body_0.mref_m5_diff_0.tail.n34 comparator_slice_0.comparator_body_0.mref_m5_diff_0.mref_m5_array_1/n1_2$1_8.D 1.51274
R2947 comparator_slice_0.comparator_body_0.mref_m5_diff_0.tail.n104 comparator_slice_0.comparator_body_0.mref_m5_diff_0.mref_m5_array_1/n1_2$1_2.D 1.51274
R2948 comparator_slice_0.comparator_body_0.mref_m5_diff_0.tail.n38 comparator_slice_0.comparator_body_0.mref_m5_diff_0.mref_m5_array_0/n1_2$1_8.D 1.51274
R2949 comparator_slice_0.comparator_body_0.mref_m5_diff_0.tail.n63 comparator_slice_0.comparator_body_0.mref_m5_diff_0.mref_m5_array_0/n1_2$1_2.D 1.51274
R2950 comparator_slice_0.comparator_body_0.mref_m5_diff_0.tail.n79 comparator_slice_0.comparator_body_0.mref_m5_diff_0.mref_m5_array_2/n1_2$1_2.D 1.51274
R2951 comparator_slice_0.comparator_body_0.mref_m5_diff_0.tail.n29 comparator_slice_0.comparator_body_0.mref_m5_diff_0.mref_m5_array_2/n1_2$1_8.D 1.51274
R2952 comparator_slice_0.comparator_body_0.mref_m5_diff_0.tail.n56 comparator_slice_0.comparator_body_0.mref_m5_diff_0.tail.n55 1.46922
R2953 comparator_slice_0.comparator_body_0.mref_m5_diff_0.tail.n73 comparator_slice_0.comparator_body_0.mref_m5_diff_0.tail.n72 1.43754
R2954 comparator_slice_0.comparator_body_0.mref_m5_diff_0.tail.n96 comparator_slice_0.comparator_body_0.mref_m5_diff_0.tail.n95 1.3557
R2955 comparator_slice_0.comparator_body_0.mref_m5_diff_0.tail.n88 comparator_slice_0.comparator_body_0.mref_m5_diff_0.tail.n86 1.3557
R2956 comparator_slice_0.comparator_body_0.mref_m5_diff_0.tail.n78 comparator_slice_0.comparator_body_0.mref_m5_diff_0.tail.n71 1.3557
R2957 comparator_slice_0.comparator_body_0.mref_m5_diff_0.tail.n75 comparator_slice_0.comparator_body_0.mref_m5_diff_0.tail.n69 1.3557
R2958 comparator_slice_0.comparator_body_0.mref_m5_diff_0.tail.n101 comparator_slice_0.comparator_body_0.mref_m5_diff_0.tail.n53 1.3557
R2959 comparator_slice_0.comparator_body_0.mref_m5_diff_0.tail.n106 comparator_slice_0.comparator_body_0.mref_m5_diff_0.tail.n105 1.3557
R2960 comparator_slice_0.comparator_body_0.mref_m5_diff_0.tail.n58 comparator_slice_0.comparator_body_0.mref_m5_diff_0.tail.n57 1.3557
R2961 comparator_slice_0.comparator_body_0.mref_m5_diff_0.tail.n64 comparator_slice_0.comparator_body_0.mref_m5_diff_0.tail.n62 1.3557
R2962 comparator_slice_0.comparator_body_0.m1_m2_diff_0.m1_m2_array_0/n1_2_13.S comparator_slice_0.comparator_body_0.mref_m5_diff_0.tail.n3 3.26582
R2963 comparator_slice_0.comparator_body_0.mref_m5_diff_0.tail.n17 comparator_slice_0.comparator_body_0.mref_m5_diff_0.tail.n115 1.20056
R2964 comparator_slice_0.comparator_body_0.m1_m2_diff_0.m1_m2_array_3/n1_2_10.S comparator_slice_0.comparator_body_0.mref_m5_diff_0.tail.n0 3.34878
R2965 comparator_slice_0.comparator_body_0.mref_m5_diff_0.tail.n40 comparator_slice_0.comparator_body_0.mref_m5_diff_0.tail.n0 1.15699
R2966 comparator_slice_0.comparator_body_0.mref_m5_diff_0.tail.n11 comparator_slice_0.comparator_body_0.mref_m5_diff_0.tail.n3 0.270668
R2967 comparator_slice_0.comparator_body_0.mref_m5_diff_0.tail.n12 comparator_slice_0.comparator_body_0.mref_m5_diff_0.tail.n3 0.270668
R2968 comparator_slice_0.comparator_body_0.mref_m5_diff_0.tail.n58 comparator_slice_0.comparator_body_0.mref_m5_diff_0.tail.n56 1.07322
R2969 comparator_slice_0.comparator_body_0.mref_m5_diff_0.tail.n78 comparator_slice_0.comparator_body_0.mref_m5_diff_0.tail.n73 1.05738
R2970 comparator_slice_0.comparator_body_0.mref_m5_diff_0.tail.n5 comparator_slice_0.comparator_body_0.m1_m2_diff_0.tail 0.201997
R2971 comparator_slice_0.comparator_body_0.mref_m5_diff_0.tail.n21 comparator_slice_0.comparator_body_0.m1_m2_diff_0.tail 1.00432
R2972 comparator_slice_0.comparator_body_0.mref_m5_diff_0.tail.n31 comparator_slice_0.comparator_body_0.mref_m5_diff_0.tail.n28 0.9597
R2973 comparator_slice_0.comparator_body_0.mref_m5_diff_0.tail.n27 comparator_slice_0.comparator_body_0.mref_m5_diff_0.tail.n24 0.9597
R2974 comparator_slice_0.comparator_body_0.mref_m5_diff_0.tail.n35 comparator_slice_0.comparator_body_0.mref_m5_diff_0.tail.n33 0.9597
R2975 comparator_slice_0.comparator_body_0.mref_m5_diff_0.tail.n39 comparator_slice_0.comparator_body_0.mref_m5_diff_0.tail.n36 0.9597
R2976 comparator_slice_0.comparator_body_0.mref_m5_diff_0.tail.n27 comparator_slice_0.comparator_body_0.mref_m5_diff_0.tail.n25 0.95794
R2977 comparator_slice_0.comparator_body_0.mref_m5_diff_0.tail.n31 comparator_slice_0.comparator_body_0.mref_m5_diff_0.tail.n30 0.95794
R2978 comparator_slice_0.comparator_body_0.mref_m5_diff_0.tail.n103 comparator_slice_0.comparator_body_0.mref_m5_diff_0.tail.n35 0.95794
R2979 comparator_slice_0.comparator_body_0.mref_m5_diff_0.tail.n39 comparator_slice_0.comparator_body_0.mref_m5_diff_0.tail.n37 0.95794
R2980 comparator_slice_0.comparator_body_0.mref_m5_diff_0.tail.n90 comparator_slice_0.comparator_body_0.mref_m5_diff_0.tail.n28 0.9553
R2981 comparator_slice_0.comparator_body_0.mref_m5_diff_0.tail.n89 comparator_slice_0.comparator_body_0.mref_m5_diff_0.tail.n82 0.9553
R2982 comparator_slice_0.comparator_body_0.mref_m5_diff_0.tail.n83 comparator_slice_0.comparator_body_0.mref_m5_diff_0.tail.n65 0.9553
R2983 comparator_slice_0.comparator_body_0.mref_m5_diff_0.tail.n24 comparator_slice_0.comparator_body_0.mref_m5_diff_0.tail.n66 0.9553
R2984 comparator_slice_0.comparator_body_0.mref_m5_diff_0.tail.n109 comparator_slice_0.comparator_body_0.mref_m5_diff_0.tail.n108 0.9553
R2985 comparator_slice_0.comparator_body_0.mref_m5_diff_0.tail.n110 comparator_slice_0.comparator_body_0.mref_m5_diff_0.tail.n33 0.9553
R2986 comparator_slice_0.comparator_body_0.mref_m5_diff_0.tail.n36 comparator_slice_0.comparator_body_0.mref_m5_diff_0.tail.n56 0.9553
R2987 comparator_slice_0.comparator_body_0.mref_m5_diff_0.tail.n30 comparator_slice_0.comparator_body_0.mref_m5_diff_0.tail.n73 0.93946
R2988 comparator_slice_0.comparator_body_0.mref_m5_diff_0.tail.n90 comparator_slice_0.comparator_body_0.mref_m5_diff_0.tail.n25 0.93946
R2989 comparator_slice_0.comparator_body_0.mref_m5_diff_0.tail.n110 comparator_slice_0.comparator_body_0.mref_m5_diff_0.tail.n37 0.93946
R2990 comparator_slice_0.comparator_body_0.mref_m5_diff_0.tail.n103 comparator_slice_0.comparator_body_0.mref_m5_diff_0.tail.n66 0.93946
R2991 comparator_slice_0.comparator_body_0.mref_m5_diff_0.tail.n92 comparator_slice_0.comparator_body_0.mref_m5_diff_0.tail.n91 0.92362
R2992 comparator_slice_0.comparator_body_0.mref_m5_diff_0.tail.n98 comparator_slice_0.comparator_body_0.mref_m5_diff_0.tail.n97 0.92362
R2993 comparator_slice_0.comparator_body_0.mref_m5_diff_0.tail.n112 comparator_slice_0.comparator_body_0.mref_m5_diff_0.tail.n111 0.92362
R2994 comparator_slice_0.comparator_body_0.mref_m5_diff_0.tail.n0 comparator_slice_0.comparator_body_0.m1_m2_diff_0.m1_m2_array_3/n1_2_8.S 3.28206
R2995 comparator_slice_0.comparator_body_0.mref_m5_diff_0.tail.n3 comparator_slice_0.comparator_body_0.mref_m5_diff_0.tail.n1 0.226949
R2996 comparator_slice_0.comparator_body_0.mref_m5_diff_0.tail.n2 comparator_slice_0.comparator_body_0.mref_m5_diff_0.tail.n9 0.433624
R2997 comparator_slice_0.comparator_body_0.mref_m5_diff_0.tail.n13 comparator_slice_0.comparator_body_0.mref_m5_diff_0.tail.n3 0.360564
R2998 comparator_slice_0.comparator_body_0.mref_m5_diff_0.tail.n5 comparator_slice_0.comparator_body_0.mref_m5_diff_0.tail.n6 0.240485
R2999 comparator_slice_0.comparator_body_0.mref_m5_diff_0.tail.n4 comparator_slice_0.comparator_body_0.m1_m2_diff_0.m1_m2_array_3/n1_2_15.S 3.53263
R3000 comparator_slice_0.comparator_body_0.m1_m2_diff_0.m1_m2_array_2/n1_2_15.S comparator_slice_0.comparator_body_0.mref_m5_diff_0.tail.n3 3.32207
R3001 comparator_slice_0.comparator_body_0.mref_m5_diff_0.tail.n16 comparator_slice_0.comparator_body_0.mref_m5_diff_0.tail.n49 0.782916
R3002 comparator_slice_0.comparator_body_0.mref_m5_diff_0.tail.n114 comparator_slice_0.comparator_body_0.mref_m5_diff_0.tail.n23 0.76549
R3003 comparator_slice_0.comparator_body_0.mref_m5_diff_0.tail.n17 comparator_slice_0.comparator_body_0.mref_m5_diff_0.tail.n19 0.74674
R3004 comparator_slice_0.comparator_body_0.mref_m5_diff_0.tail.n44 comparator_slice_0.comparator_body_0.mref_m5_diff_0.tail.n43 0.736738
R3005 comparator_slice_0.comparator_body_0.m1_m2_diff_0.m1_m2_array_0/n1_2_11.S comparator_slice_0.comparator_body_0.mref_m5_diff_0.tail.n7 3.20999
R3006 comparator_slice_0.comparator_body_0.mref_m5_diff_0.tail.n48 comparator_slice_0.comparator_body_0.mref_m5_diff_0.tail.n47 0.736738
R3007 comparator_slice_0.comparator_body_0.mref_m5_diff_0.tail.n3 comparator_slice_0.comparator_body_0.mref_m5_diff_0.tail.n2 0.292277
R3008 comparator_slice_0.comparator_body_0.m1_m2_diff_0.m1_m2_array_3/n1_2_4.S comparator_slice_0.comparator_body_0.mref_m5_diff_0.tail.n0 3.1252
R3009 comparator_slice_0.comparator_body_0.m1_m2_diff_0.m1_m2_array_0/n1_2_4.S comparator_slice_0.comparator_body_0.mref_m5_diff_0.tail.n3 3.12476
R3010 comparator_slice_0.comparator_body_0.mref_m5_diff_0.tail.n42 comparator_slice_0.comparator_body_0.mref_m5_diff_0.tail.n41 0.694916
R3011 comparator_slice_0.comparator_body_0.mref_m5_diff_0.tail.n45 comparator_slice_0.comparator_body_0.mref_m5_diff_0.tail.n11 0.785418
R3012 comparator_slice_0.comparator_body_0.mref_m5_diff_0.tail.n46 comparator_slice_0.comparator_body_0.mref_m5_diff_0.tail.n12 0.785418
R3013 comparator_slice_0.comparator_body_0.mref_m5_diff_0.tail.n0 comparator_slice_0.comparator_body_0.m1_m2_diff_0.m1_m2_array_3/n1_2_14.S 3.27705
R3014 comparator_slice_0.comparator_body_0.mref_m5_diff_0.tail.n3 comparator_slice_0.comparator_body_0.m1_m2_diff_0.m1_m2_array_2/n1_2_14.S 3.13704
R3015 comparator_slice_0.comparator_body_0.m1_m2_diff_0.m1_m2_array_0/n1_2_15.S comparator_slice_0.comparator_body_0.mref_m5_diff_0.tail.n3 3.3218
R3016 comparator_slice_0.comparator_body_0.mref_m5_diff_0.tail.n18 comparator_slice_0.comparator_body_0.mref_m5_diff_0.tail.n3 0.230649
R3017 comparator_slice_0.comparator_body_0.mref_m5_diff_0.tail.n18 comparator_slice_0.comparator_body_0.mref_m5_diff_0.tail.n16 0.673421
R3018 comparator_slice_0.comparator_body_0.mref_m5_diff_0.tail.n20 comparator_slice_0.comparator_body_0.mref_m5_diff_0.tail.n51 0.651351
R3019 comparator_slice_0.comparator_body_0.m1_m2_diff_0.m1_m2_array_2/n1_2_8.S comparator_slice_0.comparator_body_0.mref_m5_diff_0.tail.n0 3.30412
R3020 comparator_slice_0.comparator_body_0.m1_m2_diff_0.m1_m2_array_0/n1_2_8.S comparator_slice_0.comparator_body_0.mref_m5_diff_0.tail.n3 3.33189
R3021 comparator_slice_0.comparator_body_0.mref_m5_diff_0.tail.n51 comparator_slice_0.comparator_body_0.mref_m5_diff_0.tail.n3 0.632488
R3022 comparator_slice_0.comparator_body_0.mref_m5_diff_0.tail.n2 comparator_slice_0.comparator_body_0.mref_m5_diff_0.tail.n10 0.613015
R3023 comparator_slice_0.comparator_body_0.mref_m5_diff_0.tail.n72 comparator_slice_0.comparator_body_0.mref_m5_diff_0.tail.n76 0.57778
R3024 comparator_slice_0.comparator_body_0.mref_m5_diff_0.tail.n92 comparator_slice_0.comparator_body_0.mref_m5_diff_0.tail.n68 0.57778
R3025 comparator_slice_0.comparator_body_0.mref_m5_diff_0.tail.n112 comparator_slice_0.comparator_body_0.mref_m5_diff_0.tail.n52 0.57778
R3026 comparator_slice_0.comparator_body_0.mref_m5_diff_0.tail.n102 comparator_slice_0.comparator_body_0.mref_m5_diff_0.tail.n98 0.57778
R3027 comparator_slice_0.comparator_body_0.mref_m5_diff_0.tail.n39 comparator_slice_0.comparator_body_0.mref_m5_diff_0.tail.n38 0.5769
R3028 comparator_slice_0.comparator_body_0.mref_m5_diff_0.tail.n35 comparator_slice_0.comparator_body_0.mref_m5_diff_0.tail.n34 0.5769
R3029 comparator_slice_0.comparator_body_0.mref_m5_diff_0.tail.n31 comparator_slice_0.comparator_body_0.mref_m5_diff_0.tail.n29 0.5769
R3030 comparator_slice_0.comparator_body_0.mref_m5_diff_0.tail.n27 comparator_slice_0.comparator_body_0.mref_m5_diff_0.tail.n26 0.5769
R3031 comparator_slice_0.comparator_body_0.mref_m5_diff_0.tail.n82 comparator_slice_0.comparator_body_0.mref_m5_diff_0.tail.n81 0.5637
R3032 comparator_slice_0.comparator_body_0.mref_m5_diff_0.tail.n85 comparator_slice_0.comparator_body_0.mref_m5_diff_0.tail.n83 0.5637
R3033 comparator_slice_0.comparator_body_0.mref_m5_diff_0.tail.n108 comparator_slice_0.comparator_body_0.mref_m5_diff_0.tail.n107 0.5637
R3034 comparator_slice_0.comparator_body_0.mref_m5_diff_0.tail.n61 comparator_slice_0.comparator_body_0.mref_m5_diff_0.tail.n55 0.5637
R3035 comparator_slice_0.comparator_body_0.mref_m5_diff_0.tail.n91 comparator_slice_0.comparator_body_0.mref_m5_diff_0.tail.n69 0.5593
R3036 comparator_slice_0.comparator_body_0.mref_m5_diff_0.tail.n97 comparator_slice_0.comparator_body_0.mref_m5_diff_0.tail.n96 0.5593
R3037 comparator_slice_0.comparator_body_0.mref_m5_diff_0.tail.n111 comparator_slice_0.comparator_body_0.mref_m5_diff_0.tail.n53 0.5593
R3038 comparator_slice_0.comparator_body_0.mref_m5_diff_0.tail.n89 comparator_slice_0.comparator_body_0.mref_m5_diff_0.tail.n88 0.54346
R3039 comparator_slice_0.comparator_body_0.mref_m5_diff_0.tail.n105 comparator_slice_0.comparator_body_0.mref_m5_diff_0.tail.n65 0.54346
R3040 comparator_slice_0.comparator_body_0.mref_m5_diff_0.tail.n109 comparator_slice_0.comparator_body_0.mref_m5_diff_0.tail.n64 0.54346
R3041 comparator_slice_0.comparator_body_0.mref_m5_diff_0.tail.n28 comparator_slice_0.comparator_body_0.mref_m5_diff_0.tail.n70 0.52058
R3042 comparator_slice_0.comparator_body_0.mref_m5_diff_0.tail.n24 comparator_slice_0.comparator_body_0.mref_m5_diff_0.tail.n67 0.52058
R3043 comparator_slice_0.comparator_body_0.mref_m5_diff_0.tail.n33 comparator_slice_0.comparator_body_0.mref_m5_diff_0.tail.n54 0.52058
R3044 comparator_slice_0.comparator_body_0.mref_m5_diff_0.tail.n36 comparator_slice_0.comparator_body_0.mref_m5_diff_0.tail.n59 0.52058
R3045 comparator_slice_0.comparator_body_0.mref_m5_diff_0.tail.n87 comparator_slice_0.comparator_body_0.mref_m5_diff_0.tail.n25 0.5197
R3046 comparator_slice_0.comparator_body_0.mref_m5_diff_0.tail.n80 comparator_slice_0.comparator_body_0.mref_m5_diff_0.tail.n31 0.5197
R3047 comparator_slice_0.comparator_body_0.mref_m5_diff_0.tail.n30 comparator_slice_0.comparator_body_0.mref_m5_diff_0.tail.n79 0.5197
R3048 comparator_slice_0.comparator_body_0.mref_m5_diff_0.tail.n84 comparator_slice_0.comparator_body_0.mref_m5_diff_0.tail.n27 0.5197
R3049 comparator_slice_0.comparator_body_0.mref_m5_diff_0.tail.n104 comparator_slice_0.comparator_body_0.mref_m5_diff_0.tail.n103 0.5197
R3050 comparator_slice_0.comparator_body_0.mref_m5_diff_0.tail.n35 comparator_slice_0.comparator_body_0.mref_m5_diff_0.tail.n32 0.5197
R3051 comparator_slice_0.comparator_body_0.mref_m5_diff_0.tail.n63 comparator_slice_0.comparator_body_0.mref_m5_diff_0.tail.n37 0.5197
R3052 comparator_slice_0.comparator_body_0.mref_m5_diff_0.tail.n60 comparator_slice_0.comparator_body_0.mref_m5_diff_0.tail.n39 0.5197
R3053 comparator_slice_0.comparator_body_0.mref_m5_diff_0.tail.n75 comparator_slice_0.comparator_body_0.mref_m5_diff_0.tail.n74 0.51354
R3054 comparator_slice_0.comparator_body_0.mref_m5_diff_0.tail.n57 comparator_slice_0.comparator_body_0.mref_m5_diff_0.tail.n50 0.50826
R3055 comparator_slice_0.comparator_body_0.mref_m5_diff_0.tail.n95 comparator_slice_0.comparator_body_0.mref_m5_diff_0.tail.n94 0.49858
R3056 comparator_slice_0.comparator_body_0.mref_m5_diff_0.tail.n101 comparator_slice_0.comparator_body_0.mref_m5_diff_0.tail.n100 0.49242
R3057 comparator_slice_0.comparator_body_0.mref_m5_diff_0.tail.n23 comparator_slice_0.comparator_body_0.mref_m5_diff_0.tail.n3 0.496177
R3058 comparator_slice_0.comparator_body_0.mref_m5_diff_0.tail.n114 comparator_slice_0.comparator_body_0.mref_m5_diff_0.tail.n19 0.47042
R3059 comparator_slice_0.comparator_body_0.m1_m2_diff_0.m1_m2_array_3/n1_2_11.S comparator_slice_0.comparator_body_0.mref_m5_diff_0.tail.n4 3.158
R3060 comparator_slice_0.comparator_body_0.mref_m5_diff_0.tail.n41 comparator_slice_0.comparator_body_0.mref_m5_diff_0.tail.n8 0.46954
R3061 comparator_slice_0.comparator_body_0.mref_m5_diff_0.tail.n44 comparator_slice_0.comparator_body_0.mref_m5_diff_0.tail.n3 0.472548
R3062 comparator_slice_0.comparator_body_0.mref_m5_diff_0.tail.n43 comparator_slice_0.comparator_body_0.mref_m5_diff_0.tail.n2 0.46954
R3063 comparator_slice_0.comparator_body_0.mref_m5_diff_0.tail.n45 comparator_slice_0.comparator_body_0.mref_m5_diff_0.tail.n7 0.551024
R3064 comparator_slice_0.comparator_body_0.mref_m5_diff_0.tail.n49 comparator_slice_0.comparator_body_0.mref_m5_diff_0.tail.n3 0.46954
R3065 comparator_slice_0.comparator_body_0.mref_m5_diff_0.tail.n47 comparator_slice_0.comparator_body_0.mref_m5_diff_0.tail.n13 0.46954
R3066 comparator_slice_0.comparator_body_0.mref_m5_diff_0.tail.n72 comparator_slice_0.comparator_body_0.mref_m5_diff_0.tail.n77 0.46074
R3067 comparator_slice_0.comparator_body_0.mref_m5_diff_0.tail.n99 comparator_slice_0.comparator_body_0.mref_m5_diff_0.tail.n98 0.45722
R3068 comparator_slice_0.comparator_body_0.mref_m5_diff_0.tail.n95 comparator_slice_0.comparator_body_0.mref_m5_diff_0.tail.n68 0.45458
R3069 comparator_slice_0.comparator_body_0.mref_m5_diff_0.tail.n76 comparator_slice_0.comparator_body_0.mref_m5_diff_0.tail.n75 0.45458
R3070 comparator_slice_0.comparator_body_0.mref_m5_diff_0.tail.n102 comparator_slice_0.comparator_body_0.mref_m5_diff_0.tail.n101 0.45458
R3071 comparator_slice_0.comparator_body_0.mref_m5_diff_0.tail.n57 comparator_slice_0.comparator_body_0.mref_m5_diff_0.tail.n52 0.45458
R3072 comparator_slice_0.comparator_body_0.mref_m5_diff_0.tail.n81 comparator_slice_0.comparator_body_0.mref_m5_diff_0.tail.n71 0.45282
R3073 comparator_slice_0.comparator_body_0.mref_m5_diff_0.tail.n86 comparator_slice_0.comparator_body_0.mref_m5_diff_0.tail.n85 0.45282
R3074 comparator_slice_0.comparator_body_0.mref_m5_diff_0.tail.n107 comparator_slice_0.comparator_body_0.mref_m5_diff_0.tail.n106 0.45282
R3075 comparator_slice_0.comparator_body_0.mref_m5_diff_0.tail.n62 comparator_slice_0.comparator_body_0.mref_m5_diff_0.tail.n61 0.45282
R3076 comparator_slice_0.comparator_body_0.mref_m5_diff_0.tail.n113 comparator_slice_0.comparator_body_0.mref_m5_diff_0.tail.n112 0.45106
R3077 comparator_slice_0.comparator_body_0.mref_m5_diff_0.tail.n1 comparator_slice_0.comparator_body_0.mref_m5_diff_0.tail.n20 0.430045
R3078 comparator_slice_0.comparator_body_0.mref_m5_diff_0.tail.n10 comparator_slice_0.comparator_body_0.mref_m5_diff_0.tail.n0 0.426559
R3079 comparator_slice_0.comparator_body_0.mref_m5_diff_0.tail.n93 comparator_slice_0.comparator_body_0.mref_m5_diff_0.tail.n92 0.42642
R3080 comparator_slice_0.comparator_body_0.mref_m5_diff_0.tail.n15 comparator_slice_0.comparator_body_0.mref_m5_diff_0.tail.n19 0.0772902
R3081 comparator_slice_0.comparator_body_0.mref_m5_diff_0.tail.n41 comparator_slice_0.comparator_body_0.mref_m5_diff_0.tail.n40 0.38648
R3082 comparator_slice_0.comparator_body_0.mref_m5_diff_0.tail.n11 comparator_slice_0.comparator_body_0.m1_m2_diff_0.m1_m2_array_0/n1_2_10.S 3.22467
R3083 comparator_slice_0.comparator_body_0.mref_m5_diff_0.tail.n12 comparator_slice_0.comparator_body_0.m1_m2_diff_0.m1_m2_array_1/n1_2_10.S 3.22467
R3084 comparator_slice_0.comparator_body_0.mref_m5_diff_0.tail.n22 comparator_slice_0.comparator_body_0.mref_m5_diff_0.tail.n21 0.368183
R3085 comparator_slice_0.comparator_body_0.mref_m5_diff_0.tail.n18 comparator_slice_0.comparator_body_0.mref_m5_diff_0.tail.n17 0.3657
R3086 comparator_slice_0.comparator_body_0.m1_m2_diff_0.tail comparator_slice_0.comparator_body_0.mref_m5_diff_0.tail.n3 0.35866
R3087 comparator_slice_0.comparator_body_0.m1_m2_diff_0.m1_m2_array_3/n1_2_7.S comparator_slice_0.comparator_body_0.mref_m5_diff_0.tail.n0 3.15561
R3088 comparator_slice_0.comparator_body_0.mref_m5_diff_0.tail.n3 comparator_slice_0.comparator_body_0.m1_m2_diff_0.m1_m2_array_0/n1_2_7.S 3.13703
R3089 comparator_slice_0.comparator_body_0.mref_m5_diff_0.tail.n3 comparator_slice_0.comparator_body_0.m1_m2_diff_0.m1_m2_array_1/n1_2_7.S 3.18015
R3090 comparator_slice_0.comparator_body_0.mref_m5_diff_0.tail.n0 comparator_slice_0.comparator_body_0.m1_m2_diff_0.m1_m2_array_2/n1_2_7.S 3.18015
R3091 comparator_slice_0.comparator_body_0.mref_m5_diff_0.tail.n0 comparator_slice_0.comparator_body_0.m1_m2_diff_0.m1_m2_array_3/n1_2_0.S 3.16128
R3092 comparator_slice_0.comparator_body_0.mref_m5_diff_0.tail.n43 comparator_slice_0.comparator_body_0.mref_m5_diff_0.tail.n42 0.344658
R3093 comparator_slice_0.comparator_body_0.mref_m5_diff_0.tail.n47 comparator_slice_0.comparator_body_0.mref_m5_diff_0.tail.n46 0.344658
R3094 comparator_slice_0.comparator_body_0.mref_m5_diff_0.tail.n9 comparator_slice_0.comparator_body_0.mref_m5_diff_0.tail.n8 0.0751681
R3095 comparator_slice_0.comparator_body_0.mref_m5_diff_0.tail.n26 comparator_slice_0.comparator_body_0.mref_m5_diff_0.tail.n68 0.3041
R3096 comparator_slice_0.comparator_body_0.mref_m5_diff_0.tail.n76 comparator_slice_0.comparator_body_0.mref_m5_diff_0.tail.n29 0.3041
R3097 comparator_slice_0.comparator_body_0.mref_m5_diff_0.tail.n3 comparator_slice_0.comparator_body_0.m1_m2_diff_0.m1_m2_array_0/n1_2_3.S 3.14266
R3098 comparator_slice_0.comparator_body_0.mref_m5_diff_0.tail.n34 comparator_slice_0.comparator_body_0.mref_m5_diff_0.tail.n102 0.3041
R3099 comparator_slice_0.comparator_body_0.mref_m5_diff_0.tail.n3 comparator_slice_0.comparator_body_0.m1_m2_diff_0.m1_m2_array_1/n1_2_3.S 3.14266
R3100 comparator_slice_0.comparator_body_0.mref_m5_diff_0.tail.n38 comparator_slice_0.comparator_body_0.mref_m5_diff_0.tail.n52 0.3041
R3101 comparator_slice_0.comparator_body_0.mref_m5_diff_0.tail.n2 comparator_slice_0.comparator_body_0.m1_m2_diff_0.m1_m2_array_2/n1_2_3.S 3.14266
R3102 comparator_slice_0.comparator_body_0.m1_m2_diff_0.m1_m2_array_3/n1_2_3.S comparator_slice_0.comparator_body_0.mref_m5_diff_0.tail.n0 3.14266
R3103 comparator_slice_0.comparator_body_0.mref_m5_diff_0.tail.n88 comparator_slice_0.comparator_body_0.mref_m5_diff_0.tail.n87 0.30322
R3104 comparator_slice_0.comparator_body_0.mref_m5_diff_0.tail.n81 comparator_slice_0.comparator_body_0.mref_m5_diff_0.tail.n80 0.30322
R3105 comparator_slice_0.comparator_body_0.mref_m5_diff_0.tail.n79 comparator_slice_0.comparator_body_0.mref_m5_diff_0.tail.n78 0.30322
R3106 comparator_slice_0.comparator_body_0.mref_m5_diff_0.tail.n85 comparator_slice_0.comparator_body_0.mref_m5_diff_0.tail.n84 0.30322
R3107 comparator_slice_0.comparator_body_0.mref_m5_diff_0.tail.n105 comparator_slice_0.comparator_body_0.mref_m5_diff_0.tail.n104 0.30322
R3108 comparator_slice_0.comparator_body_0.mref_m5_diff_0.tail.n107 comparator_slice_0.comparator_body_0.mref_m5_diff_0.tail.n32 0.30322
R3109 comparator_slice_0.comparator_body_0.mref_m5_diff_0.tail.n64 comparator_slice_0.comparator_body_0.mref_m5_diff_0.tail.n63 0.30322
R3110 comparator_slice_0.comparator_body_0.mref_m5_diff_0.tail.n61 comparator_slice_0.comparator_body_0.mref_m5_diff_0.tail.n60 0.30322
R3111 comparator_slice_0.comparator_body_0.mref_m5_diff_0.tail.n70 comparator_slice_0.comparator_body_0.mref_m5_diff_0.tail.n69 0.30234
R3112 comparator_slice_0.comparator_body_0.mref_m5_diff_0.tail.n96 comparator_slice_0.comparator_body_0.mref_m5_diff_0.tail.n67 0.30234
R3113 comparator_slice_0.comparator_body_0.mref_m5_diff_0.tail.n54 comparator_slice_0.comparator_body_0.mref_m5_diff_0.tail.n53 0.30234
R3114 comparator_slice_0.comparator_body_0.mref_m5_diff_0.tail.n59 comparator_slice_0.comparator_body_0.mref_m5_diff_0.tail.n58 0.30234
R3115 comparator_slice_0.comparator_body_0.mref_m5_diff_0.tail.n49 comparator_slice_0.comparator_body_0.mref_m5_diff_0.tail.n48 0.29848
R3116 comparator_slice_0.comparator_body_0.mref_m5_diff_0.tail.n91 comparator_slice_0.comparator_body_0.mref_m5_diff_0.tail.n90 0.25746
R3117 comparator_slice_0.comparator_body_0.mref_m5_diff_0.tail.n90 comparator_slice_0.comparator_body_0.mref_m5_diff_0.tail.n89 0.25746
R3118 comparator_slice_0.comparator_body_0.mref_m5_diff_0.tail.n97 comparator_slice_0.comparator_body_0.mref_m5_diff_0.tail.n66 0.25746
R3119 comparator_slice_0.comparator_body_0.mref_m5_diff_0.tail.n66 comparator_slice_0.comparator_body_0.mref_m5_diff_0.tail.n65 0.25746
R3120 comparator_slice_0.comparator_body_0.mref_m5_diff_0.tail.n111 comparator_slice_0.comparator_body_0.mref_m5_diff_0.tail.n110 0.25746
R3121 comparator_slice_0.comparator_body_0.mref_m5_diff_0.tail.n110 comparator_slice_0.comparator_body_0.mref_m5_diff_0.tail.n109 0.25746
R3122 comparator_slice_0.comparator_body_0.mref_m5_diff_0.tail.n15 comparator_slice_0.comparator_body_0.m1_m2_diff_0.m1_m2_array_1/n1_2_4.S 3.13489
R3123 comparator_slice_0.comparator_body_0.mref_m5_diff_0.tail.n3 comparator_slice_0.comparator_body_0.m1_m2_diff_0.m1_m2_array_2/n1_2_4.S 3.12476
R3124 comparator_slice_0.comparator_body_0.mref_m5_diff_0.tail.n115 comparator_slice_0.comparator_body_0.mref_m5_diff_0.tail.n114 0.256658
R3125 comparator_slice_0.comparator_body_0.m1_m2_diff_0.m1_m2_array_1/n1_2_14.S comparator_slice_0.comparator_body_0.mref_m5_diff_0.tail.n3 3.12754
R3126 comparator_slice_0.comparator_body_0.mref_m5_diff_0.tail.n22 comparator_slice_0.comparator_body_0.mref_m5_diff_0.tail.n3 1.13561
R3127 comparator_slice_0.comparator_body_0.mref_m5_diff_0.tail.n15 comparator_slice_0.comparator_body_0.mref_m5_diff_0.tail.n3 1.09901
R3128 comparator_slice_0.comparator_body_0.mref_m5_diff_0.tail.n5 comparator_slice_0.comparator_body_0.mref_m5_diff_0.tail.n0 1.07789
R3129 comparator_slice_0.comparator_body_0.mref_m5_diff_0.tail.n14 comparator_slice_0.comparator_body_0.mref_m5_diff_0.tail.n3 1.07597
R3130 comparator_slice_0.comparator_body_0.mref_m5_diff_0.tail.n0 comparator_slice_0.comparator_body_0.mref_m5_diff_0.tail.n4 1.07543
R3131 comparator_slice_0.comparator_body_0.mref_m5_diff_0.tail.n3 comparator_slice_0.comparator_body_0.mref_m5_diff_0.tail.n7 1.04209
R3132 comparator_slice_0.comparator_body_0.mref_m5_diff_0.tail.n9 comparator_slice_0.comparator_body_0.mref_m5_diff_0.tail.n0 1.01918
R3133 comparator_slice_0.comparator_body_0.m3_m4_diff_0.n1.n41 comparator_slice_0.comparator_body_0.m3_m4_diff_0.n1.n16 10.3502
R3134 comparator_slice_0.comparator_body_0.m3_m4_diff_0.n1.n57 comparator_slice_0.comparator_body_0.m3_m4_diff_0.m3_m4_array_1/p1_2$1_13.D 10.3502
R3135 comparator_slice_0.comparator_body_0.m3_m4_diff_0.n1.n34 comparator_slice_0.comparator_body_0.m3_m4_diff_0.m3_m4_array_1/p1_2$1_13.D 10.3502
R3136 comparator_slice_0.comparator_body_0.m3_m4_diff_0.n1.n33 comparator_slice_0.comparator_body_0.m3_m4_diff_0.n1.n17 10.3502
R3137 comparator_slice_0.comparator_body_0.m3_m4_diff_0.m3_m4_array_2/p1_2$1_9.D comparator_slice_0.comparator_body_0.m3_m4_diff_0.n1.n54 10.3502
R3138 comparator_slice_0.comparator_body_0.m3_m4_diff_0.n1.n61 comparator_slice_0.comparator_body_0.m3_m4_diff_0.m3_m4_array_0/p1_2$1_13.D 10.3502
R3139 comparator_slice_0.comparator_body_0.m3_m4_diff_0.n1.n20 comparator_slice_0.comparator_body_0.m3_m4_diff_0.n1.n60 8.82038
R3140 comparator_slice_0.comparator_body_0.m3_m4_diff_0.m3_m4_array_1/p1_2$1_13.D comparator_slice_0.comparator_body_0.m3_m4_diff_0.n1.t46 4.98207
R3141 comparator_slice_0.comparator_body_0.m3_m4_diff_0.m3_m4_array_1/p1_2$1_13.D comparator_slice_0.comparator_body_0.m3_m4_diff_0.n1.t60 4.98207
R3142 comparator_slice_0.comparator_body_0.m3_m4_diff_0.n1.n40 comparator_slice_0.comparator_body_0.m3_m4_diff_0.n1.t78 2.19641
R3143 comparator_slice_0.comparator_body_0.m3_m4_diff_0.m3_m4_array_1/p1_2$1_13.D comparator_slice_0.comparator_body_0.m3_m4_diff_0.n1.t58 4.98207
R3144 comparator_slice_0.comparator_body_0.m3_m4_diff_0.n1.n49 comparator_slice_0.comparator_body_0.m3_m4_diff_0.n1.t38 4.9771
R3145 comparator_slice_0.comparator_body_0.m3_m4_diff_0.m3_m4_array_1/p1_2$1_13.D comparator_slice_0.comparator_body_0.m3_m4_diff_0.n1.t64 4.9771
R3146 comparator_slice_0.comparator_body_0.m3_m4_diff_0.m3_m4_array_1/p1_2$1_13.D comparator_slice_0.comparator_body_0.m3_m4_diff_0.n1.t32 4.9771
R3147 comparator_slice_0.comparator_body_0.m3_m4_diff_0.n1.t52 comparator_slice_0.comparator_body_0.m3_m4_diff_0.n1.n42 4.98207
R3148 comparator_slice_0.comparator_body_0.m3_m4_diff_0.n1.n42 comparator_slice_0.comparator_body_0.m3_m4_diff_0.n1.t42 4.98207
R3149 comparator_slice_0.comparator_body_0.m3_m4_diff_0.n1.t84 comparator_slice_0.comparator_body_0.m3_m4_diff_0.n1.n42 4.98207
R3150 comparator_slice_0.comparator_body_0.m3_m4_diff_0.n1.t56 comparator_slice_0.comparator_body_0.m3_m4_diff_0.n1.n42 4.98207
R3151 comparator_slice_0.comparator_body_0.m3_m4_diff_0.n1.t74 comparator_slice_0.comparator_body_0.m3_m4_diff_0.n1.n42 4.9771
R3152 comparator_slice_0.comparator_body_0.m3_m4_diff_0.n1.n12 comparator_slice_0.comparator_body_0.m3_m4_diff_0.n1.t40 2.19423
R3153 comparator_slice_0.comparator_body_0.m3_m4_diff_0.n1.t44 comparator_slice_0.comparator_body_0.m3_m4_diff_0.n1.n42 4.9771
R3154 comparator_slice_0.comparator_body_0.m3_m4_diff_0.n1.n42 comparator_slice_0.comparator_body_0.m3_m4_diff_0.n1.t92 4.9771
R3155 comparator_slice_0.comparator_body_0.m3_m4_diff_0.n1.n46 comparator_slice_0.comparator_body_0.m3_m4_diff_0.n1.t66 2.1764
R3156 comparator_slice_0.comparator_body_0.m3_m4_diff_0.n1.n44 comparator_slice_0.comparator_body_0.m3_m4_diff_0.n1.t88 4.98207
R3157 comparator_slice_0.comparator_body_0.m3_m4_diff_0.n1.n44 comparator_slice_0.comparator_body_0.m3_m4_diff_0.n1.n45 0.574581
R3158 comparator_slice_0.comparator_body_0.m3_m4_diff_0.n1.n17 comparator_slice_0.comparator_body_0.m3_m4_diff_0.n1.t48 4.98207
R3159 comparator_slice_0.comparator_body_0.m3_m4_diff_0.n1.n44 comparator_slice_0.comparator_body_0.m3_m4_diff_0.n1.t94 4.98207
R3160 comparator_slice_0.comparator_body_0.m3_m4_diff_0.n1.n44 comparator_slice_0.comparator_body_0.m3_m4_diff_0.n1.t54 4.9771
R3161 comparator_slice_0.comparator_body_0.m3_m4_diff_0.n1.n44 comparator_slice_0.comparator_body_0.m3_m4_diff_0.n1.t62 4.9771
R3162 comparator_slice_0.comparator_body_0.m3_m4_diff_0.n1.n44 comparator_slice_0.comparator_body_0.m3_m4_diff_0.n1.t34 4.9771
R3163 comparator_slice_0.comparator_body_0.m3_m4_diff_0.m3_m4_array_1/p1_2$1_14.D comparator_slice_0.comparator_body_0.m3_m4_diff_0.n1.t64 4.93952
R3164 comparator_slice_0.comparator_body_0.m3_m4_diff_0.m3_m4_array_2/p1_2$1_14.D comparator_slice_0.comparator_body_0.m3_m4_diff_0.n1.t54 4.93952
R3165 comparator_slice_0.comparator_body_0.m3_m4_diff_0.n1.t68 comparator_slice_0.comparator_body_0.m3_m4_diff_0.n1.n35 2.19201
R3166 comparator_slice_0.comparator_body_0.m1_m2_diff_0.m1_m2_array_3/n1_2_4.D comparator_slice_0.comparator_body_0.m3_m4_diff_0.n1.t0 5.76088
R3167 comparator_slice_0.comparator_body_0.m3_m4_diff_0.m3_m4_array_1/p1_2$1_14.D comparator_slice_0.comparator_body_0.m3_m4_diff_0.n1.t65 2.41949
R3168 comparator_slice_0.comparator_body_0.m3_m4_diff_0.m3_m4_array_2/p1_2$1_14.D comparator_slice_0.comparator_body_0.m3_m4_diff_0.n1.t55 2.41949
R3169 comparator_slice_0.comparator_body_0.m3_m4_diff_0.m3_m4_array_3/p1_2$1_14.D comparator_slice_0.comparator_body_0.m3_m4_diff_0.n1.t69 2.41949
R3170 comparator_slice_0.comparator_body_0.m3_m4_diff_0.m3_m4_array_0/p1_2$1_14.D comparator_slice_0.comparator_body_0.m3_m4_diff_0.n1.t41 2.41949
R3171 comparator_slice_0.comparator_body_0.m3_m4_diff_0.n1.n39 comparator_slice_0.comparator_body_0.m3_m4_diff_0.n1.n29 5.17146
R3172 comparator_slice_0.comparator_body_0.m3_m4_diff_0.n1.n23 comparator_slice_0.comparator_body_0.m3_m4_diff_0.n1.t50 4.96805
R3173 comparator_slice_0.comparator_body_0.m3_m4_diff_0.n1.n23 comparator_slice_0.comparator_body_0.m3_m4_diff_0.n1.t82 4.96805
R3174 comparator_slice_0.comparator_body_0.m3_m4_diff_0.n1.t72 comparator_slice_0.comparator_body_0.m3_m4_diff_0.n1.n30 2.21935
R3175 comparator_slice_0.comparator_body_0.m3_m4_diff_0.n1.t90 comparator_slice_0.comparator_body_0.m3_m4_diff_0.n1.n31 2.21646
R3176 comparator_slice_0.comparator_body_0.m3_m4_diff_0.n1.n22 comparator_slice_0.comparator_body_0.m3_m4_diff_0.n1.t76 4.96805
R3177 comparator_slice_0.comparator_body_0.m3_m4_diff_0.n1.n22 comparator_slice_0.comparator_body_0.m3_m4_diff_0.n1.t70 4.96805
R3178 comparator_slice_0.comparator_body_0.m3_m4_diff_0.n1.n21 comparator_slice_0.comparator_body_0.m3_m4_diff_0.n1.t80 4.96805
R3179 comparator_slice_0.comparator_body_0.m3_m4_diff_0.m3_m4_array_3/p1_2$1_13.D comparator_slice_0.comparator_body_0.m3_m4_diff_0.n1.n30 0.518752
R3180 comparator_slice_0.comparator_body_0.m3_m4_diff_0.m3_m4_array_1/p1_2$1_13.D comparator_slice_0.comparator_body_0.m3_m4_diff_0.n1.t86 2.2495
R3181 comparator_slice_0.comparator_body_0.m3_m4_diff_0.n1.t34 comparator_slice_0.comparator_body_0.m3_m4_diff_0.m3_m4_array_2/p1_2$1_13.D 4.9444
R3182 comparator_slice_0.comparator_body_0.m3_m4_diff_0.n1.t92 comparator_slice_0.comparator_body_0.m3_m4_diff_0.m3_m4_array_0/p1_2$1_13.D 4.9444
R3183 comparator_slice_0.comparator_body_0.m3_m4_diff_0.n1.t84 comparator_slice_0.comparator_body_0.m3_m4_diff_0.m3_m4_array_3/p1_2$1_4.D 4.94339
R3184 comparator_slice_0.comparator_body_0.m3_m4_diff_0.m3_m4_array_2/p1_2$1_4.D comparator_slice_0.comparator_body_0.m3_m4_diff_0.n1.t70 4.94339
R3185 comparator_slice_0.comparator_body_0.m3_m4_diff_0.n1.n45 comparator_slice_0.comparator_body_0.m3_m4_diff_0.n1.t36 2.19641
R3186 comparator_slice_0.comparator_body_0.m3_m4_diff_0.m3_m4_array_0/p1_2$1_1.D comparator_slice_0.comparator_body_0.m3_m4_diff_0.n1.t46 4.94339
R3187 comparator_slice_0.comparator_body_0.m3_m4_diff_0.n1.t52 comparator_slice_0.comparator_body_0.m3_m4_diff_0.m3_m4_array_3/p1_2$1_1.D 4.94339
R3188 comparator_slice_0.comparator_body_0.m3_m4_diff_0.n1.n46 comparator_slice_0.comparator_body_0.m3_m4_diff_0.m3_m4_array_1/p1_2$1_1.D 0.607819
R3189 comparator_slice_0.comparator_body_0.m3_m4_diff_0.m3_m4_array_2/p1_2$1_1.D comparator_slice_0.comparator_body_0.m3_m4_diff_0.n1.n31 0.523964
R3190 comparator_slice_0.comparator_body_0.m3_m4_diff_0.n1.t56 comparator_slice_0.comparator_body_0.m3_m4_diff_0.m3_m4_array_3/p1_2$1_4.D 4.89895
R3191 comparator_slice_0.comparator_body_0.m3_m4_diff_0.n1.t82 comparator_slice_0.comparator_body_0.m3_m4_diff_0.n1.n8 4.89895
R3192 comparator_slice_0.comparator_body_0.m3_m4_diff_0.n1.t50 comparator_slice_0.comparator_body_0.m3_m4_diff_0.m3_m4_array_3/p1_2$1_14.D 4.89895
R3193 comparator_slice_0.comparator_body_0.m3_m4_diff_0.n1.n3 comparator_slice_0.comparator_body_0.m3_m4_diff_0.n1.t32 4.89895
R3194 comparator_slice_0.comparator_body_0.m3_m4_diff_0.n1.t48 comparator_slice_0.comparator_body_0.m3_m4_diff_0.m3_m4_array_1/p1_2$1_4.D 4.89895
R3195 comparator_slice_0.comparator_body_0.m3_m4_diff_0.m3_m4_array_2/p1_2$1_4.D comparator_slice_0.comparator_body_0.m3_m4_diff_0.n1.t80 4.89895
R3196 comparator_slice_0.comparator_body_0.m3_m4_diff_0.n1.n5 comparator_slice_0.comparator_body_0.m3_m4_diff_0.n1.t62 4.89895
R3197 comparator_slice_0.comparator_body_0.m3_m4_diff_0.n1.n2 comparator_slice_0.comparator_body_0.m3_m4_diff_0.n1.t88 4.89895
R3198 comparator_slice_0.comparator_body_0.m3_m4_diff_0.n1.t76 comparator_slice_0.comparator_body_0.m3_m4_diff_0.n1.n4 4.89895
R3199 comparator_slice_0.comparator_body_0.m3_m4_diff_0.n1.t94 comparator_slice_0.comparator_body_0.m3_m4_diff_0.m3_m4_array_2/p1_2$1_14.D 4.89895
R3200 comparator_slice_0.comparator_body_0.m3_m4_diff_0.m3_m4_array_1/p1_2$1_14.D comparator_slice_0.comparator_body_0.m3_m4_diff_0.n1.t38 4.89895
R3201 comparator_slice_0.comparator_body_0.m3_m4_diff_0.n1.t74 comparator_slice_0.comparator_body_0.m3_m4_diff_0.m3_m4_array_0/p1_2$1_14.D 4.89895
R3202 comparator_slice_0.comparator_body_0.m3_m4_diff_0.n1.t42 comparator_slice_0.comparator_body_0.m3_m4_diff_0.n1.n0 4.89895
R3203 comparator_slice_0.comparator_body_0.m3_m4_diff_0.n1.t44 comparator_slice_0.comparator_body_0.m3_m4_diff_0.n1.n11 4.89895
R3204 comparator_slice_0.comparator_body_0.m3_m4_diff_0.n1.t58 comparator_slice_0.comparator_body_0.m3_m4_diff_0.m3_m4_array_0/p1_2$1_4.D 4.89895
R3205 comparator_slice_0.comparator_body_0.m3_m4_diff_0.n1.n6 comparator_slice_0.comparator_body_0.m3_m4_diff_0.n1.t60 4.89895
R3206 comparator_slice_0.comparator_body_0.m3_m4_diff_0.m3_m4_array_3/p1_2$1_7.D comparator_slice_0.comparator_body_0.m3_m4_diff_0.n1.t83 2.4162
R3207 comparator_slice_0.comparator_body_0.m3_m4_diff_0.m3_m4_array_3/p1_2$1_13.D comparator_slice_0.comparator_body_0.m3_m4_diff_0.n1.t73 2.41712
R3208 comparator_slice_0.comparator_body_0.m3_m4_diff_0.m3_m4_array_1/p1_2$1_7.D comparator_slice_0.comparator_body_0.m3_m4_diff_0.n1.t33 2.4162
R3209 comparator_slice_0.comparator_body_0.m3_m4_diff_0.m3_m4_array_1/p1_2$1_13.D comparator_slice_0.comparator_body_0.m3_m4_diff_0.n1.t87 2.41712
R3210 comparator_slice_0.comparator_body_0.m3_m4_diff_0.m3_m4_array_2/p1_2$1_7.D comparator_slice_0.comparator_body_0.m3_m4_diff_0.n1.t63 2.4162
R3211 comparator_slice_0.comparator_body_0.m3_m4_diff_0.m3_m4_array_2/p1_2$1_13.D comparator_slice_0.comparator_body_0.m3_m4_diff_0.n1.t35 2.41712
R3212 comparator_slice_0.comparator_body_0.m3_m4_diff_0.m3_m4_array_2/p1_2$1_0.D comparator_slice_0.comparator_body_0.m3_m4_diff_0.n1.t95 2.4162
R3213 comparator_slice_0.comparator_body_0.m3_m4_diff_0.m3_m4_array_1/p1_2$1_0.D comparator_slice_0.comparator_body_0.m3_m4_diff_0.n1.t39 2.4162
R3214 comparator_slice_0.comparator_body_0.m3_m4_diff_0.m3_m4_array_0/p1_2$1_0.D comparator_slice_0.comparator_body_0.m3_m4_diff_0.n1.t75 2.4162
R3215 comparator_slice_0.comparator_body_0.m3_m4_diff_0.m3_m4_array_3/p1_2$1_0.D comparator_slice_0.comparator_body_0.m3_m4_diff_0.n1.t51 2.4162
R3216 comparator_slice_0.comparator_body_0.m3_m4_diff_0.m3_m4_array_0/p1_2$1_7.D comparator_slice_0.comparator_body_0.m3_m4_diff_0.n1.t45 2.4162
R3217 comparator_slice_0.comparator_body_0.m3_m4_diff_0.m3_m4_array_0/p1_2$1_13.D comparator_slice_0.comparator_body_0.m3_m4_diff_0.n1.t93 2.41712
R3218 comparator_slice_0.comparator_body_0.m3_m4_diff_0.n1.t0 comparator_slice_0.comparator_body_0.m1_m2_diff_0.m1_m2_array_3/n1_2_4.D 4.30825
R3219 comparator_slice_0.comparator_body_0.m3_m4_diff_0.n1.n39 comparator_slice_0.comparator_body_0.m1_m2_diff_0.m1_m2_array_3/n1_2_11.D 3.75615
R3220 comparator_slice_0.comparator_body_0.m3_m4_diff_0.n1.n25 comparator_slice_0.comparator_body_0.m1_m2_diff_0.m1_m2_array_2/n1_2_14.D 3.38802
R3221 comparator_slice_0.comparator_body_0.m3_m4_diff_0.n1.n26 comparator_slice_0.comparator_body_0.m1_m2_diff_0.m1_m2_array_0/n1_2_14.D 3.38802
R3222 comparator_slice_0.comparator_body_0.m3_m4_diff_0.n1.n27 comparator_slice_0.comparator_body_0.m1_m2_diff_0.m1_m2_array_1/n1_2_14.D 3.38802
R3223 comparator_slice_0.comparator_body_0.m3_m4_diff_0.n1.n24 comparator_slice_0.comparator_body_0.m1_m2_diff_0.m1_m2_array_3/n1_2_14.D 3.38802
R3224 comparator_slice_0.comparator_body_0.m3_m4_diff_0.n1.n36 comparator_slice_0.comparator_body_0.m3_m4_diff_0.n1.n50 2.90186
R3225 comparator_slice_0.comparator_body_0.m1_m2_diff_0.m1_m2_array_3/n1_2_1.D comparator_slice_0.comparator_body_0.m3_m4_diff_0.n1.t16 2.46703
R3226 comparator_slice_0.comparator_body_0.m1_m2_diff_0.m1_m2_array_3/n1_2_2.D comparator_slice_0.comparator_body_0.m3_m4_diff_0.n1.t21 2.46703
R3227 comparator_slice_0.comparator_body_0.m1_m2_diff_0.m1_m2_array_3/n1_2_13.D comparator_slice_0.comparator_body_0.m3_m4_diff_0.n1.t1 2.46703
R3228 comparator_slice_0.comparator_body_0.m1_m2_diff_0.m1_m2_array_2/n1_2_1.D comparator_slice_0.comparator_body_0.m3_m4_diff_0.n1.t26 2.46703
R3229 comparator_slice_0.comparator_body_0.m1_m2_diff_0.m1_m2_array_0/n1_2_1.D comparator_slice_0.comparator_body_0.m3_m4_diff_0.n1.t2 2.46703
R3230 comparator_slice_0.comparator_body_0.m1_m2_diff_0.m1_m2_array_2/n1_2_13.D comparator_slice_0.comparator_body_0.m3_m4_diff_0.n1.t18 2.46703
R3231 comparator_slice_0.comparator_body_0.m1_m2_diff_0.m1_m2_array_2/n1_2_2.D comparator_slice_0.comparator_body_0.m3_m4_diff_0.n1.t9 2.46703
R3232 comparator_slice_0.comparator_body_0.m1_m2_diff_0.m1_m2_array_0/n1_2_2.D comparator_slice_0.comparator_body_0.m3_m4_diff_0.n1.t14 2.46703
R3233 comparator_slice_0.comparator_body_0.m1_m2_diff_0.m1_m2_array_0/n1_2_13.D comparator_slice_0.comparator_body_0.m3_m4_diff_0.n1.t23 2.46703
R3234 comparator_slice_0.comparator_body_0.m1_m2_diff_0.m1_m2_array_1/n1_2_1.D comparator_slice_0.comparator_body_0.m3_m4_diff_0.n1.t6 2.46703
R3235 comparator_slice_0.comparator_body_0.m1_m2_diff_0.m1_m2_array_1/n1_2_2.D comparator_slice_0.comparator_body_0.m3_m4_diff_0.n1.t25 2.46703
R3236 comparator_slice_0.comparator_body_0.m1_m2_diff_0.m1_m2_array_1/n1_2_13.D comparator_slice_0.comparator_body_0.m3_m4_diff_0.n1.t29 2.46703
R3237 comparator_slice_0.comparator_body_0.m1_m2_diff_0.m1_m2_array_3/n1_2_14.D comparator_slice_0.comparator_body_0.m3_m4_diff_0.n1.t15 2.46703
R3238 comparator_slice_0.comparator_body_0.m1_m2_diff_0.m1_m2_array_1/n1_2_14.D comparator_slice_0.comparator_body_0.m3_m4_diff_0.n1.t12 2.46703
R3239 comparator_slice_0.comparator_body_0.m1_m2_diff_0.m1_m2_array_0/n1_2_14.D comparator_slice_0.comparator_body_0.m3_m4_diff_0.n1.t10 2.46703
R3240 comparator_slice_0.comparator_body_0.m1_m2_diff_0.m1_m2_array_2/n1_2_14.D comparator_slice_0.comparator_body_0.m3_m4_diff_0.n1.t28 2.46703
R3241 comparator_slice_0.comparator_body_0.m1_m2_diff_0.m1_m2_array_3/n1_2_7.D comparator_slice_0.comparator_body_0.m3_m4_diff_0.n1.t17 2.45485
R3242 comparator_slice_0.comparator_body_0.m1_m2_diff_0.m1_m2_array_2/n1_2_7.D comparator_slice_0.comparator_body_0.m3_m4_diff_0.n1.t27 2.45485
R3243 comparator_slice_0.comparator_body_0.m1_m2_diff_0.m1_m2_array_2/n1_2_4.D comparator_slice_0.comparator_body_0.m3_m4_diff_0.n1.t11 2.45485
R3244 comparator_slice_0.comparator_body_0.m1_m2_diff_0.m1_m2_array_2/n1_2_10.D comparator_slice_0.comparator_body_0.m3_m4_diff_0.n1.t4 2.45485
R3245 comparator_slice_0.comparator_body_0.m1_m2_diff_0.m1_m2_array_2/n1_2_11.D comparator_slice_0.comparator_body_0.m3_m4_diff_0.n1.t13 2.45485
R3246 comparator_slice_0.comparator_body_0.m1_m2_diff_0.m1_m2_array_0/n1_2_11.D comparator_slice_0.comparator_body_0.m3_m4_diff_0.n1.t31 2.45485
R3247 comparator_slice_0.comparator_body_0.m1_m2_diff_0.m1_m2_array_0/n1_2_10.D comparator_slice_0.comparator_body_0.m3_m4_diff_0.n1.t7 2.45485
R3248 comparator_slice_0.comparator_body_0.m1_m2_diff_0.m1_m2_array_0/n1_2_7.D comparator_slice_0.comparator_body_0.m3_m4_diff_0.n1.t22 2.45485
R3249 comparator_slice_0.comparator_body_0.m1_m2_diff_0.m1_m2_array_0/n1_2_4.D comparator_slice_0.comparator_body_0.m3_m4_diff_0.n1.t5 2.45485
R3250 comparator_slice_0.comparator_body_0.m1_m2_diff_0.m1_m2_array_1/n1_2_7.D comparator_slice_0.comparator_body_0.m3_m4_diff_0.n1.t24 2.45485
R3251 comparator_slice_0.comparator_body_0.m1_m2_diff_0.m1_m2_array_1/n1_2_4.D comparator_slice_0.comparator_body_0.m3_m4_diff_0.n1.t19 2.45485
R3252 comparator_slice_0.comparator_body_0.m1_m2_diff_0.m1_m2_array_1/n1_2_10.D comparator_slice_0.comparator_body_0.m3_m4_diff_0.n1.t20 2.45485
R3253 comparator_slice_0.comparator_body_0.m1_m2_diff_0.m1_m2_array_1/n1_2_11.D comparator_slice_0.comparator_body_0.m3_m4_diff_0.n1.t3 2.45485
R3254 comparator_slice_0.comparator_body_0.m1_m2_diff_0.m1_m2_array_3/n1_2_11.D comparator_slice_0.comparator_body_0.m3_m4_diff_0.n1.t8 2.45485
R3255 comparator_slice_0.comparator_body_0.m1_m2_diff_0.m1_m2_array_3/n1_2_10.D comparator_slice_0.comparator_body_0.m3_m4_diff_0.n1.t30 2.45481
R3256 comparator_slice_0.comparator_body_0.m3_m4_diff_0.m3_m4_array_3/p1_2$1_9.D comparator_slice_0.comparator_body_0.m3_m4_diff_0.n1.t57 2.40771
R3257 comparator_slice_0.comparator_body_0.m3_m4_diff_0.m3_m4_array_3/p1_2$1_4.D comparator_slice_0.comparator_body_0.m3_m4_diff_0.n1.t85 2.40771
R3258 comparator_slice_0.comparator_body_0.m3_m4_diff_0.m3_m4_array_2/p1_2$1_9.D comparator_slice_0.comparator_body_0.m3_m4_diff_0.n1.t81 2.40771
R3259 comparator_slice_0.comparator_body_0.m3_m4_diff_0.m3_m4_array_2/p1_2$1_4.D comparator_slice_0.comparator_body_0.m3_m4_diff_0.n1.t71 2.40771
R3260 comparator_slice_0.comparator_body_0.m3_m4_diff_0.m3_m4_array_1/p1_2$1_9.D comparator_slice_0.comparator_body_0.m3_m4_diff_0.n1.t49 2.40771
R3261 comparator_slice_0.comparator_body_0.m3_m4_diff_0.m3_m4_array_1/p1_2$1_4.D comparator_slice_0.comparator_body_0.m3_m4_diff_0.n1.t37 2.40771
R3262 comparator_slice_0.comparator_body_0.m3_m4_diff_0.m3_m4_array_1/p1_2$1_10.D comparator_slice_0.comparator_body_0.m3_m4_diff_0.n1.t89 2.40771
R3263 comparator_slice_0.comparator_body_0.m3_m4_diff_0.m3_m4_array_2/p1_2$1_10.D comparator_slice_0.comparator_body_0.m3_m4_diff_0.n1.t77 2.40771
R3264 comparator_slice_0.comparator_body_0.m3_m4_diff_0.m3_m4_array_1/p1_2$1_1.D comparator_slice_0.comparator_body_0.m3_m4_diff_0.n1.t67 2.40771
R3265 comparator_slice_0.comparator_body_0.m3_m4_diff_0.m3_m4_array_2/p1_2$1_1.D comparator_slice_0.comparator_body_0.m3_m4_diff_0.n1.t91 2.40771
R3266 comparator_slice_0.comparator_body_0.m3_m4_diff_0.m3_m4_array_0/p1_2$1_1.D comparator_slice_0.comparator_body_0.m3_m4_diff_0.n1.t47 2.40771
R3267 comparator_slice_0.comparator_body_0.m3_m4_diff_0.m3_m4_array_3/p1_2$1_1.D comparator_slice_0.comparator_body_0.m3_m4_diff_0.n1.t53 2.40771
R3268 comparator_slice_0.comparator_body_0.m3_m4_diff_0.m3_m4_array_3/p1_2$1_10.D comparator_slice_0.comparator_body_0.m3_m4_diff_0.n1.t43 2.40771
R3269 comparator_slice_0.comparator_body_0.m3_m4_diff_0.m3_m4_array_0/p1_2$1_9.D comparator_slice_0.comparator_body_0.m3_m4_diff_0.n1.t59 2.40771
R3270 comparator_slice_0.comparator_body_0.m3_m4_diff_0.m3_m4_array_0/p1_2$1_4.D comparator_slice_0.comparator_body_0.m3_m4_diff_0.n1.t79 2.40771
R3271 comparator_slice_0.comparator_body_0.m3_m4_diff_0.m3_m4_array_0/p1_2$1_10.D comparator_slice_0.comparator_body_0.m3_m4_diff_0.n1.t61 2.40771
R3272 comparator_slice_0.comparator_body_0.m3_m4_diff_0.n1.n60 comparator_slice_0.comparator_body_0.m3_m4_diff_0.n1.n59 2.23218
R3273 comparator_slice_0.comparator_body_0.m3_m4_diff_0.n1.n57 comparator_slice_0.comparator_body_0.m1_m2_diff_0.m1_m2_array_0/n1_2_11.D 2.16511
R3274 comparator_slice_0.comparator_body_0.m3_m4_diff_0.m3_m4_array_0/p1_2$1_0.D comparator_slice_0.comparator_body_0.m3_m4_diff_0.m3_m4_array_0/p1_2$1_14.D 2.14418
R3275 comparator_slice_0.comparator_body_0.m3_m4_diff_0.m3_m4_array_1/p1_2$1_14.D comparator_slice_0.comparator_body_0.m3_m4_diff_0.m3_m4_array_1/p1_2$1_0.D 2.14418
R3276 comparator_slice_0.comparator_body_0.m3_m4_diff_0.m3_m4_array_2/p1_2$1_14.D comparator_slice_0.comparator_body_0.m3_m4_diff_0.m3_m4_array_2/p1_2$1_0.D 2.14418
R3277 comparator_slice_0.comparator_body_0.m3_m4_diff_0.m3_m4_array_3/p1_2$1_14.D comparator_slice_0.comparator_body_0.m3_m4_diff_0.m3_m4_array_3/p1_2$1_0.D 2.14418
R3278 comparator_slice_0.comparator_body_0.m3_m4_diff_0.m3_m4_array_0/p1_2$1_7.D comparator_slice_0.comparator_body_0.m3_m4_diff_0.m3_m4_array_0/p1_2$1_9.D 2.1212
R3279 comparator_slice_0.comparator_body_0.m3_m4_diff_0.m3_m4_array_2/p1_2$1_9.D comparator_slice_0.comparator_body_0.m3_m4_diff_0.m3_m4_array_2/p1_2$1_7.D 2.1212
R3280 comparator_slice_0.comparator_body_0.m3_m4_diff_0.m3_m4_array_1/p1_2$1_9.D comparator_slice_0.comparator_body_0.m3_m4_diff_0.m3_m4_array_1/p1_2$1_7.D 2.1212
R3281 comparator_slice_0.comparator_body_0.m3_m4_diff_0.n1.n54 comparator_slice_0.comparator_body_0.m1_m2_diff_0.m1_m2_array_1/n1_2_11.D 2.11935
R3282 comparator_slice_0.comparator_body_0.m3_m4_diff_0.n1.n6 comparator_slice_0.comparator_body_0.m3_m4_diff_0.m3_m4_array_0/p1_2$1_4.D 2.10483
R3283 comparator_slice_0.comparator_body_0.m3_m4_diff_0.n1.n2 comparator_slice_0.comparator_body_0.m3_m4_diff_0.m3_m4_array_1/p1_2$1_4.D 2.10483
R3284 comparator_slice_0.comparator_body_0.m3_m4_diff_0.n1.n43 comparator_slice_0.comparator_body_0.m3_m4_diff_0.m3_m4_array_3/p1_2$1_4.D 2.1024
R3285 comparator_slice_0.comparator_body_0.m3_m4_diff_0.n1.n28 comparator_slice_0.comparator_body_0.m3_m4_diff_0.n1.n58 2.0949
R3286 comparator_slice_0.comparator_body_0.m1_m2_diff_0.n1 comparator_slice_0.comparator_body_0.m3_m4_diff_0.n1.n50 2.0465
R3287 comparator_slice_0.comparator_body_0.m3_m4_diff_0.n1.n32 comparator_slice_0.comparator_body_0.m3_m4_diff_0.n1.n27 2.04298
R3288 comparator_slice_0.comparator_body_0.m3_m4_diff_0.n1.n38 comparator_slice_0.comparator_body_0.m3_m4_diff_0.n1.n26 2.04298
R3289 comparator_slice_0.comparator_body_0.m3_m4_diff_0.n1.n37 comparator_slice_0.comparator_body_0.m3_m4_diff_0.n1.n25 2.04298
R3290 comparator_slice_0.comparator_body_0.m3_m4_diff_0.n1.n24 comparator_slice_0.comparator_body_0.m3_m4_diff_0.n1.n36 2.04298
R3291 comparator_slice_0.comparator_body_0.m3_m4_diff_0.n1.n16 comparator_slice_0.comparator_body_0.m3_m4_diff_0.n1.n61 2.0025
R3292 comparator_slice_0.comparator_body_0.m1_m2_diff_0.n1 comparator_slice_0.comparator_body_0.m3_m4_diff_0.n1.n53 1.99898
R3293 comparator_slice_0.comparator_body_0.m1_m2_diff_0.m1_m2_array_3/n1_2_4.D comparator_slice_0.comparator_body_0.m3_m4_diff_0.n1.n24 1.92675
R3294 comparator_slice_0.comparator_body_0.m3_m4_diff_0.n1.n27 comparator_slice_0.comparator_body_0.m1_m2_diff_0.m1_m2_array_1/n1_2_4.D 1.90111
R3295 comparator_slice_0.comparator_body_0.m3_m4_diff_0.n1.n32 comparator_slice_0.comparator_body_0.m1_m2_diff_0.m1_m2_array_1/n1_2_7.D 1.90111
R3296 comparator_slice_0.comparator_body_0.m3_m4_diff_0.n1.n26 comparator_slice_0.comparator_body_0.m1_m2_diff_0.m1_m2_array_0/n1_2_4.D 1.90111
R3297 comparator_slice_0.comparator_body_0.m3_m4_diff_0.n1.n38 comparator_slice_0.comparator_body_0.m1_m2_diff_0.m1_m2_array_0/n1_2_7.D 1.90111
R3298 comparator_slice_0.comparator_body_0.m3_m4_diff_0.n1.n25 comparator_slice_0.comparator_body_0.m1_m2_diff_0.m1_m2_array_2/n1_2_4.D 1.90111
R3299 comparator_slice_0.comparator_body_0.m3_m4_diff_0.n1.n37 comparator_slice_0.comparator_body_0.m1_m2_diff_0.m1_m2_array_2/n1_2_7.D 1.90111
R3300 comparator_slice_0.comparator_body_0.m3_m4_diff_0.n1.n36 comparator_slice_0.comparator_body_0.m1_m2_diff_0.m1_m2_array_3/n1_2_7.D 1.90111
R3301 comparator_slice_0.comparator_body_0.m3_m4_diff_0.n1.n27 comparator_slice_0.comparator_body_0.m1_m2_diff_0.m1_m2_array_1/n1_2_1.D 1.88938
R3302 comparator_slice_0.comparator_body_0.m3_m4_diff_0.n1.n26 comparator_slice_0.comparator_body_0.m1_m2_diff_0.m1_m2_array_0/n1_2_1.D 1.88938
R3303 comparator_slice_0.comparator_body_0.m3_m4_diff_0.n1.n25 comparator_slice_0.comparator_body_0.m1_m2_diff_0.m1_m2_array_2/n1_2_1.D 1.88938
R3304 comparator_slice_0.comparator_body_0.m3_m4_diff_0.n1.n24 comparator_slice_0.comparator_body_0.m1_m2_diff_0.m1_m2_array_3/n1_2_1.D 1.88938
R3305 comparator_slice_0.comparator_body_0.m3_m4_diff_0.n1.n58 comparator_slice_0.comparator_body_0.m1_m2_diff_0.n1 1.87314
R3306 comparator_slice_0.comparator_body_0.m3_m4_diff_0.n1.n53 comparator_slice_0.comparator_body_0.m1_m2_diff_0.n1 1.87314
R3307 comparator_slice_0.comparator_body_0.m3_m4_diff_0.n1.n59 comparator_slice_0.comparator_body_0.m3_m4_diff_0.n1.n28 1.87314
R3308 comparator_slice_0.comparator_body_0.m3_m4_diff_0.n1.n28 comparator_slice_0.comparator_body_0.m3_m4_diff_0.n1.n32 1.81066
R3309 comparator_slice_0.comparator_body_0.m3_m4_diff_0.n1.n19 comparator_slice_0.comparator_body_0.m3_m4_diff_0.m3_m4_array_2/p1_2$1_13.D 0.505116
R3310 comparator_slice_0.comparator_body_0.m3_m4_diff_0.n1.n61 comparator_slice_0.comparator_body_0.m1_m2_diff_0.m1_m2_array_2/n1_2_11.D 1.75415
R3311 comparator_slice_0.comparator_body_0.m3_m4_diff_0.n1.n29 comparator_slice_0.comparator_body_0.m3_m4_diff_0.n1.n23 1.7484
R3312 comparator_slice_0.comparator_body_0.m3_m4_diff_0.n1.n55 comparator_slice_0.comparator_body_0.m3_m4_diff_0.m3_m4_array_2/p1_2$1_4.D 1.67969
R3313 comparator_slice_0.comparator_body_0.m3_m4_diff_0.m3_m4_array_2/p1_2$1_9.D comparator_slice_0.comparator_body_0.m3_m4_diff_0.m3_m4_array_2/p1_2$1_13.D 1.66267
R3314 comparator_slice_0.comparator_body_0.m3_m4_diff_0.n1.n33 comparator_slice_0.comparator_body_0.m1_m2_diff_0.m1_m2_array_1/n1_2_10.D 1.66175
R3315 comparator_slice_0.comparator_body_0.m3_m4_diff_0.n1.n34 comparator_slice_0.comparator_body_0.m1_m2_diff_0.m1_m2_array_0/n1_2_10.D 1.66175
R3316 comparator_slice_0.comparator_body_0.m3_m4_diff_0.n1.n16 comparator_slice_0.comparator_body_0.m1_m2_diff_0.m1_m2_array_2/n1_2_10.D 1.66175
R3317 comparator_slice_0.comparator_body_0.m3_m4_diff_0.n1.n39 comparator_slice_0.comparator_body_0.m1_m2_diff_0.m1_m2_array_3/n1_2_10.D 1.66132
R3318 comparator_slice_0.comparator_body_0.m3_m4_diff_0.n1.n51 comparator_slice_0.comparator_body_0.m3_m4_diff_0.n1.n8 1.65906
R3319 comparator_slice_0.comparator_body_0.m3_m4_diff_0.n1.n47 comparator_slice_0.comparator_body_0.m3_m4_diff_0.n1.n9 0.505995
R3320 comparator_slice_0.comparator_body_0.m3_m4_diff_0.n1.n56 comparator_slice_0.comparator_body_0.m3_m4_diff_0.n1.n10 0.505995
R3321 comparator_slice_0.comparator_body_0.m3_m4_diff_0.n1.n52 comparator_slice_0.comparator_body_0.m3_m4_diff_0.n1.n13 0.505995
R3322 comparator_slice_0.comparator_body_0.m3_m4_diff_0.n1.n48 comparator_slice_0.comparator_body_0.m3_m4_diff_0.n1.n15 0.505995
R3323 comparator_slice_0.comparator_body_0.m3_m4_diff_0.m3_m4_array_1/p1_2$1_13.D comparator_slice_0.comparator_body_0.m3_m4_diff_0.n1.n49 1.65805
R3324 comparator_slice_0.comparator_body_0.m3_m4_diff_0.n1.n59 comparator_slice_0.comparator_body_0.m1_m2_diff_0.m1_m2_array_1/n1_2_2.D 1.65002
R3325 comparator_slice_0.comparator_body_0.m3_m4_diff_0.n1.n28 comparator_slice_0.comparator_body_0.m1_m2_diff_0.m1_m2_array_0/n1_2_13.D 1.65002
R3326 comparator_slice_0.comparator_body_0.m3_m4_diff_0.n1.n58 comparator_slice_0.comparator_body_0.m1_m2_diff_0.m1_m2_array_0/n1_2_2.D 1.65002
R3327 comparator_slice_0.comparator_body_0.m3_m4_diff_0.n1.n53 comparator_slice_0.comparator_body_0.m1_m2_diff_0.m1_m2_array_2/n1_2_2.D 1.65002
R3328 comparator_slice_0.comparator_body_0.m1_m2_diff_0.n1 comparator_slice_0.comparator_body_0.m1_m2_diff_0.m1_m2_array_2/n1_2_13.D 1.65002
R3329 comparator_slice_0.comparator_body_0.m1_m2_diff_0.n1 comparator_slice_0.comparator_body_0.m1_m2_diff_0.m1_m2_array_3/n1_2_13.D 1.65002
R3330 comparator_slice_0.comparator_body_0.m3_m4_diff_0.n1.n50 comparator_slice_0.comparator_body_0.m1_m2_diff_0.m1_m2_array_3/n1_2_2.D 1.65002
R3331 comparator_slice_0.comparator_body_0.m3_m4_diff_0.n1.n54 comparator_slice_0.comparator_body_0.m3_m4_diff_0.n1.n33 1.6373
R3332 comparator_slice_0.comparator_body_0.m3_m4_diff_0.n1.n42 comparator_slice_0.comparator_body_0.m3_m4_diff_0.n1.n41 1.63055
R3333 comparator_slice_0.comparator_body_0.m1_m2_diff_0.n1 comparator_slice_0.comparator_body_0.m3_m4_diff_0.n1.n38 1.63026
R3334 comparator_slice_0.comparator_body_0.m3_m4_diff_0.n1.n21 comparator_slice_0.comparator_body_0.m3_m4_diff_0.n1.n55 1.6205
R3335 comparator_slice_0.comparator_body_0.m3_m4_diff_0.n1.n23 comparator_slice_0.comparator_body_0.m3_m4_diff_0.m3_m4_array_3/p1_2$1_14.D 1.62016
R3336 comparator_slice_0.comparator_body_0.m3_m4_diff_0.n1.n3 comparator_slice_0.comparator_body_0.m3_m4_diff_0.m3_m4_array_1/p1_2$1_13.D 1.60467
R3337 comparator_slice_0.comparator_body_0.m3_m4_diff_0.n1.n38 comparator_slice_0.comparator_body_0.m3_m4_diff_0.n1.n34 1.59946
R3338 comparator_slice_0.comparator_body_0.m3_m4_diff_0.n1.n37 comparator_slice_0.comparator_body_0.m3_m4_diff_0.n1.n16 1.59946
R3339 comparator_slice_0.comparator_body_0.m3_m4_diff_0.n1.n36 comparator_slice_0.comparator_body_0.m3_m4_diff_0.n1.n39 1.59946
R3340 comparator_slice_0.comparator_body_0.m3_m4_diff_0.n1.n34 comparator_slice_0.comparator_body_0.m3_m4_diff_0.n1.n57 1.59154
R3341 comparator_slice_0.comparator_body_0.m1_m2_diff_0.n1 comparator_slice_0.comparator_body_0.m3_m4_diff_0.n1.n37 1.58978
R3342 comparator_slice_0.comparator_body_0.m3_m4_diff_0.n1.n5 comparator_slice_0.comparator_body_0.m3_m4_diff_0.m3_m4_array_2/p1_2$1_13.D 1.5855
R3343 comparator_slice_0.comparator_body_0.m3_m4_diff_0.m3_m4_array_3/p1_2$1_7.D comparator_slice_0.comparator_body_0.m3_m4_diff_0.m3_m4_array_3/p1_2$1_9.D 1.58252
R3344 comparator_slice_0.comparator_body_0.m3_m4_diff_0.n1.n51 comparator_slice_0.comparator_body_0.m3_m4_diff_0.m3_m4_array_3/p1_2$1_14.D 1.52716
R3345 comparator_slice_0.comparator_body_0.m3_m4_diff_0.n1.n52 comparator_slice_0.comparator_body_0.m3_m4_diff_0.m3_m4_array_0/p1_2$1_14.D 1.52716
R3346 comparator_slice_0.comparator_body_0.m3_m4_diff_0.n1.n60 comparator_slice_0.comparator_body_0.m1_m2_diff_0.m1_m2_array_1/n1_2_13.D 1.51274
R3347 comparator_slice_0.comparator_body_0.m3_m4_diff_0.m3_m4_array_0/p1_2$1_13.D comparator_slice_0.comparator_body_0.m3_m4_diff_0.n1.n11 1.50395
R3348 comparator_slice_0.comparator_body_0.m3_m4_diff_0.m3_m4_array_3/p1_2$1_14.D comparator_slice_0.comparator_body_0.m3_m4_diff_0.n1.n35 1.3997
R3349 comparator_slice_0.comparator_body_0.m3_m4_diff_0.m3_m4_array_0/p1_2$1_4.D comparator_slice_0.comparator_body_0.m3_m4_diff_0.n1.n40 1.39958
R3350 comparator_slice_0.comparator_body_0.m3_m4_diff_0.m3_m4_array_1/p1_2$1_4.D comparator_slice_0.comparator_body_0.m3_m4_diff_0.n1.n45 1.39958
R3351 comparator_slice_0.comparator_body_0.m3_m4_diff_0.n1.n12 comparator_slice_0.comparator_body_0.m3_m4_diff_0.m3_m4_array_0/p1_2$1_14.D 1.39924
R3352 comparator_slice_0.comparator_body_0.m3_m4_diff_0.n1.n17 comparator_slice_0.comparator_body_0.m3_m4_diff_0.n1.n19 0.566893
R3353 comparator_slice_0.comparator_body_0.m3_m4_diff_0.n1.n44 comparator_slice_0.comparator_body_0.m3_m4_diff_0.m3_m4_array_2/p1_2$1_14.D 1.3887
R3354 comparator_slice_0.comparator_body_0.m3_m4_diff_0.n1.n46 comparator_slice_0.comparator_body_0.m3_m4_diff_0.n1.n44 0.611957
R3355 comparator_slice_0.comparator_body_0.m3_m4_diff_0.n1.n49 comparator_slice_0.comparator_body_0.m3_m4_diff_0.m3_m4_array_1/p1_2$1_14.D 1.3887
R3356 comparator_slice_0.comparator_body_0.m3_m4_diff_0.n1.n49 comparator_slice_0.comparator_body_0.m3_m4_diff_0.m3_m4_array_0/p1_2$1_1.D 1.3887
R3357 comparator_slice_0.comparator_body_0.m3_m4_diff_0.m3_m4_array_0/p1_2$1_14.D comparator_slice_0.comparator_body_0.m3_m4_diff_0.n1.n42 1.3887
R3358 comparator_slice_0.comparator_body_0.m3_m4_diff_0.n1.n7 comparator_slice_0.comparator_body_0.m3_m4_diff_0.m3_m4_array_3/p1_2$1_1.D 0.448621
R3359 comparator_slice_0.comparator_body_0.m3_m4_diff_0.m3_m4_array_0/p1_2$1_13.D comparator_slice_0.comparator_body_0.m3_m4_diff_0.m3_m4_array_0/p1_2$1_9.D 1.37887
R3360 comparator_slice_0.comparator_body_0.m3_m4_diff_0.m3_m4_array_1/p1_2$1_13.D comparator_slice_0.comparator_body_0.m3_m4_diff_0.m3_m4_array_1/p1_2$1_9.D 1.35137
R3361 comparator_slice_0.comparator_body_0.m3_m4_diff_0.m3_m4_array_3/p1_2$1_7.D comparator_slice_0.comparator_body_0.m3_m4_diff_0.n1.n1 1.33246
R3362 comparator_slice_0.comparator_body_0.m3_m4_diff_0.m3_m4_array_1/p1_2$1_13.D comparator_slice_0.comparator_body_0.m3_m4_diff_0.n1.n15 1.3216
R3363 comparator_slice_0.comparator_body_0.m3_m4_diff_0.n1.n33 comparator_slice_0.comparator_body_0.m3_m4_diff_0.n1.n32 1.31346
R3364 comparator_slice_0.comparator_body_0.m3_m4_diff_0.n1.n18 comparator_slice_0.comparator_body_0.m3_m4_diff_0.n1.n5 1.31021
R3365 comparator_slice_0.comparator_body_0.m3_m4_diff_0.n1.n14 comparator_slice_0.comparator_body_0.m3_m4_diff_0.n1.n3 1.31021
R3366 comparator_slice_0.comparator_body_0.m3_m4_diff_0.n1.n14 comparator_slice_0.comparator_body_0.m3_m4_diff_0.m3_m4_array_1/p1_2$1_14.D 1.30986
R3367 comparator_slice_0.comparator_body_0.m3_m4_diff_0.n1.n18 comparator_slice_0.comparator_body_0.m3_m4_diff_0.m3_m4_array_2/p1_2$1_14.D 1.30986
R3368 comparator_slice_0.comparator_body_0.m3_m4_diff_0.m3_m4_array_0/p1_2$1_9.D comparator_slice_0.comparator_body_0.m3_m4_diff_0.m3_m4_array_0/p1_2$1_4.D 1.3095
R3369 comparator_slice_0.comparator_body_0.m3_m4_diff_0.n1.n47 comparator_slice_0.comparator_body_0.m3_m4_diff_0.m3_m4_array_1/p1_2$1_10.D 1.3095
R3370 comparator_slice_0.comparator_body_0.m3_m4_diff_0.m3_m4_array_0/p1_2$1_10.D comparator_slice_0.comparator_body_0.m3_m4_diff_0.n1.n48 1.3095
R3371 comparator_slice_0.comparator_body_0.m3_m4_diff_0.m3_m4_array_0/p1_2$1_7.D comparator_slice_0.comparator_body_0.m3_m4_diff_0.n1.n6 1.3095
R3372 comparator_slice_0.comparator_body_0.m3_m4_diff_0.n1.n1 comparator_slice_0.comparator_body_0.m3_m4_diff_0.n1.n0 0.443394
R3373 comparator_slice_0.comparator_body_0.m3_m4_diff_0.m3_m4_array_3/p1_2$1_9.D comparator_slice_0.comparator_body_0.m3_m4_diff_0.m3_m4_array_3/p1_2$1_4.D 1.3095
R3374 comparator_slice_0.comparator_body_0.m3_m4_diff_0.m3_m4_array_3/p1_2$1_4.D comparator_slice_0.comparator_body_0.m3_m4_diff_0.m3_m4_array_3/p1_2$1_7.D 1.3095
R3375 comparator_slice_0.comparator_body_0.m3_m4_diff_0.m3_m4_array_3/p1_2$1_10.D comparator_slice_0.comparator_body_0.m3_m4_diff_0.n1.n1 0.425211
R3376 comparator_slice_0.comparator_body_0.m3_m4_diff_0.m3_m4_array_2/p1_2$1_0.D comparator_slice_0.comparator_body_0.m3_m4_diff_0.m3_m4_array_2/p1_2$1_1.D 1.3095
R3377 comparator_slice_0.comparator_body_0.m3_m4_diff_0.m3_m4_array_1/p1_2$1_0.D comparator_slice_0.comparator_body_0.m3_m4_diff_0.m3_m4_array_1/p1_2$1_1.D 1.3095
R3378 comparator_slice_0.comparator_body_0.m3_m4_diff_0.m3_m4_array_0/p1_2$1_1.D comparator_slice_0.comparator_body_0.m3_m4_diff_0.m3_m4_array_0/p1_2$1_0.D 1.3095
R3379 comparator_slice_0.comparator_body_0.m3_m4_diff_0.m3_m4_array_3/p1_2$1_0.D comparator_slice_0.comparator_body_0.m3_m4_diff_0.m3_m4_array_3/p1_2$1_1.D 1.3095
R3380 comparator_slice_0.comparator_body_0.m3_m4_diff_0.m3_m4_array_2/p1_2$1_10.D comparator_slice_0.comparator_body_0.m3_m4_diff_0.n1.n56 1.3095
R3381 comparator_slice_0.comparator_body_0.m3_m4_diff_0.m3_m4_array_2/p1_2$1_7.D comparator_slice_0.comparator_body_0.m3_m4_diff_0.n1.n4 1.3095
R3382 comparator_slice_0.comparator_body_0.m3_m4_diff_0.m3_m4_array_1/p1_2$1_7.D comparator_slice_0.comparator_body_0.m3_m4_diff_0.n1.n2 1.3095
R3383 comparator_slice_0.comparator_body_0.m3_m4_diff_0.m3_m4_array_1/p1_2$1_7.D comparator_slice_0.comparator_body_0.m3_m4_diff_0.m3_m4_array_1/p1_2$1_4.D 1.3095
R3384 comparator_slice_0.comparator_body_0.m3_m4_diff_0.m3_m4_array_1/p1_2$1_9.D comparator_slice_0.comparator_body_0.m3_m4_diff_0.m3_m4_array_1/p1_2$1_4.D 1.3095
R3385 comparator_slice_0.comparator_body_0.m3_m4_diff_0.n1.n55 comparator_slice_0.comparator_body_0.m3_m4_diff_0.m3_m4_array_2/p1_2$1_9.D 1.3095
R3386 comparator_slice_0.comparator_body_0.m3_m4_diff_0.m3_m4_array_2/p1_2$1_7.D comparator_slice_0.comparator_body_0.m3_m4_diff_0.m3_m4_array_2/p1_2$1_4.D 1.3095
R3387 comparator_slice_0.comparator_body_0.m3_m4_diff_0.m3_m4_array_0/p1_2$1_7.D comparator_slice_0.comparator_body_0.m3_m4_diff_0.m3_m4_array_0/p1_2$1_4.D 1.3095
R3388 comparator_slice_0.comparator_body_0.m3_m4_diff_0.m3_m4_array_1/p1_2$1_10.D comparator_slice_0.comparator_body_0.m3_m4_diff_0.m3_m4_array_1/p1_2$1_14.D 1.2941
R3389 comparator_slice_0.comparator_body_0.m3_m4_diff_0.m3_m4_array_0/p1_2$1_14.D comparator_slice_0.comparator_body_0.m3_m4_diff_0.m3_m4_array_0/p1_2$1_10.D 1.2941
R3390 comparator_slice_0.comparator_body_0.m3_m4_diff_0.m3_m4_array_0/p1_2$1_7.D comparator_slice_0.comparator_body_0.m3_m4_diff_0.n1.n52 1.2941
R3391 comparator_slice_0.comparator_body_0.m3_m4_diff_0.n1.n51 comparator_slice_0.comparator_body_0.m3_m4_diff_0.m3_m4_array_3/p1_2$1_7.D 1.2941
R3392 comparator_slice_0.comparator_body_0.m3_m4_diff_0.m3_m4_array_3/p1_2$1_13.D comparator_slice_0.comparator_body_0.m3_m4_diff_0.m3_m4_array_3/p1_2$1_9.D 1.2941
R3393 comparator_slice_0.comparator_body_0.m3_m4_diff_0.m3_m4_array_3/p1_2$1_7.D comparator_slice_0.comparator_body_0.m3_m4_diff_0.n1.n8 1.2941
R3394 comparator_slice_0.comparator_body_0.m3_m4_diff_0.m3_m4_array_3/p1_2$1_10.D comparator_slice_0.comparator_body_0.m3_m4_diff_0.m3_m4_array_3/p1_2$1_14.D 1.2941
R3395 comparator_slice_0.comparator_body_0.m3_m4_diff_0.m3_m4_array_2/p1_2$1_14.D comparator_slice_0.comparator_body_0.m3_m4_diff_0.m3_m4_array_2/p1_2$1_10.D 1.2941
R3396 comparator_slice_0.comparator_body_0.m3_m4_diff_0.m3_m4_array_2/p1_2$1_7.D comparator_slice_0.comparator_body_0.m3_m4_diff_0.n1.n5 1.2941
R3397 comparator_slice_0.comparator_body_0.m3_m4_diff_0.m3_m4_array_1/p1_2$1_7.D comparator_slice_0.comparator_body_0.m3_m4_diff_0.n1.n3 1.2941
R3398 comparator_slice_0.comparator_body_0.m3_m4_diff_0.m3_m4_array_1/p1_2$1_7.D comparator_slice_0.comparator_body_0.m3_m4_diff_0.m3_m4_array_1/p1_2$1_13.D 1.2941
R3399 comparator_slice_0.comparator_body_0.m3_m4_diff_0.m3_m4_array_2/p1_2$1_7.D comparator_slice_0.comparator_body_0.m3_m4_diff_0.m3_m4_array_2/p1_2$1_13.D 1.2941
R3400 comparator_slice_0.comparator_body_0.m3_m4_diff_0.n1.n11 comparator_slice_0.comparator_body_0.m3_m4_diff_0.m3_m4_array_0/p1_2$1_7.D 1.2941
R3401 comparator_slice_0.comparator_body_0.m3_m4_diff_0.m3_m4_array_0/p1_2$1_4.D comparator_slice_0.comparator_body_0.m3_m4_diff_0.m3_m4_array_1/p1_2$1_13.D 1.2919
R3402 comparator_slice_0.comparator_body_0.m3_m4_diff_0.n1.n44 comparator_slice_0.comparator_body_0.m3_m4_diff_0.n1.n9 0.394203
R3403 comparator_slice_0.comparator_body_0.m3_m4_diff_0.n1.n42 comparator_slice_0.comparator_body_0.m3_m4_diff_0.n1.n12 0.574461
R3404 comparator_slice_0.comparator_body_0.m3_m4_diff_0.n1.n15 comparator_slice_0.comparator_body_0.m3_m4_diff_0.n1.n6 0.505995
R3405 comparator_slice_0.comparator_body_0.m3_m4_diff_0.n1.n13 comparator_slice_0.comparator_body_0.m3_m4_diff_0.n1.n42 0.394203
R3406 comparator_slice_0.comparator_body_0.m3_m4_diff_0.n1.n42 comparator_slice_0.comparator_body_0.m3_m4_diff_0.n1.n43 0.435595
R3407 comparator_slice_0.comparator_body_0.m3_m4_diff_0.n1.n23 comparator_slice_0.comparator_body_0.m3_m4_diff_0.n1.n51 1.2919
R3408 comparator_slice_0.comparator_body_0.m3_m4_diff_0.m3_m4_array_3/p1_2$1_4.D comparator_slice_0.comparator_body_0.m3_m4_diff_0.n1.n42 1.2919
R3409 comparator_slice_0.comparator_body_0.m3_m4_diff_0.n1.n8 comparator_slice_0.comparator_body_0.m3_m4_diff_0.n1.n29 1.2919
R3410 comparator_slice_0.comparator_body_0.m3_m4_diff_0.n1.n42 comparator_slice_0.comparator_body_0.m3_m4_diff_0.n1.n7 0.4543
R3411 comparator_slice_0.comparator_body_0.m3_m4_diff_0.n1.n10 comparator_slice_0.comparator_body_0.m3_m4_diff_0.n1.n22 0.394203
R3412 comparator_slice_0.comparator_body_0.m3_m4_diff_0.n1.n10 comparator_slice_0.comparator_body_0.m3_m4_diff_0.n1.n4 0.505995
R3413 comparator_slice_0.comparator_body_0.m3_m4_diff_0.n1.n44 comparator_slice_0.comparator_body_0.m3_m4_diff_0.n1.n18 0.406823
R3414 comparator_slice_0.comparator_body_0.m3_m4_diff_0.n1.n9 comparator_slice_0.comparator_body_0.m3_m4_diff_0.n1.n2 0.505995
R3415 comparator_slice_0.comparator_body_0.m3_m4_diff_0.m3_m4_array_1/p1_2$1_13.D comparator_slice_0.comparator_body_0.m3_m4_diff_0.n1.n14 0.406823
R3416 comparator_slice_0.comparator_body_0.m3_m4_diff_0.n1.n17 comparator_slice_0.comparator_body_0.m3_m4_diff_0.m3_m4_array_1/p1_2$1_4.D 1.2919
R3417 comparator_slice_0.comparator_body_0.m3_m4_diff_0.n1.n21 comparator_slice_0.comparator_body_0.m3_m4_diff_0.m3_m4_array_2/p1_2$1_4.D 1.2919
R3418 comparator_slice_0.comparator_body_0.m3_m4_diff_0.n1.n44 comparator_slice_0.comparator_body_0.m3_m4_diff_0.n1.n19 0.417369
R3419 comparator_slice_0.comparator_body_0.m3_m4_diff_0.m3_m4_array_1/p1_2$1_13.D comparator_slice_0.comparator_body_0.m3_m4_diff_0.n1.n40 0.574581
R3420 comparator_slice_0.comparator_body_0.m3_m4_diff_0.n1.n13 comparator_slice_0.comparator_body_0.m3_m4_diff_0.n1.n11 0.505995
R3421 comparator_slice_0.comparator_body_0.m3_m4_diff_0.n1.n22 comparator_slice_0.comparator_body_0.m3_m4_diff_0.n1.n21 1.28781
R3422 comparator_slice_0.comparator_body_0.m3_m4_diff_0.m3_m4_array_0/p1_2$1_1.D comparator_slice_0.comparator_body_0.m3_m4_diff_0.n1.n48 1.27572
R3423 comparator_slice_0.comparator_body_0.m3_m4_diff_0.m3_m4_array_1/p1_2$1_1.D comparator_slice_0.comparator_body_0.m3_m4_diff_0.n1.n47 1.27572
R3424 comparator_slice_0.comparator_body_0.m3_m4_diff_0.n1.n56 comparator_slice_0.comparator_body_0.m3_m4_diff_0.m3_m4_array_2/p1_2$1_1.D 1.27572
R3425 comparator_slice_0.comparator_body_0.m3_m4_diff_0.m3_m4_array_0/p1_2$1_10.D comparator_slice_0.comparator_body_0.m3_m4_diff_0.m3_m4_array_0/p1_2$1_7.D 1.2557
R3426 comparator_slice_0.comparator_body_0.m3_m4_diff_0.m3_m4_array_2/p1_2$1_7.D comparator_slice_0.comparator_body_0.m3_m4_diff_0.m3_m4_array_2/p1_2$1_10.D 1.2557
R3427 comparator_slice_0.comparator_body_0.m3_m4_diff_0.m3_m4_array_1/p1_2$1_10.D comparator_slice_0.comparator_body_0.m3_m4_diff_0.m3_m4_array_1/p1_2$1_7.D 1.2557
R3428 comparator_slice_0.comparator_body_0.m3_m4_diff_0.m3_m4_array_2/p1_2$1_4.D comparator_slice_0.comparator_body_0.m3_m4_diff_0.n1.n4 1.25509
R3429 comparator_slice_0.comparator_body_0.m3_m4_diff_0.n1.n43 comparator_slice_0.comparator_body_0.m3_m4_diff_0.n1.n0 1.25232
R3430 comparator_slice_0.comparator_body_0.m3_m4_diff_0.n1.n0 comparator_slice_0.comparator_body_0.m3_m4_diff_0.n1.n7 1.24686
R3431 comparator_slice_0.comparator_body_0.m3_m4_diff_0.m3_m4_array_3/p1_2$1_10.D comparator_slice_0.comparator_body_0.m3_m4_diff_0.m3_m4_array_3/p1_2$1_0.D 1.23457
R3432 comparator_slice_0.comparator_body_0.m3_m4_diff_0.m3_m4_array_0/p1_2$1_10.D comparator_slice_0.comparator_body_0.m3_m4_diff_0.m3_m4_array_0/p1_2$1_0.D 1.23457
R3433 comparator_slice_0.comparator_body_0.m3_m4_diff_0.m3_m4_array_1/p1_2$1_10.D comparator_slice_0.comparator_body_0.m3_m4_diff_0.m3_m4_array_1/p1_2$1_0.D 1.23457
R3434 comparator_slice_0.comparator_body_0.m3_m4_diff_0.m3_m4_array_2/p1_2$1_10.D comparator_slice_0.comparator_body_0.m3_m4_diff_0.m3_m4_array_2/p1_2$1_0.D 1.23457
R3435 comparator_slice_0.comparator_body_0.m3_m4_diff_0.n1.n8 comparator_slice_0.comparator_body_0.m3_m4_diff_0.m3_m4_array_3/p1_2$1_13.D 1.22015
R3436 comparator_slice_0.comparator_body_0.m3_m4_diff_0.n1.n35 comparator_slice_0.comparator_body_0.m3_m4_diff_0.n1.n23 1.21753
R3437 comparator_slice_0.comparator_body_0.m3_m4_diff_0.n1.n31 comparator_slice_0.comparator_body_0.m3_m4_diff_0.n1.n20 0.526573
R3438 comparator_slice_0.comparator_body_0.m3_m4_diff_0.n1.n29 comparator_slice_0.comparator_body_0.m3_m4_diff_0.n1.n30 0.521229
R3439 comparator_slice_0.comparator_body_0.m3_m4_diff_0.n1.n41 comparator_slice_0.comparator_body_0.m3_m4_diff_0.m3_m4_array_0/p1_2$1_13.D 1.1115
R3440 comparator_slice_0.comparator_body_0.m3_m4_diff_0.n1.n22 comparator_slice_0.comparator_body_0.m3_m4_diff_0.n1.n20 1.09121
R3441 comparator_slice_1.comparator_body_0.m1_m2_diff_0.m1_m2_array_1/n1_2_13.S comparator_slice_1.comparator_body_0.mref_m5_diff_0.tail.t0 5.77518
R3442 comparator_slice_1.comparator_body_0.m1_m2_diff_0.m1_m2_array_1/n1_2_13.S comparator_slice_1.comparator_body_0.mref_m5_diff_0.tail.t0 4.33628
R3443 comparator_slice_1.comparator_body_0.mref_m5_diff_0.tail.n93 comparator_slice_1.comparator_body_0.mref_m5_diff_0.tail.n21 3.7177
R3444 comparator_slice_1.comparator_body_0.mref_m5_diff_0.tail.n18 comparator_slice_1.comparator_body_0.mref_m5_diff_0.tail.n39 3.7177
R3445 comparator_slice_1.comparator_body_0.mref_m5_diff_0.tail.n22 comparator_slice_1.comparator_body_0.mref_m5_diff_0.tail.n38 3.7177
R3446 comparator_slice_1.comparator_body_0.mref_m5_diff_0.tail.n13 comparator_slice_1.comparator_body_0.mref_m5_diff_0.tail.n92 3.7177
R3447 comparator_slice_1.comparator_body_0.mref_m5_diff_0.tail.n1 comparator_slice_1.comparator_body_0.mref_m5_diff_0.tail.n99 3.7177
R3448 comparator_slice_1.comparator_body_0.mref_m5_diff_0.tail.n101 comparator_slice_1.comparator_body_0.mref_m5_diff_0.tail.n100 3.7177
R3449 comparator_slice_1.comparator_body_0.mref_m5_diff_0.tail.n37 comparator_slice_1.comparator_body_0.mref_m5_diff_0.tail.n114 3.7177
R3450 comparator_slice_1.comparator_body_0.mref_m5_diff_0.tail.n3 comparator_slice_1.comparator_body_0.mref_m5_diff_0.tail.n51 3.7177
R3451 comparator_slice_1.comparator_body_0.mref_m5_diff_0.tail.n40 comparator_slice_1.comparator_body_0.m1_m2_diff_0.m1_m2_array_1/n1_2_10.S 3.01738
R3452 comparator_slice_1.comparator_body_0.mref_m5_diff_0.tail.n42 comparator_slice_1.comparator_body_0.m1_m2_diff_0.m1_m2_array_1/n1_2_0.S 3.01738
R3453 comparator_slice_1.comparator_body_0.mref_m5_diff_0.tail.n44 comparator_slice_1.comparator_body_0.m1_m2_diff_0.m1_m2_array_1/n1_2_11.S 3.01738
R3454 comparator_slice_1.comparator_body_0.mref_m5_diff_0.tail.n16 comparator_slice_1.comparator_body_0.m1_m2_diff_0.m1_m2_array_1/n1_2_12.S 3.01738
R3455 comparator_slice_1.comparator_body_0.mref_m5_diff_0.tail.n46 comparator_slice_1.comparator_body_0.m1_m2_diff_0.m1_m2_array_0/n1_2_10.S 3.01738
R3456 comparator_slice_1.comparator_body_0.mref_m5_diff_0.tail.n1 comparator_slice_1.comparator_body_0.m1_m2_diff_0.m1_m2_array_2/n1_2_12.S 3.01738
R3457 comparator_slice_1.comparator_body_0.mref_m5_diff_0.tail.n1 comparator_slice_1.comparator_body_0.m1_m2_diff_0.m1_m2_array_3/n1_2_12.S 3.01738
R3458 comparator_slice_1.comparator_body_0.mref_m5_diff_0.tail.n1 comparator_slice_1.comparator_body_0.m1_m2_diff_0.m1_m2_array_0/n1_2_12.S 3.47694
R3459 comparator_slice_1.comparator_body_0.mref_m5_diff_0.tail.n49 comparator_slice_1.comparator_body_0.m1_m2_diff_0.m1_m2_array_2/n1_2_10.S 3.01738
R3460 comparator_slice_1.comparator_body_0.mref_m5_diff_0.tail.n47 comparator_slice_1.comparator_body_0.m1_m2_diff_0.m1_m2_array_2/n1_2_0.S 3.01738
R3461 comparator_slice_1.comparator_body_0.mref_m5_diff_0.tail.n50 comparator_slice_1.comparator_body_0.m1_m2_diff_0.m1_m2_array_3/n1_2_0.S 3.01738
R3462 comparator_slice_1.comparator_body_0.mref_m5_diff_0.tail.n15 comparator_slice_1.comparator_body_0.m1_m2_diff_0.m1_m2_array_1/n1_2_15.S 3.01696
R3463 comparator_slice_1.comparator_body_0.m1_m2_diff_0.m1_m2_array_1/n1_2_13.S comparator_slice_1.comparator_body_0.mref_m5_diff_0.tail.n117 3.0027
R3464 comparator_slice_1.comparator_body_0.mref_m5_diff_0.tail.n1 comparator_slice_1.comparator_body_0.m1_m2_diff_0.m1_m2_array_1/n1_2_6.S 3.00226
R3465 comparator_slice_1.comparator_body_0.mref_m5_diff_0.tail.n1 comparator_slice_1.comparator_body_0.m1_m2_diff_0.m1_m2_array_1/n1_2_1.S 3.00226
R3466 comparator_slice_1.comparator_body_0.mref_m5_diff_0.tail.n8 comparator_slice_1.comparator_body_0.m1_m2_diff_0.m1_m2_array_1/n1_2_9.S 3.00226
R3467 comparator_slice_1.comparator_body_0.mref_m5_diff_0.tail.n1 comparator_slice_1.comparator_body_0.m1_m2_diff_0.m1_m2_array_0/n1_2_6.S 3.00226
R3468 comparator_slice_1.comparator_body_0.mref_m5_diff_0.tail.n1 comparator_slice_1.comparator_body_0.m1_m2_diff_0.m1_m2_array_0/n1_2_1.S 3.00226
R3469 comparator_slice_1.comparator_body_0.mref_m5_diff_0.tail.n0 comparator_slice_1.comparator_body_0.m1_m2_diff_0.m1_m2_array_0/n1_2_9.S 3.00226
R3470 comparator_slice_1.comparator_body_0.mref_m5_diff_0.tail.n1 comparator_slice_1.comparator_body_0.m1_m2_diff_0.m1_m2_array_0/n1_2_14.S 3.00226
R3471 comparator_slice_1.comparator_body_0.mref_m5_diff_0.tail.n1 comparator_slice_1.comparator_body_0.m1_m2_diff_0.m1_m2_array_3/n1_2_2.S 3.13083
R3472 comparator_slice_1.comparator_body_0.mref_m5_diff_0.tail.n3 comparator_slice_1.comparator_body_0.m1_m2_diff_0.m1_m2_array_3/n1_2_5.S 3.00226
R3473 comparator_slice_1.comparator_body_0.mref_m5_diff_0.tail.n37 comparator_slice_1.comparator_body_0.m1_m2_diff_0.m1_m2_array_3/n1_2_13.S 3.00226
R3474 comparator_slice_1.comparator_body_0.mref_m5_diff_0.tail.n20 comparator_slice_1.comparator_body_0.m1_m2_diff_0.m1_m2_array_2/n1_2_2.S 3.00226
R3475 comparator_slice_1.comparator_body_0.mref_m5_diff_0.tail.n1 comparator_slice_1.comparator_body_0.m1_m2_diff_0.m1_m2_array_2/n1_2_5.S 3.00226
R3476 comparator_slice_1.comparator_body_0.mref_m5_diff_0.tail.n21 comparator_slice_1.comparator_body_0.m1_m2_diff_0.m1_m2_array_0/n1_2_2.S 3.00226
R3477 comparator_slice_1.comparator_body_0.mref_m5_diff_0.tail.n13 comparator_slice_1.comparator_body_0.m1_m2_diff_0.m1_m2_array_0/n1_2_5.S 3.00226
R3478 comparator_slice_1.comparator_body_0.mref_m5_diff_0.tail.n1 comparator_slice_1.comparator_body_0.m1_m2_diff_0.m1_m2_array_2/n1_2_6.S 3.00226
R3479 comparator_slice_1.comparator_body_0.mref_m5_diff_0.tail.n1 comparator_slice_1.comparator_body_0.m1_m2_diff_0.m1_m2_array_2/n1_2_1.S 3.00226
R3480 comparator_slice_1.comparator_body_0.mref_m5_diff_0.tail.n7 comparator_slice_1.comparator_body_0.m1_m2_diff_0.m1_m2_array_2/n1_2_9.S 3.00226
R3481 comparator_slice_1.comparator_body_0.mref_m5_diff_0.tail.n1 comparator_slice_1.comparator_body_0.m1_m2_diff_0.m1_m2_array_2/n1_2_14.S 3.00226
R3482 comparator_slice_1.comparator_body_0.mref_m5_diff_0.tail.n1 comparator_slice_1.comparator_body_0.m1_m2_diff_0.m1_m2_array_3/n1_2_6.S 3.00226
R3483 comparator_slice_1.comparator_body_0.mref_m5_diff_0.tail.n1 comparator_slice_1.comparator_body_0.m1_m2_diff_0.m1_m2_array_3/n1_2_1.S 3.00226
R3484 comparator_slice_1.comparator_body_0.mref_m5_diff_0.tail.n1 comparator_slice_1.comparator_body_0.m1_m2_diff_0.m1_m2_array_3/n1_2_9.S 3.00226
R3485 comparator_slice_1.comparator_body_0.mref_m5_diff_0.tail.n1 comparator_slice_1.comparator_body_0.m1_m2_diff_0.m1_m2_array_3/n1_2_14.S 3.00226
R3486 comparator_slice_1.comparator_body_0.mref_m5_diff_0.tail.n115 comparator_slice_1.comparator_body_0.m1_m2_diff_0.m1_m2_array_1/n1_2_8.S 3.00226
R3487 comparator_slice_1.comparator_body_0.mref_m5_diff_0.tail.n19 comparator_slice_1.comparator_body_0.m1_m2_diff_0.m1_m2_array_1/n1_2_2.S 3.00226
R3488 comparator_slice_1.comparator_body_0.mref_m5_diff_0.tail.n22 comparator_slice_1.comparator_body_0.m1_m2_diff_0.m1_m2_array_1/n1_2_5.S 3.00226
R3489 comparator_slice_1.comparator_body_0.m1_m2_diff_0.m1_m2_array_1/n1_2_5.S comparator_slice_1.comparator_body_0.mref_m5_diff_0.tail.t55 2.47757
R3490 comparator_slice_1.comparator_body_0.m1_m2_diff_0.m1_m2_array_1/n1_2_2.S comparator_slice_1.comparator_body_0.mref_m5_diff_0.tail.t21 2.47757
R3491 comparator_slice_1.comparator_body_0.m1_m2_diff_0.m1_m2_array_1/n1_2_8.S comparator_slice_1.comparator_body_0.mref_m5_diff_0.tail.t50 2.47757
R3492 comparator_slice_1.comparator_body_0.m1_m2_diff_0.m1_m2_array_3/n1_2_14.S comparator_slice_1.comparator_body_0.mref_m5_diff_0.tail.t19 2.47757
R3493 comparator_slice_1.comparator_body_0.m1_m2_diff_0.m1_m2_array_3/n1_2_9.S comparator_slice_1.comparator_body_0.mref_m5_diff_0.tail.t39 2.47757
R3494 comparator_slice_1.comparator_body_0.m1_m2_diff_0.m1_m2_array_3/n1_2_1.S comparator_slice_1.comparator_body_0.mref_m5_diff_0.tail.t12 2.47757
R3495 comparator_slice_1.comparator_body_0.m1_m2_diff_0.m1_m2_array_3/n1_2_6.S comparator_slice_1.comparator_body_0.mref_m5_diff_0.tail.t54 2.47757
R3496 comparator_slice_1.comparator_body_0.m1_m2_diff_0.m1_m2_array_2/n1_2_14.S comparator_slice_1.comparator_body_0.mref_m5_diff_0.tail.t1 2.47757
R3497 comparator_slice_1.comparator_body_0.m1_m2_diff_0.m1_m2_array_2/n1_2_9.S comparator_slice_1.comparator_body_0.mref_m5_diff_0.tail.t51 2.47757
R3498 comparator_slice_1.comparator_body_0.m1_m2_diff_0.m1_m2_array_2/n1_2_1.S comparator_slice_1.comparator_body_0.mref_m5_diff_0.tail.t9 2.47757
R3499 comparator_slice_1.comparator_body_0.m1_m2_diff_0.m1_m2_array_2/n1_2_6.S comparator_slice_1.comparator_body_0.mref_m5_diff_0.tail.t41 2.47757
R3500 comparator_slice_1.comparator_body_0.m1_m2_diff_0.m1_m2_array_0/n1_2_13.S comparator_slice_1.comparator_body_0.mref_m5_diff_0.tail.t28 2.47757
R3501 comparator_slice_1.comparator_body_0.m1_m2_diff_0.m1_m2_array_0/n1_2_5.S comparator_slice_1.comparator_body_0.mref_m5_diff_0.tail.t46 2.47757
R3502 comparator_slice_1.comparator_body_0.m1_m2_diff_0.m1_m2_array_0/n1_2_2.S comparator_slice_1.comparator_body_0.mref_m5_diff_0.tail.t16 2.47757
R3503 comparator_slice_1.comparator_body_0.m1_m2_diff_0.m1_m2_array_0/n1_2_8.S comparator_slice_1.comparator_body_0.mref_m5_diff_0.tail.t48 2.47757
R3504 comparator_slice_1.comparator_body_0.m1_m2_diff_0.m1_m2_array_2/n1_2_13.S comparator_slice_1.comparator_body_0.mref_m5_diff_0.tail.t10 2.47757
R3505 comparator_slice_1.comparator_body_0.m1_m2_diff_0.m1_m2_array_2/n1_2_5.S comparator_slice_1.comparator_body_0.mref_m5_diff_0.tail.t60 2.47757
R3506 comparator_slice_1.comparator_body_0.m1_m2_diff_0.m1_m2_array_2/n1_2_2.S comparator_slice_1.comparator_body_0.mref_m5_diff_0.tail.t30 2.47757
R3507 comparator_slice_1.comparator_body_0.m1_m2_diff_0.m1_m2_array_2/n1_2_8.S comparator_slice_1.comparator_body_0.mref_m5_diff_0.tail.t32 2.47757
R3508 comparator_slice_1.comparator_body_0.m1_m2_diff_0.m1_m2_array_3/n1_2_13.S comparator_slice_1.comparator_body_0.mref_m5_diff_0.tail.t5 2.47757
R3509 comparator_slice_1.comparator_body_0.m1_m2_diff_0.m1_m2_array_3/n1_2_5.S comparator_slice_1.comparator_body_0.mref_m5_diff_0.tail.t52 2.47757
R3510 comparator_slice_1.comparator_body_0.m1_m2_diff_0.m1_m2_array_3/n1_2_2.S comparator_slice_1.comparator_body_0.mref_m5_diff_0.tail.t11 2.47757
R3511 comparator_slice_1.comparator_body_0.m1_m2_diff_0.m1_m2_array_3/n1_2_8.S comparator_slice_1.comparator_body_0.mref_m5_diff_0.tail.t45 2.47757
R3512 comparator_slice_1.comparator_body_0.m1_m2_diff_0.m1_m2_array_0/n1_2_14.S comparator_slice_1.comparator_body_0.mref_m5_diff_0.tail.t18 2.47757
R3513 comparator_slice_1.comparator_body_0.m1_m2_diff_0.m1_m2_array_0/n1_2_9.S comparator_slice_1.comparator_body_0.mref_m5_diff_0.tail.t35 2.47757
R3514 comparator_slice_1.comparator_body_0.m1_m2_diff_0.m1_m2_array_0/n1_2_1.S comparator_slice_1.comparator_body_0.mref_m5_diff_0.tail.t24 2.47757
R3515 comparator_slice_1.comparator_body_0.m1_m2_diff_0.m1_m2_array_0/n1_2_6.S comparator_slice_1.comparator_body_0.mref_m5_diff_0.tail.t38 2.47757
R3516 comparator_slice_1.comparator_body_0.m1_m2_diff_0.m1_m2_array_1/n1_2_14.S comparator_slice_1.comparator_body_0.mref_m5_diff_0.tail.t23 2.47757
R3517 comparator_slice_1.comparator_body_0.m1_m2_diff_0.m1_m2_array_1/n1_2_9.S comparator_slice_1.comparator_body_0.mref_m5_diff_0.tail.t36 2.47757
R3518 comparator_slice_1.comparator_body_0.m1_m2_diff_0.m1_m2_array_1/n1_2_1.S comparator_slice_1.comparator_body_0.mref_m5_diff_0.tail.t2 2.47757
R3519 comparator_slice_1.comparator_body_0.m1_m2_diff_0.m1_m2_array_1/n1_2_6.S comparator_slice_1.comparator_body_0.mref_m5_diff_0.tail.t63 2.47757
R3520 comparator_slice_1.comparator_body_0.mref_m5_diff_0.mref_m5_array_1/n1_2$1_15.D comparator_slice_1.comparator_body_0.mref_m5_diff_0.tail.t77 2.46703
R3521 comparator_slice_1.comparator_body_0.mref_m5_diff_0.mref_m5_array_0/n1_2$1_15.D comparator_slice_1.comparator_body_0.mref_m5_diff_0.tail.t91 2.46703
R3522 comparator_slice_1.comparator_body_0.mref_m5_diff_0.mref_m5_array_0/n1_2$1_6.D comparator_slice_1.comparator_body_0.mref_m5_diff_0.tail.t88 2.46703
R3523 comparator_slice_1.comparator_body_0.mref_m5_diff_0.mref_m5_array_0/n1_2$1_12.D comparator_slice_1.comparator_body_0.mref_m5_diff_0.tail.t86 2.46703
R3524 comparator_slice_1.comparator_body_0.mref_m5_diff_0.mref_m5_array_0/n1_2$1_5.D comparator_slice_1.comparator_body_0.mref_m5_diff_0.tail.t81 2.46703
R3525 comparator_slice_1.comparator_body_0.mref_m5_diff_0.mref_m5_array_1/n1_2$1_12.D comparator_slice_1.comparator_body_0.mref_m5_diff_0.tail.t89 2.46703
R3526 comparator_slice_1.comparator_body_0.mref_m5_diff_0.mref_m5_array_1/n1_2$1_6.D comparator_slice_1.comparator_body_0.mref_m5_diff_0.tail.t76 2.46703
R3527 comparator_slice_1.comparator_body_0.mref_m5_diff_0.mref_m5_array_3/n1_2$1_15.D comparator_slice_1.comparator_body_0.mref_m5_diff_0.tail.t95 2.46703
R3528 comparator_slice_1.comparator_body_0.mref_m5_diff_0.mref_m5_array_2/n1_2$1_15.D comparator_slice_1.comparator_body_0.mref_m5_diff_0.tail.t87 2.46703
R3529 comparator_slice_1.comparator_body_0.mref_m5_diff_0.mref_m5_array_2/n1_2$1_5.D comparator_slice_1.comparator_body_0.mref_m5_diff_0.tail.t84 2.46703
R3530 comparator_slice_1.comparator_body_0.mref_m5_diff_0.mref_m5_array_2/n1_2$1_6.D comparator_slice_1.comparator_body_0.mref_m5_diff_0.tail.t73 2.46703
R3531 comparator_slice_1.comparator_body_0.mref_m5_diff_0.mref_m5_array_2/n1_2$1_12.D comparator_slice_1.comparator_body_0.mref_m5_diff_0.tail.t93 2.46703
R3532 comparator_slice_1.comparator_body_0.mref_m5_diff_0.mref_m5_array_3/n1_2$1_5.D comparator_slice_1.comparator_body_0.mref_m5_diff_0.tail.t66 2.46703
R3533 comparator_slice_1.comparator_body_0.mref_m5_diff_0.mref_m5_array_3/n1_2$1_6.D comparator_slice_1.comparator_body_0.mref_m5_diff_0.tail.t79 2.46703
R3534 comparator_slice_1.comparator_body_0.mref_m5_diff_0.mref_m5_array_3/n1_2$1_12.D comparator_slice_1.comparator_body_0.mref_m5_diff_0.tail.t71 2.46703
R3535 comparator_slice_1.comparator_body_0.mref_m5_diff_0.mref_m5_array_1/n1_2$1_5.D comparator_slice_1.comparator_body_0.mref_m5_diff_0.tail.t90 2.46703
R3536 comparator_slice_1.comparator_body_0.m1_m2_diff_0.m1_m2_array_1/n1_2_7.S comparator_slice_1.comparator_body_0.mref_m5_diff_0.tail.t26 2.46281
R3537 comparator_slice_1.comparator_body_0.m1_m2_diff_0.m1_m2_array_3/n1_2_15.S comparator_slice_1.comparator_body_0.mref_m5_diff_0.tail.t49 2.46281
R3538 comparator_slice_1.comparator_body_0.m1_m2_diff_0.m1_m2_array_3/n1_2_11.S comparator_slice_1.comparator_body_0.mref_m5_diff_0.tail.t15 2.46281
R3539 comparator_slice_1.comparator_body_0.m1_m2_diff_0.m1_m2_array_3/n1_2_0.S comparator_slice_1.comparator_body_0.mref_m5_diff_0.tail.t44 2.46281
R3540 comparator_slice_1.comparator_body_0.m1_m2_diff_0.m1_m2_array_3/n1_2_10.S comparator_slice_1.comparator_body_0.mref_m5_diff_0.tail.t27 2.46281
R3541 comparator_slice_1.comparator_body_0.m1_m2_diff_0.m1_m2_array_2/n1_2_15.S comparator_slice_1.comparator_body_0.mref_m5_diff_0.tail.t53 2.46281
R3542 comparator_slice_1.comparator_body_0.m1_m2_diff_0.m1_m2_array_2/n1_2_11.S comparator_slice_1.comparator_body_0.mref_m5_diff_0.tail.t4 2.46281
R3543 comparator_slice_1.comparator_body_0.m1_m2_diff_0.m1_m2_array_2/n1_2_0.S comparator_slice_1.comparator_body_0.mref_m5_diff_0.tail.t40 2.46281
R3544 comparator_slice_1.comparator_body_0.m1_m2_diff_0.m1_m2_array_2/n1_2_10.S comparator_slice_1.comparator_body_0.mref_m5_diff_0.tail.t31 2.46281
R3545 comparator_slice_1.comparator_body_0.m1_m2_diff_0.m1_m2_array_0/n1_2_12.S comparator_slice_1.comparator_body_0.mref_m5_diff_0.tail.t56 2.46281
R3546 comparator_slice_1.comparator_body_0.m1_m2_diff_0.m1_m2_array_3/n1_2_7.S comparator_slice_1.comparator_body_0.mref_m5_diff_0.tail.t13 2.46281
R3547 comparator_slice_1.comparator_body_0.m1_m2_diff_0.m1_m2_array_3/n1_2_3.S comparator_slice_1.comparator_body_0.mref_m5_diff_0.tail.t37 2.46281
R3548 comparator_slice_1.comparator_body_0.m1_m2_diff_0.m1_m2_array_3/n1_2_4.S comparator_slice_1.comparator_body_0.mref_m5_diff_0.tail.t20 2.46281
R3549 comparator_slice_1.comparator_body_0.m1_m2_diff_0.m1_m2_array_3/n1_2_12.S comparator_slice_1.comparator_body_0.mref_m5_diff_0.tail.t58 2.46281
R3550 comparator_slice_1.comparator_body_0.m1_m2_diff_0.m1_m2_array_2/n1_2_7.S comparator_slice_1.comparator_body_0.mref_m5_diff_0.tail.t7 2.46281
R3551 comparator_slice_1.comparator_body_0.m1_m2_diff_0.m1_m2_array_2/n1_2_3.S comparator_slice_1.comparator_body_0.mref_m5_diff_0.tail.t43 2.46281
R3552 comparator_slice_1.comparator_body_0.m1_m2_diff_0.m1_m2_array_2/n1_2_4.S comparator_slice_1.comparator_body_0.mref_m5_diff_0.tail.t17 2.46281
R3553 comparator_slice_1.comparator_body_0.m1_m2_diff_0.m1_m2_array_2/n1_2_12.S comparator_slice_1.comparator_body_0.mref_m5_diff_0.tail.t59 2.46281
R3554 comparator_slice_1.comparator_body_0.m1_m2_diff_0.m1_m2_array_0/n1_2_7.S comparator_slice_1.comparator_body_0.mref_m5_diff_0.tail.t3 2.46281
R3555 comparator_slice_1.comparator_body_0.m1_m2_diff_0.m1_m2_array_0/n1_2_3.S comparator_slice_1.comparator_body_0.mref_m5_diff_0.tail.t42 2.46281
R3556 comparator_slice_1.comparator_body_0.m1_m2_diff_0.m1_m2_array_0/n1_2_4.S comparator_slice_1.comparator_body_0.mref_m5_diff_0.tail.t22 2.46281
R3557 comparator_slice_1.comparator_body_0.m1_m2_diff_0.m1_m2_array_0/n1_2_15.S comparator_slice_1.comparator_body_0.mref_m5_diff_0.tail.t33 2.46281
R3558 comparator_slice_1.comparator_body_0.m1_m2_diff_0.m1_m2_array_0/n1_2_11.S comparator_slice_1.comparator_body_0.mref_m5_diff_0.tail.t8 2.46281
R3559 comparator_slice_1.comparator_body_0.m1_m2_diff_0.m1_m2_array_0/n1_2_0.S comparator_slice_1.comparator_body_0.mref_m5_diff_0.tail.t34 2.46281
R3560 comparator_slice_1.comparator_body_0.m1_m2_diff_0.m1_m2_array_0/n1_2_10.S comparator_slice_1.comparator_body_0.mref_m5_diff_0.tail.t25 2.46281
R3561 comparator_slice_1.comparator_body_0.m1_m2_diff_0.m1_m2_array_1/n1_2_12.S comparator_slice_1.comparator_body_0.mref_m5_diff_0.tail.t47 2.46281
R3562 comparator_slice_1.comparator_body_0.m1_m2_diff_0.m1_m2_array_1/n1_2_4.S comparator_slice_1.comparator_body_0.mref_m5_diff_0.tail.t29 2.46281
R3563 comparator_slice_1.comparator_body_0.m1_m2_diff_0.m1_m2_array_1/n1_2_3.S comparator_slice_1.comparator_body_0.mref_m5_diff_0.tail.t61 2.46281
R3564 comparator_slice_1.comparator_body_0.m1_m2_diff_0.m1_m2_array_1/n1_2_11.S comparator_slice_1.comparator_body_0.mref_m5_diff_0.tail.t14 2.46281
R3565 comparator_slice_1.comparator_body_0.m1_m2_diff_0.m1_m2_array_1/n1_2_0.S comparator_slice_1.comparator_body_0.mref_m5_diff_0.tail.t62 2.46281
R3566 comparator_slice_1.comparator_body_0.m1_m2_diff_0.m1_m2_array_1/n1_2_10.S comparator_slice_1.comparator_body_0.mref_m5_diff_0.tail.t6 2.46281
R3567 comparator_slice_1.comparator_body_0.m1_m2_diff_0.m1_m2_array_1/n1_2_15.S comparator_slice_1.comparator_body_0.mref_m5_diff_0.tail.t57 2.46277
R3568 comparator_slice_1.comparator_body_0.mref_m5_diff_0.mref_m5_array_0/n1_2$1_3.D comparator_slice_1.comparator_body_0.mref_m5_diff_0.tail.t65 2.45485
R3569 comparator_slice_1.comparator_body_0.mref_m5_diff_0.mref_m5_array_0/n1_2$1_11.D comparator_slice_1.comparator_body_0.mref_m5_diff_0.tail.t74 2.45485
R3570 comparator_slice_1.comparator_body_0.mref_m5_diff_0.mref_m5_array_0/n1_2$1_2.D comparator_slice_1.comparator_body_0.mref_m5_diff_0.tail.t80 2.45485
R3571 comparator_slice_1.comparator_body_0.mref_m5_diff_0.mref_m5_array_0/n1_2$1_8.D comparator_slice_1.comparator_body_0.mref_m5_diff_0.tail.t82 2.45485
R3572 comparator_slice_1.comparator_body_0.mref_m5_diff_0.mref_m5_array_1/n1_2$1_11.D comparator_slice_1.comparator_body_0.mref_m5_diff_0.tail.t68 2.45485
R3573 comparator_slice_1.comparator_body_0.mref_m5_diff_0.mref_m5_array_1/n1_2$1_2.D comparator_slice_1.comparator_body_0.mref_m5_diff_0.tail.t64 2.45485
R3574 comparator_slice_1.comparator_body_0.mref_m5_diff_0.mref_m5_array_3/n1_2$1_11.D comparator_slice_1.comparator_body_0.mref_m5_diff_0.tail.t67 2.45485
R3575 comparator_slice_1.comparator_body_0.mref_m5_diff_0.mref_m5_array_3/n1_2$1_2.D comparator_slice_1.comparator_body_0.mref_m5_diff_0.tail.t69 2.45485
R3576 comparator_slice_1.comparator_body_0.mref_m5_diff_0.mref_m5_array_2/n1_2$1_11.D comparator_slice_1.comparator_body_0.mref_m5_diff_0.tail.t78 2.45485
R3577 comparator_slice_1.comparator_body_0.mref_m5_diff_0.mref_m5_array_2/n1_2$1_2.D comparator_slice_1.comparator_body_0.mref_m5_diff_0.tail.t72 2.45485
R3578 comparator_slice_1.comparator_body_0.mref_m5_diff_0.mref_m5_array_2/n1_2$1_8.D comparator_slice_1.comparator_body_0.mref_m5_diff_0.tail.t85 2.45485
R3579 comparator_slice_1.comparator_body_0.mref_m5_diff_0.mref_m5_array_2/n1_2$1_3.D comparator_slice_1.comparator_body_0.mref_m5_diff_0.tail.t94 2.45485
R3580 comparator_slice_1.comparator_body_0.mref_m5_diff_0.mref_m5_array_3/n1_2$1_8.D comparator_slice_1.comparator_body_0.mref_m5_diff_0.tail.t75 2.45485
R3581 comparator_slice_1.comparator_body_0.mref_m5_diff_0.mref_m5_array_3/n1_2$1_3.D comparator_slice_1.comparator_body_0.mref_m5_diff_0.tail.t92 2.45485
R3582 comparator_slice_1.comparator_body_0.mref_m5_diff_0.mref_m5_array_1/n1_2$1_8.D comparator_slice_1.comparator_body_0.mref_m5_diff_0.tail.t83 2.45485
R3583 comparator_slice_1.comparator_body_0.mref_m5_diff_0.mref_m5_array_1/n1_2$1_3.D comparator_slice_1.comparator_body_0.mref_m5_diff_0.tail.t70 2.45485
R3584 comparator_slice_1.comparator_body_0.mref_m5_diff_0.tail.n59 comparator_slice_1.comparator_body_0.mref_m5_diff_0.mref_m5_array_2/n1_2$1_11.D 2.04455
R3585 comparator_slice_1.comparator_body_0.mref_m5_diff_0.tail.n106 comparator_slice_1.comparator_body_0.mref_m5_diff_0.mref_m5_array_3/n1_2$1_11.D 2.04455
R3586 comparator_slice_1.comparator_body_0.mref_m5_diff_0.tail.n80 comparator_slice_1.comparator_body_0.mref_m5_diff_0.mref_m5_array_1/n1_2$1_11.D 2.04455
R3587 comparator_slice_1.comparator_body_0.mref_m5_diff_0.tail.n78 comparator_slice_1.comparator_body_0.mref_m5_diff_0.mref_m5_array_0/n1_2$1_11.D 2.04455
R3588 comparator_slice_1.comparator_body_0.mref_m5_diff_0.tail.n62 comparator_slice_1.comparator_body_0.mref_m5_diff_0.mref_m5_array_2/n1_2$1_15.D 2.03194
R3589 comparator_slice_1.comparator_body_0.mref_m5_diff_0.tail.n64 comparator_slice_1.comparator_body_0.mref_m5_diff_0.mref_m5_array_3/n1_2$1_15.D 2.03194
R3590 comparator_slice_1.comparator_body_0.mref_m5_diff_0.tail.n70 comparator_slice_1.comparator_body_0.mref_m5_diff_0.mref_m5_array_0/n1_2$1_15.D 2.03194
R3591 comparator_slice_1.comparator_body_0.mref_m5_diff_0.tail.n86 comparator_slice_1.comparator_body_0.mref_m5_diff_0.mref_m5_array_1/n1_2$1_15.D 2.03194
R3592 comparator_slice_1.comparator_body_0.mref_m5_diff_0.tail.n93 comparator_slice_1.comparator_body_0.mref_m5_diff_0.mref_m5_array_1/n1_2$1_3.D 1.52623
R3593 comparator_slice_1.comparator_body_0.mref_m5_diff_0.tail.n101 comparator_slice_1.comparator_body_0.mref_m5_diff_0.mref_m5_array_3/n1_2$1_3.D 1.52623
R3594 comparator_slice_1.comparator_body_0.mref_m5_diff_0.tail.n51 comparator_slice_1.comparator_body_0.mref_m5_diff_0.mref_m5_array_2/n1_2$1_3.D 1.52623
R3595 comparator_slice_1.comparator_body_0.mref_m5_diff_0.tail.n39 comparator_slice_1.comparator_body_0.mref_m5_diff_0.mref_m5_array_0/n1_2$1_3.D 1.52623
R3596 comparator_slice_1.comparator_body_0.mref_m5_diff_0.tail.n25 comparator_slice_1.comparator_body_0.mref_m5_diff_0.mref_m5_array_1/n1_2$1_8.D 1.52535
R3597 comparator_slice_1.comparator_body_0.mref_m5_diff_0.tail.n33 comparator_slice_1.comparator_body_0.mref_m5_diff_0.mref_m5_array_3/n1_2$1_8.D 1.52535
R3598 comparator_slice_1.comparator_body_0.mref_m5_diff_0.tail.n35 comparator_slice_1.comparator_body_0.mref_m5_diff_0.mref_m5_array_2/n1_2$1_8.D 1.52535
R3599 comparator_slice_1.comparator_body_0.mref_m5_diff_0.tail.n57 comparator_slice_1.comparator_body_0.mref_m5_diff_0.mref_m5_array_2/n1_2$1_2.D 1.52535
R3600 comparator_slice_1.comparator_body_0.mref_m5_diff_0.tail.n63 comparator_slice_1.comparator_body_0.mref_m5_diff_0.mref_m5_array_3/n1_2$1_2.D 1.52535
R3601 comparator_slice_1.comparator_body_0.mref_m5_diff_0.tail.n83 comparator_slice_1.comparator_body_0.mref_m5_diff_0.mref_m5_array_1/n1_2$1_2.D 1.52535
R3602 comparator_slice_1.comparator_body_0.mref_m5_diff_0.tail.n29 comparator_slice_1.comparator_body_0.mref_m5_diff_0.mref_m5_array_0/n1_2$1_8.D 1.52535
R3603 comparator_slice_1.comparator_body_0.mref_m5_diff_0.tail.n69 comparator_slice_1.comparator_body_0.mref_m5_diff_0.mref_m5_array_0/n1_2$1_2.D 1.52535
R3604 comparator_slice_1.comparator_body_0.mref_m5_diff_0.tail.n99 comparator_slice_1.comparator_body_0.mref_m5_diff_0.mref_m5_array_3/n1_2$1_6.D 1.51362
R3605 comparator_slice_1.comparator_body_0.mref_m5_diff_0.tail.n114 comparator_slice_1.comparator_body_0.mref_m5_diff_0.mref_m5_array_2/n1_2$1_6.D 1.51362
R3606 comparator_slice_1.comparator_body_0.mref_m5_diff_0.tail.n92 comparator_slice_1.comparator_body_0.mref_m5_diff_0.mref_m5_array_1/n1_2$1_6.D 1.51362
R3607 comparator_slice_1.comparator_body_0.mref_m5_diff_0.tail.n38 comparator_slice_1.comparator_body_0.mref_m5_diff_0.mref_m5_array_0/n1_2$1_6.D 1.51362
R3608 comparator_slice_1.comparator_body_0.mref_m5_diff_0.tail.n84 comparator_slice_1.comparator_body_0.mref_m5_diff_0.mref_m5_array_1/n1_2$1_5.D 1.51274
R3609 comparator_slice_1.comparator_body_0.mref_m5_diff_0.tail.n96 comparator_slice_1.comparator_body_0.mref_m5_diff_0.mref_m5_array_3/n1_2$1_12.D 1.51274
R3610 comparator_slice_1.comparator_body_0.mref_m5_diff_0.tail.n104 comparator_slice_1.comparator_body_0.mref_m5_diff_0.mref_m5_array_3/n1_2$1_5.D 1.51274
R3611 comparator_slice_1.comparator_body_0.mref_m5_diff_0.tail.n111 comparator_slice_1.comparator_body_0.mref_m5_diff_0.mref_m5_array_2/n1_2$1_12.D 1.51274
R3612 comparator_slice_1.comparator_body_0.mref_m5_diff_0.tail.n60 comparator_slice_1.comparator_body_0.mref_m5_diff_0.mref_m5_array_2/n1_2$1_5.D 1.51274
R3613 comparator_slice_1.comparator_body_0.mref_m5_diff_0.tail.n67 comparator_slice_1.comparator_body_0.mref_m5_diff_0.mref_m5_array_1/n1_2$1_12.D 1.51274
R3614 comparator_slice_1.comparator_body_0.mref_m5_diff_0.tail.n76 comparator_slice_1.comparator_body_0.mref_m5_diff_0.mref_m5_array_0/n1_2$1_5.D 1.51274
R3615 comparator_slice_1.comparator_body_0.mref_m5_diff_0.tail.n72 comparator_slice_1.comparator_body_0.mref_m5_diff_0.mref_m5_array_0/n1_2$1_12.D 1.51274
R3616 comparator_slice_1.comparator_body_0.mref_m5_diff_0.tail.n71 comparator_slice_1.comparator_body_0.mref_m5_diff_0.tail.n70 1.46922
R3617 comparator_slice_1.comparator_body_0.mref_m5_diff_0.tail.n55 comparator_slice_1.comparator_body_0.mref_m5_diff_0.tail.n54 1.43754
R3618 comparator_slice_1.comparator_body_0.mref_m5_diff_0.tail.n74 comparator_slice_1.comparator_body_0.mref_m5_diff_0.tail.n73 1.3557
R3619 comparator_slice_1.comparator_body_0.mref_m5_diff_0.tail.n79 comparator_slice_1.comparator_body_0.mref_m5_diff_0.tail.n78 1.3557
R3620 comparator_slice_1.comparator_body_0.mref_m5_diff_0.tail.n91 comparator_slice_1.comparator_body_0.mref_m5_diff_0.tail.n90 1.3557
R3621 comparator_slice_1.comparator_body_0.mref_m5_diff_0.tail.n82 comparator_slice_1.comparator_body_0.mref_m5_diff_0.tail.n80 1.3557
R3622 comparator_slice_1.comparator_body_0.mref_m5_diff_0.tail.n98 comparator_slice_1.comparator_body_0.mref_m5_diff_0.tail.n97 1.3557
R3623 comparator_slice_1.comparator_body_0.mref_m5_diff_0.tail.n107 comparator_slice_1.comparator_body_0.mref_m5_diff_0.tail.n106 1.3557
R3624 comparator_slice_1.comparator_body_0.mref_m5_diff_0.tail.n113 comparator_slice_1.comparator_body_0.mref_m5_diff_0.tail.n112 1.3557
R3625 comparator_slice_1.comparator_body_0.mref_m5_diff_0.tail.n59 comparator_slice_1.comparator_body_0.mref_m5_diff_0.tail.n58 1.3557
R3626 comparator_slice_1.comparator_body_0.mref_m5_diff_0.tail.n117 comparator_slice_1.comparator_body_0.mref_m5_diff_0.tail.n16 1.20056
R3627 comparator_slice_1.comparator_body_0.m1_m2_diff_0.m1_m2_array_0/n1_2_13.S comparator_slice_1.comparator_body_0.mref_m5_diff_0.tail.n1 3.1331
R3628 comparator_slice_1.comparator_body_0.mref_m5_diff_0.tail.n40 comparator_slice_1.comparator_body_0.mref_m5_diff_0.tail.n8 1.15699
R3629 comparator_slice_1.comparator_body_0.mref_m5_diff_0.tail.n0 comparator_slice_1.comparator_body_0.mref_m5_diff_0.tail.n46 1.15699
R3630 comparator_slice_1.comparator_body_0.mref_m5_diff_0.tail.n7 comparator_slice_1.comparator_body_0.mref_m5_diff_0.tail.n49 1.15699
R3631 comparator_slice_1.comparator_body_0.mref_m5_diff_0.tail.n6 comparator_slice_1.comparator_body_0.m1_m2_diff_0.m1_m2_array_3/n1_2_10.S 3.2398
R3632 comparator_slice_1.comparator_body_0.mref_m5_diff_0.tail.n73 comparator_slice_1.comparator_body_0.mref_m5_diff_0.tail.n71 1.07322
R3633 comparator_slice_1.comparator_body_0.mref_m5_diff_0.tail.n58 comparator_slice_1.comparator_body_0.mref_m5_diff_0.tail.n55 1.05738
R3634 comparator_slice_1.comparator_body_0.mref_m5_diff_0.tail.n4 comparator_slice_1.comparator_body_0.m1_m2_diff_0.tail 0.20886
R3635 comparator_slice_1.comparator_body_0.mref_m5_diff_0.tail.n37 comparator_slice_1.comparator_body_0.mref_m5_diff_0.tail.n1 0.246191
R3636 comparator_slice_1.comparator_body_0.mref_m5_diff_0.tail.n30 comparator_slice_1.comparator_body_0.mref_m5_diff_0.tail.n27 0.9597
R3637 comparator_slice_1.comparator_body_0.mref_m5_diff_0.tail.n26 comparator_slice_1.comparator_body_0.mref_m5_diff_0.tail.n23 0.9597
R3638 comparator_slice_1.comparator_body_0.mref_m5_diff_0.tail.n110 comparator_slice_1.comparator_body_0.mref_m5_diff_0.tail.n36 0.9597
R3639 comparator_slice_1.comparator_body_0.mref_m5_diff_0.tail.n34 comparator_slice_1.comparator_body_0.mref_m5_diff_0.tail.n31 0.9597
R3640 comparator_slice_1.comparator_body_0.mref_m5_diff_0.tail.n26 comparator_slice_1.comparator_body_0.mref_m5_diff_0.tail.n24 0.95794
R3641 comparator_slice_1.comparator_body_0.mref_m5_diff_0.tail.n30 comparator_slice_1.comparator_body_0.mref_m5_diff_0.tail.n28 0.95794
R3642 comparator_slice_1.comparator_body_0.mref_m5_diff_0.tail.n34 comparator_slice_1.comparator_body_0.mref_m5_diff_0.tail.n32 0.95794
R3643 comparator_slice_1.comparator_body_0.mref_m5_diff_0.tail.n56 comparator_slice_1.comparator_body_0.mref_m5_diff_0.tail.n36 0.95794
R3644 comparator_slice_1.comparator_body_0.mref_m5_diff_0.tail.n87 comparator_slice_1.comparator_body_0.mref_m5_diff_0.tail.n86 0.9553
R3645 comparator_slice_1.comparator_body_0.mref_m5_diff_0.tail.n71 comparator_slice_1.comparator_body_0.mref_m5_diff_0.tail.n27 0.9553
R3646 comparator_slice_1.comparator_body_0.mref_m5_diff_0.tail.n88 comparator_slice_1.comparator_body_0.mref_m5_diff_0.tail.n23 0.9553
R3647 comparator_slice_1.comparator_body_0.mref_m5_diff_0.tail.n65 comparator_slice_1.comparator_body_0.mref_m5_diff_0.tail.n31 0.9553
R3648 comparator_slice_1.comparator_body_0.mref_m5_diff_0.tail.n81 comparator_slice_1.comparator_body_0.mref_m5_diff_0.tail.n64 0.9553
R3649 comparator_slice_1.comparator_body_0.mref_m5_diff_0.tail.n110 comparator_slice_1.comparator_body_0.mref_m5_diff_0.tail.n109 0.9553
R3650 comparator_slice_1.comparator_body_0.mref_m5_diff_0.tail.n108 comparator_slice_1.comparator_body_0.mref_m5_diff_0.tail.n62 0.9553
R3651 comparator_slice_1.comparator_body_0.mref_m5_diff_0.tail.n88 comparator_slice_1.comparator_body_0.mref_m5_diff_0.tail.n28 0.93946
R3652 comparator_slice_1.comparator_body_0.mref_m5_diff_0.tail.n24 comparator_slice_1.comparator_body_0.mref_m5_diff_0.tail.n65 0.93946
R3653 comparator_slice_1.comparator_body_0.mref_m5_diff_0.tail.n109 comparator_slice_1.comparator_body_0.mref_m5_diff_0.tail.n32 0.93946
R3654 comparator_slice_1.comparator_body_0.mref_m5_diff_0.tail.n56 comparator_slice_1.comparator_body_0.mref_m5_diff_0.tail.n55 0.93946
R3655 comparator_slice_1.comparator_body_0.mref_m5_diff_0.tail.n95 comparator_slice_1.comparator_body_0.mref_m5_diff_0.tail.n94 0.92362
R3656 comparator_slice_1.comparator_body_0.mref_m5_diff_0.tail.n89 comparator_slice_1.comparator_body_0.mref_m5_diff_0.tail.n68 0.92362
R3657 comparator_slice_1.comparator_body_0.mref_m5_diff_0.tail.n102 comparator_slice_1.comparator_body_0.mref_m5_diff_0.tail.n53 0.92362
R3658 comparator_slice_1.comparator_body_0.mref_m5_diff_0.tail.n1 comparator_slice_1.comparator_body_0.m1_m2_diff_0.m1_m2_array_0/n1_2_8.S 3.26694
R3659 comparator_slice_1.comparator_body_0.mref_m5_diff_0.tail.n12 comparator_slice_1.comparator_body_0.m1_m2_diff_0.m1_m2_array_2/n1_2_8.S 3.28899
R3660 comparator_slice_1.comparator_body_0.m1_m2_diff_0.m1_m2_array_3/n1_2_8.S comparator_slice_1.comparator_body_0.mref_m5_diff_0.tail.n1 3.26694
R3661 comparator_slice_1.comparator_body_0.mref_m5_diff_0.tail.n10 comparator_slice_1.comparator_body_0.mref_m5_diff_0.tail.n19 0.226949
R3662 comparator_slice_1.comparator_body_0.mref_m5_diff_0.tail.n21 comparator_slice_1.comparator_body_0.mref_m5_diff_0.tail.n1 0.17416
R3663 comparator_slice_1.comparator_body_0.mref_m5_diff_0.tail.n15 comparator_slice_1.comparator_body_0.mref_m5_diff_0.tail.n45 0.782916
R3664 comparator_slice_1.comparator_body_0.m1_m2_diff_0.m1_m2_array_0/n1_2_11.S comparator_slice_1.comparator_body_0.mref_m5_diff_0.tail.n1 3.2259
R3665 comparator_slice_1.comparator_body_0.mref_m5_diff_0.tail.n1 comparator_slice_1.comparator_body_0.m1_m2_diff_0.m1_m2_array_2/n1_2_15.S 3.33126
R3666 comparator_slice_1.comparator_body_0.mref_m5_diff_0.tail.n2 comparator_slice_1.comparator_body_0.mref_m5_diff_0.tail.n1 0.133438
R3667 comparator_slice_1.comparator_body_0.mref_m5_diff_0.tail.n116 comparator_slice_1.comparator_body_0.mref_m5_diff_0.tail.n22 0.76549
R3668 comparator_slice_1.comparator_body_0.mref_m5_diff_0.tail.n14 comparator_slice_1.comparator_body_0.mref_m5_diff_0.tail.n16 0.74674
R3669 comparator_slice_1.comparator_body_0.mref_m5_diff_0.tail.n44 comparator_slice_1.comparator_body_0.mref_m5_diff_0.tail.n43 0.736738
R3670 comparator_slice_1.comparator_body_0.m1_m2_diff_0.m1_m2_array_0/n1_2_0.S comparator_slice_1.comparator_body_0.mref_m5_diff_0.tail.n9 3.24084
R3671 comparator_slice_1.comparator_body_0.mref_m5_diff_0.tail.n5 comparator_slice_1.comparator_body_0.m1_m2_diff_0.m1_m2_array_2/n1_2_11.S 3.22578
R3672 comparator_slice_1.comparator_body_0.mref_m5_diff_0.tail.n2 comparator_slice_1.comparator_body_0.m1_m2_diff_0.m1_m2_array_3/n1_2_11.S 3.22577
R3673 comparator_slice_1.comparator_body_0.mref_m5_diff_0.tail.n1 comparator_slice_1.comparator_body_0.m1_m2_diff_0.m1_m2_array_0/n1_2_4.S 3.15002
R3674 comparator_slice_1.comparator_body_0.mref_m5_diff_0.tail.n42 comparator_slice_1.comparator_body_0.mref_m5_diff_0.tail.n41 0.694916
R3675 comparator_slice_1.comparator_body_0.mref_m5_diff_0.tail.n46 comparator_slice_1.comparator_body_0.mref_m5_diff_0.tail.n9 0.577045
R3676 comparator_slice_1.comparator_body_0.mref_m5_diff_0.tail.n48 comparator_slice_1.comparator_body_0.mref_m5_diff_0.tail.n47 0.694916
R3677 comparator_slice_1.comparator_body_0.mref_m5_diff_0.tail.n6 comparator_slice_1.comparator_body_0.mref_m5_diff_0.tail.n50 0.785418
R3678 comparator_slice_1.comparator_body_0.mref_m5_diff_0.tail.n17 comparator_slice_1.comparator_body_0.mref_m5_diff_0.tail.n1 0.230649
R3679 comparator_slice_1.comparator_body_0.mref_m5_diff_0.tail.n17 comparator_slice_1.comparator_body_0.mref_m5_diff_0.tail.n15 0.673421
R3680 comparator_slice_1.comparator_body_0.mref_m5_diff_0.tail.n18 comparator_slice_1.comparator_body_0.mref_m5_diff_0.tail.n115 0.651351
R3681 comparator_slice_1.comparator_body_0.mref_m5_diff_0.tail.n115 comparator_slice_1.comparator_body_0.mref_m5_diff_0.tail.n1 0.632488
R3682 comparator_slice_1.comparator_body_0.mref_m5_diff_0.tail.n100 comparator_slice_1.comparator_body_0.mref_m5_diff_0.tail.n1 0.613015
R3683 comparator_slice_1.comparator_body_0.mref_m5_diff_0.tail.n94 comparator_slice_1.comparator_body_0.mref_m5_diff_0.tail.n66 0.57778
R3684 comparator_slice_1.comparator_body_0.mref_m5_diff_0.tail.n75 comparator_slice_1.comparator_body_0.mref_m5_diff_0.tail.n68 0.57778
R3685 comparator_slice_1.comparator_body_0.mref_m5_diff_0.tail.n103 comparator_slice_1.comparator_body_0.mref_m5_diff_0.tail.n102 0.57778
R3686 comparator_slice_1.comparator_body_0.mref_m5_diff_0.tail.n54 comparator_slice_1.comparator_body_0.mref_m5_diff_0.tail.n52 0.57778
R3687 comparator_slice_1.comparator_body_0.mref_m5_diff_0.tail.n36 comparator_slice_1.comparator_body_0.mref_m5_diff_0.tail.n35 0.5769
R3688 comparator_slice_1.comparator_body_0.mref_m5_diff_0.tail.n34 comparator_slice_1.comparator_body_0.mref_m5_diff_0.tail.n33 0.5769
R3689 comparator_slice_1.comparator_body_0.mref_m5_diff_0.tail.n30 comparator_slice_1.comparator_body_0.mref_m5_diff_0.tail.n29 0.5769
R3690 comparator_slice_1.comparator_body_0.mref_m5_diff_0.tail.n26 comparator_slice_1.comparator_body_0.mref_m5_diff_0.tail.n25 0.5769
R3691 comparator_slice_1.comparator_body_0.mref_m5_diff_0.tail.n86 comparator_slice_1.comparator_body_0.mref_m5_diff_0.tail.n85 0.5637
R3692 comparator_slice_1.comparator_body_0.mref_m5_diff_0.tail.n77 comparator_slice_1.comparator_body_0.mref_m5_diff_0.tail.n70 0.5637
R3693 comparator_slice_1.comparator_body_0.mref_m5_diff_0.tail.n105 comparator_slice_1.comparator_body_0.mref_m5_diff_0.tail.n64 0.5637
R3694 comparator_slice_1.comparator_body_0.mref_m5_diff_0.tail.n62 comparator_slice_1.comparator_body_0.mref_m5_diff_0.tail.n61 0.5637
R3695 comparator_slice_1.comparator_body_0.mref_m5_diff_0.tail.n90 comparator_slice_1.comparator_body_0.mref_m5_diff_0.tail.n89 0.5593
R3696 comparator_slice_1.comparator_body_0.mref_m5_diff_0.tail.n97 comparator_slice_1.comparator_body_0.mref_m5_diff_0.tail.n95 0.5593
R3697 comparator_slice_1.comparator_body_0.mref_m5_diff_0.tail.n112 comparator_slice_1.comparator_body_0.mref_m5_diff_0.tail.n53 0.5593
R3698 comparator_slice_1.comparator_body_0.mref_m5_diff_0.tail.n87 comparator_slice_1.comparator_body_0.mref_m5_diff_0.tail.n79 0.54346
R3699 comparator_slice_1.comparator_body_0.mref_m5_diff_0.tail.n82 comparator_slice_1.comparator_body_0.mref_m5_diff_0.tail.n81 0.54346
R3700 comparator_slice_1.comparator_body_0.mref_m5_diff_0.tail.n108 comparator_slice_1.comparator_body_0.mref_m5_diff_0.tail.n107 0.54346
R3701 comparator_slice_1.comparator_body_0.mref_m5_diff_0.tail.n72 comparator_slice_1.comparator_body_0.mref_m5_diff_0.tail.n27 0.52058
R3702 comparator_slice_1.comparator_body_0.mref_m5_diff_0.tail.n23 comparator_slice_1.comparator_body_0.mref_m5_diff_0.tail.n67 0.52058
R3703 comparator_slice_1.comparator_body_0.mref_m5_diff_0.tail.n96 comparator_slice_1.comparator_body_0.mref_m5_diff_0.tail.n31 0.52058
R3704 comparator_slice_1.comparator_body_0.mref_m5_diff_0.tail.n111 comparator_slice_1.comparator_body_0.mref_m5_diff_0.tail.n110 0.52058
R3705 comparator_slice_1.comparator_body_0.mref_m5_diff_0.tail.n84 comparator_slice_1.comparator_body_0.mref_m5_diff_0.tail.n26 0.5197
R3706 comparator_slice_1.comparator_body_0.mref_m5_diff_0.tail.n76 comparator_slice_1.comparator_body_0.mref_m5_diff_0.tail.n30 0.5197
R3707 comparator_slice_1.comparator_body_0.mref_m5_diff_0.tail.n69 comparator_slice_1.comparator_body_0.mref_m5_diff_0.tail.n28 0.5197
R3708 comparator_slice_1.comparator_body_0.mref_m5_diff_0.tail.n24 comparator_slice_1.comparator_body_0.mref_m5_diff_0.tail.n83 0.5197
R3709 comparator_slice_1.comparator_body_0.mref_m5_diff_0.tail.n104 comparator_slice_1.comparator_body_0.mref_m5_diff_0.tail.n34 0.5197
R3710 comparator_slice_1.comparator_body_0.mref_m5_diff_0.tail.n63 comparator_slice_1.comparator_body_0.mref_m5_diff_0.tail.n32 0.5197
R3711 comparator_slice_1.comparator_body_0.mref_m5_diff_0.tail.n60 comparator_slice_1.comparator_body_0.mref_m5_diff_0.tail.n36 0.5197
R3712 comparator_slice_1.comparator_body_0.mref_m5_diff_0.tail.n57 comparator_slice_1.comparator_body_0.mref_m5_diff_0.tail.n56 0.5197
R3713 comparator_slice_1.comparator_body_0.mref_m5_diff_0.tail.n114 comparator_slice_1.comparator_body_0.mref_m5_diff_0.tail.n113 0.51354
R3714 comparator_slice_1.comparator_body_0.mref_m5_diff_0.tail.n74 comparator_slice_1.comparator_body_0.mref_m5_diff_0.tail.n38 0.50826
R3715 comparator_slice_1.comparator_body_0.mref_m5_diff_0.tail.n99 comparator_slice_1.comparator_body_0.mref_m5_diff_0.tail.n98 0.49858
R3716 comparator_slice_1.comparator_body_0.mref_m5_diff_0.tail.n92 comparator_slice_1.comparator_body_0.mref_m5_diff_0.tail.n91 0.49242
R3717 comparator_slice_1.comparator_body_0.mref_m5_diff_0.tail.n116 comparator_slice_1.comparator_body_0.mref_m5_diff_0.tail.n14 0.47042
R3718 comparator_slice_1.comparator_body_0.mref_m5_diff_0.tail.n22 comparator_slice_1.comparator_body_0.mref_m5_diff_0.tail.n10 0.496177
R3719 comparator_slice_1.comparator_body_0.mref_m5_diff_0.tail.n20 comparator_slice_1.comparator_body_0.mref_m5_diff_0.tail.n12 0.213834
R3720 comparator_slice_1.comparator_body_0.mref_m5_diff_0.tail.n45 comparator_slice_1.comparator_body_0.mref_m5_diff_0.tail.n1 0.46954
R3721 comparator_slice_1.comparator_body_0.mref_m5_diff_0.tail.n41 comparator_slice_1.comparator_body_0.mref_m5_diff_0.tail.n1 0.46954
R3722 comparator_slice_1.comparator_body_0.mref_m5_diff_0.tail.n43 comparator_slice_1.comparator_body_0.mref_m5_diff_0.tail.n1 0.46954
R3723 comparator_slice_1.comparator_body_0.mref_m5_diff_0.tail.n48 comparator_slice_1.comparator_body_0.mref_m5_diff_0.tail.n1 0.46954
R3724 comparator_slice_1.comparator_body_0.mref_m5_diff_0.tail.n47 comparator_slice_1.comparator_body_0.mref_m5_diff_0.tail.n5 0.550764
R3725 comparator_slice_1.comparator_body_0.mref_m5_diff_0.tail.n6 comparator_slice_1.comparator_body_0.mref_m5_diff_0.tail.n1 0.270668
R3726 comparator_slice_1.comparator_body_0.mref_m5_diff_0.tail.n50 comparator_slice_1.comparator_body_0.mref_m5_diff_0.tail.n2 0.55077
R3727 comparator_slice_1.comparator_body_0.mref_m5_diff_0.tail.n54 comparator_slice_1.comparator_body_0.mref_m5_diff_0.tail.n51 0.46074
R3728 comparator_slice_1.comparator_body_0.mref_m5_diff_0.tail.n94 comparator_slice_1.comparator_body_0.mref_m5_diff_0.tail.n93 0.45722
R3729 comparator_slice_1.comparator_body_0.mref_m5_diff_0.tail.n75 comparator_slice_1.comparator_body_0.mref_m5_diff_0.tail.n74 0.45458
R3730 comparator_slice_1.comparator_body_0.mref_m5_diff_0.tail.n91 comparator_slice_1.comparator_body_0.mref_m5_diff_0.tail.n66 0.45458
R3731 comparator_slice_1.comparator_body_0.mref_m5_diff_0.tail.n113 comparator_slice_1.comparator_body_0.mref_m5_diff_0.tail.n52 0.45458
R3732 comparator_slice_1.comparator_body_0.mref_m5_diff_0.tail.n103 comparator_slice_1.comparator_body_0.mref_m5_diff_0.tail.n98 0.45458
R3733 comparator_slice_1.comparator_body_0.mref_m5_diff_0.tail.n85 comparator_slice_1.comparator_body_0.mref_m5_diff_0.tail.n80 0.45282
R3734 comparator_slice_1.comparator_body_0.mref_m5_diff_0.tail.n78 comparator_slice_1.comparator_body_0.mref_m5_diff_0.tail.n77 0.45282
R3735 comparator_slice_1.comparator_body_0.mref_m5_diff_0.tail.n106 comparator_slice_1.comparator_body_0.mref_m5_diff_0.tail.n105 0.45282
R3736 comparator_slice_1.comparator_body_0.mref_m5_diff_0.tail.n61 comparator_slice_1.comparator_body_0.mref_m5_diff_0.tail.n59 0.45282
R3737 comparator_slice_1.comparator_body_0.mref_m5_diff_0.tail.n68 comparator_slice_1.comparator_body_0.mref_m5_diff_0.tail.n39 0.45106
R3738 comparator_slice_1.comparator_body_0.mref_m5_diff_0.tail.n19 comparator_slice_1.comparator_body_0.mref_m5_diff_0.tail.n18 0.430045
R3739 comparator_slice_1.comparator_body_0.mref_m5_diff_0.tail.n100 comparator_slice_1.comparator_body_0.mref_m5_diff_0.tail.n20 0.426559
R3740 comparator_slice_1.comparator_body_0.mref_m5_diff_0.tail.n102 comparator_slice_1.comparator_body_0.mref_m5_diff_0.tail.n101 0.42642
R3741 comparator_slice_1.comparator_body_0.mref_m5_diff_0.tail.n11 comparator_slice_1.comparator_body_0.mref_m5_diff_0.tail.n14 0.0772902
R3742 comparator_slice_1.comparator_body_0.mref_m5_diff_0.tail.n41 comparator_slice_1.comparator_body_0.mref_m5_diff_0.tail.n40 0.38648
R3743 comparator_slice_1.comparator_body_0.mref_m5_diff_0.tail.n49 comparator_slice_1.comparator_body_0.mref_m5_diff_0.tail.n48 0.38648
R3744 comparator_slice_1.comparator_body_0.mref_m5_diff_0.tail.n4 comparator_slice_1.comparator_body_0.m1_m2_diff_0.m1_m2_array_2/n1_2_13.S 3.21614
R3745 comparator_slice_1.comparator_body_0.mref_m5_diff_0.tail.n17 comparator_slice_1.comparator_body_0.mref_m5_diff_0.tail.n16 0.3657
R3746 comparator_slice_1.comparator_body_0.m1_m2_diff_0.tail comparator_slice_1.comparator_body_0.mref_m5_diff_0.tail.n1 0.200497
R3747 comparator_slice_1.comparator_body_0.m1_m2_diff_0.m1_m2_array_1/n1_2_7.S comparator_slice_1.comparator_body_0.mref_m5_diff_0.tail.n1 3.19528
R3748 comparator_slice_1.comparator_body_0.m1_m2_diff_0.m1_m2_array_0/n1_2_7.S comparator_slice_1.comparator_body_0.mref_m5_diff_0.tail.n1 3.19528
R3749 comparator_slice_1.comparator_body_0.m1_m2_diff_0.m1_m2_array_2/n1_2_7.S comparator_slice_1.comparator_body_0.mref_m5_diff_0.tail.n1 3.19528
R3750 comparator_slice_1.comparator_body_0.m1_m2_diff_0.m1_m2_array_3/n1_2_7.S comparator_slice_1.comparator_body_0.mref_m5_diff_0.tail.n1 3.17074
R3751 comparator_slice_1.comparator_body_0.mref_m5_diff_0.tail.n43 comparator_slice_1.comparator_body_0.mref_m5_diff_0.tail.n42 0.344658
R3752 comparator_slice_1.comparator_body_0.mref_m5_diff_0.tail.n1 comparator_slice_1.comparator_body_0.m1_m2_diff_0.m1_m2_array_3/n1_2_15.S 3.3314
R3753 comparator_slice_1.comparator_body_0.mref_m5_diff_0.tail.n1 comparator_slice_1.comparator_body_0.m1_m2_diff_0.m1_m2_array_0/n1_2_15.S 3.33028
R3754 comparator_slice_1.comparator_body_0.mref_m5_diff_0.tail.n1 comparator_slice_1.comparator_body_0.mref_m5_diff_0.tail.n0 0.201428
R3755 comparator_slice_1.comparator_body_0.m1_m2_diff_0.m1_m2_array_1/n1_2_3.S comparator_slice_1.comparator_body_0.mref_m5_diff_0.tail.n1 3.15779
R3756 comparator_slice_1.comparator_body_0.m1_m2_diff_0.m1_m2_array_0/n1_2_3.S comparator_slice_1.comparator_body_0.mref_m5_diff_0.tail.n1 3.15779
R3757 comparator_slice_1.comparator_body_0.mref_m5_diff_0.tail.n25 comparator_slice_1.comparator_body_0.mref_m5_diff_0.tail.n66 0.3041
R3758 comparator_slice_1.comparator_body_0.mref_m5_diff_0.tail.n29 comparator_slice_1.comparator_body_0.mref_m5_diff_0.tail.n75 0.3041
R3759 comparator_slice_1.comparator_body_0.m1_m2_diff_0.m1_m2_array_2/n1_2_3.S comparator_slice_1.comparator_body_0.mref_m5_diff_0.tail.n1 3.15779
R3760 comparator_slice_1.comparator_body_0.mref_m5_diff_0.tail.n33 comparator_slice_1.comparator_body_0.mref_m5_diff_0.tail.n103 0.3041
R3761 comparator_slice_1.comparator_body_0.m1_m2_diff_0.m1_m2_array_3/n1_2_3.S comparator_slice_1.comparator_body_0.mref_m5_diff_0.tail.n1 3.15779
R3762 comparator_slice_1.comparator_body_0.mref_m5_diff_0.tail.n35 comparator_slice_1.comparator_body_0.mref_m5_diff_0.tail.n52 0.3041
R3763 comparator_slice_1.comparator_body_0.mref_m5_diff_0.tail.n85 comparator_slice_1.comparator_body_0.mref_m5_diff_0.tail.n84 0.30322
R3764 comparator_slice_1.comparator_body_0.mref_m5_diff_0.tail.n77 comparator_slice_1.comparator_body_0.mref_m5_diff_0.tail.n76 0.30322
R3765 comparator_slice_1.comparator_body_0.mref_m5_diff_0.tail.n79 comparator_slice_1.comparator_body_0.mref_m5_diff_0.tail.n69 0.30322
R3766 comparator_slice_1.comparator_body_0.mref_m5_diff_0.tail.n83 comparator_slice_1.comparator_body_0.mref_m5_diff_0.tail.n82 0.30322
R3767 comparator_slice_1.comparator_body_0.mref_m5_diff_0.tail.n105 comparator_slice_1.comparator_body_0.mref_m5_diff_0.tail.n104 0.30322
R3768 comparator_slice_1.comparator_body_0.mref_m5_diff_0.tail.n107 comparator_slice_1.comparator_body_0.mref_m5_diff_0.tail.n63 0.30322
R3769 comparator_slice_1.comparator_body_0.mref_m5_diff_0.tail.n61 comparator_slice_1.comparator_body_0.mref_m5_diff_0.tail.n60 0.30322
R3770 comparator_slice_1.comparator_body_0.mref_m5_diff_0.tail.n58 comparator_slice_1.comparator_body_0.mref_m5_diff_0.tail.n57 0.30322
R3771 comparator_slice_1.comparator_body_0.mref_m5_diff_0.tail.n73 comparator_slice_1.comparator_body_0.mref_m5_diff_0.tail.n72 0.30234
R3772 comparator_slice_1.comparator_body_0.mref_m5_diff_0.tail.n90 comparator_slice_1.comparator_body_0.mref_m5_diff_0.tail.n67 0.30234
R3773 comparator_slice_1.comparator_body_0.mref_m5_diff_0.tail.n97 comparator_slice_1.comparator_body_0.mref_m5_diff_0.tail.n96 0.30234
R3774 comparator_slice_1.comparator_body_0.mref_m5_diff_0.tail.n112 comparator_slice_1.comparator_body_0.mref_m5_diff_0.tail.n111 0.30234
R3775 comparator_slice_1.comparator_body_0.mref_m5_diff_0.tail.n45 comparator_slice_1.comparator_body_0.mref_m5_diff_0.tail.n44 0.29848
R3776 comparator_slice_1.comparator_body_0.m1_m2_diff_0.m1_m2_array_1/n1_2_4.S comparator_slice_1.comparator_body_0.mref_m5_diff_0.tail.n11 3.15002
R3777 comparator_slice_1.comparator_body_0.mref_m5_diff_0.tail.n89 comparator_slice_1.comparator_body_0.mref_m5_diff_0.tail.n88 0.25746
R3778 comparator_slice_1.comparator_body_0.mref_m5_diff_0.tail.n88 comparator_slice_1.comparator_body_0.mref_m5_diff_0.tail.n87 0.25746
R3779 comparator_slice_1.comparator_body_0.mref_m5_diff_0.tail.n95 comparator_slice_1.comparator_body_0.mref_m5_diff_0.tail.n65 0.25746
R3780 comparator_slice_1.comparator_body_0.mref_m5_diff_0.tail.n81 comparator_slice_1.comparator_body_0.mref_m5_diff_0.tail.n65 0.25746
R3781 comparator_slice_1.comparator_body_0.m1_m2_diff_0.m1_m2_array_2/n1_2_4.S comparator_slice_1.comparator_body_0.mref_m5_diff_0.tail.n1 3.37712
R3782 comparator_slice_1.comparator_body_0.mref_m5_diff_0.tail.n109 comparator_slice_1.comparator_body_0.mref_m5_diff_0.tail.n53 0.25746
R3783 comparator_slice_1.comparator_body_0.mref_m5_diff_0.tail.n109 comparator_slice_1.comparator_body_0.mref_m5_diff_0.tail.n108 0.25746
R3784 comparator_slice_1.comparator_body_0.m1_m2_diff_0.m1_m2_array_3/n1_2_4.S comparator_slice_1.comparator_body_0.mref_m5_diff_0.tail.n1 3.17121
R3785 comparator_slice_1.comparator_body_0.mref_m5_diff_0.tail.n117 comparator_slice_1.comparator_body_0.mref_m5_diff_0.tail.n116 0.256658
R3786 comparator_slice_1.comparator_body_0.m1_m2_diff_0.m1_m2_array_1/n1_2_14.S comparator_slice_1.comparator_body_0.mref_m5_diff_0.tail.n1 3.11241
R3787 comparator_slice_1.comparator_body_0.mref_m5_diff_0.tail.n13 comparator_slice_1.comparator_body_0.mref_m5_diff_0.tail.n1 1.11616
R3788 comparator_slice_1.comparator_body_0.mref_m5_diff_0.tail.n1 comparator_slice_1.comparator_body_0.mref_m5_diff_0.tail.n7 1.11101
R3789 comparator_slice_1.comparator_body_0.mref_m5_diff_0.tail.n1 comparator_slice_1.comparator_body_0.mref_m5_diff_0.tail.n3 1.11061
R3790 comparator_slice_1.comparator_body_0.mref_m5_diff_0.tail.n1 comparator_slice_1.comparator_body_0.mref_m5_diff_0.tail.n8 1.0887
R3791 comparator_slice_1.comparator_body_0.mref_m5_diff_0.tail.n9 comparator_slice_1.comparator_body_0.mref_m5_diff_0.tail.n1 1.07734
R3792 comparator_slice_1.comparator_body_0.mref_m5_diff_0.tail.n5 comparator_slice_1.comparator_body_0.mref_m5_diff_0.tail.n1 1.06187
R3793 comparator_slice_1.comparator_body_0.mref_m5_diff_0.tail.n4 comparator_slice_1.comparator_body_0.mref_m5_diff_0.tail.n1 1.05355
R3794 comparator_slice_1.comparator_body_0.mref_m5_diff_0.tail.n12 comparator_slice_1.comparator_body_0.mref_m5_diff_0.tail.n1 1.04446
R3795 comparator_slice_1.comparator_body_0.mref_m5_diff_0.tail.n10 comparator_slice_1.comparator_body_0.mref_m5_diff_0.tail.n1 1.02602
R3796 comparator_slice_1.comparator_body_0.mref_m5_diff_0.tail.n1 comparator_slice_1.comparator_body_0.mref_m5_diff_0.tail.n11 1.00271
R3797 comparator_slice_1.comparator_body_0.outx comparator_slice_1.comparator_body_0.outx.t0 5.77616
R3798 comparator_slice_1.comparator_body_0.outx comparator_slice_1.comparator_body_0.outx.t6 5.77616
R3799 comparator_slice_1.comparator_body_0.outx comparator_slice_1.comparator_body_0.outx.n47 5.69938
R3800 comparator_slice_1.comparator_body_0.outx.n1 comparator_slice_1.comparator_body_0.outx 4.84798
R3801 comparator_slice_1.comparator_body_0.outx.t6 comparator_slice_1.comparator_body_0.outx 4.33663
R3802 comparator_slice_1.comparator_body_0.outx comparator_slice_1.comparator_body_0.outx.t0 4.33464
R3803 comparator_slice_1.comparator_body_0.outx.n47 comparator_slice_1.comparator_body_0.outx.t65 4.1228
R3804 comparator_slice_1.comparator_body_0.outx.n46 comparator_slice_1.comparator_body_0.outx.t66 4.12103
R3805 comparator_slice_1.comparator_body_0.outx.n46 comparator_slice_1.comparator_body_0.outx.t67 4.11911
R3806 comparator_slice_1.comparator_body_0.outx.n47 comparator_slice_1.comparator_body_0.outx.t64 4.10479
R3807 comparator_slice_1.comparator_body_0.outx.n6 comparator_slice_1.comparator_body_0.outx.n15 2.82266
R3808 comparator_slice_1.comparator_body_0.outx.n40 comparator_slice_1.comparator_body_0.outx.n7 2.59122
R3809 comparator_slice_1.comparator_body_0.outx.n36 comparator_slice_1.comparator_body_0.outx.n61 2.57098
R3810 comparator_slice_1.comparator_body_0.outx comparator_slice_1.comparator_body_0.outx.t4 2.47695
R3811 comparator_slice_1.comparator_body_0.outx comparator_slice_1.comparator_body_0.outx.t63 2.47695
R3812 comparator_slice_1.comparator_body_0.outx comparator_slice_1.comparator_body_0.outx.t19 2.47695
R3813 comparator_slice_1.comparator_body_0.outx comparator_slice_1.comparator_body_0.outx.t61 2.47695
R3814 comparator_slice_1.comparator_body_0.outx comparator_slice_1.comparator_body_0.outx.t23 2.47695
R3815 comparator_slice_1.comparator_body_0.outx comparator_slice_1.comparator_body_0.outx.t11 2.47695
R3816 comparator_slice_1.comparator_body_0.outx comparator_slice_1.comparator_body_0.outx.t62 2.47695
R3817 comparator_slice_1.comparator_body_0.outx comparator_slice_1.comparator_body_0.outx.t27 2.47695
R3818 comparator_slice_1.comparator_body_0.outx comparator_slice_1.comparator_body_0.outx.t22 2.47695
R3819 comparator_slice_1.comparator_body_0.outx comparator_slice_1.comparator_body_0.outx.t21 2.47695
R3820 comparator_slice_1.comparator_body_0.outx comparator_slice_1.comparator_body_0.outx.t28 2.47695
R3821 comparator_slice_1.comparator_body_0.outx comparator_slice_1.comparator_body_0.outx.t12 2.47695
R3822 comparator_slice_1.comparator_body_0.outx comparator_slice_1.comparator_body_0.outx.t26 2.47695
R3823 comparator_slice_1.comparator_body_0.outx comparator_slice_1.comparator_body_0.outx.t10 2.47695
R3824 comparator_slice_1.comparator_body_0.outx comparator_slice_1.comparator_body_0.outx.t53 2.46703
R3825 comparator_slice_1.comparator_body_0.outx comparator_slice_1.comparator_body_0.outx.t39 2.46703
R3826 comparator_slice_1.comparator_body_0.outx comparator_slice_1.comparator_body_0.outx.t56 2.46703
R3827 comparator_slice_1.comparator_body_0.outx comparator_slice_1.comparator_body_0.outx.t40 2.46703
R3828 comparator_slice_1.comparator_body_0.outx comparator_slice_1.comparator_body_0.outx.t55 2.46703
R3829 comparator_slice_1.comparator_body_0.outx comparator_slice_1.comparator_body_0.outx.t34 2.46703
R3830 comparator_slice_1.comparator_body_0.outx comparator_slice_1.comparator_body_0.outx.t41 2.46703
R3831 comparator_slice_1.comparator_body_0.outx comparator_slice_1.comparator_body_0.outx.t46 2.46703
R3832 comparator_slice_1.comparator_body_0.outx comparator_slice_1.comparator_body_0.outx.t50 2.46703
R3833 comparator_slice_1.comparator_body_0.outx comparator_slice_1.comparator_body_0.outx.t37 2.46703
R3834 comparator_slice_1.comparator_body_0.outx comparator_slice_1.comparator_body_0.outx.t30 2.46703
R3835 comparator_slice_1.comparator_body_0.outx comparator_slice_1.comparator_body_0.outx.t31 2.46703
R3836 comparator_slice_1.comparator_body_0.outx comparator_slice_1.comparator_body_0.outx.t44 2.46703
R3837 comparator_slice_1.comparator_body_0.outx comparator_slice_1.comparator_body_0.outx.t58 2.46703
R3838 comparator_slice_1.comparator_body_0.outx comparator_slice_1.comparator_body_0.outx.t54 2.46703
R3839 comparator_slice_1.comparator_body_0.outx comparator_slice_1.comparator_body_0.outx.t59 2.46703
R3840 comparator_slice_1.comparator_body_0.outx comparator_slice_1.comparator_body_0.outx.t13 2.46234
R3841 comparator_slice_1.comparator_body_0.outx comparator_slice_1.comparator_body_0.outx.t7 2.46234
R3842 comparator_slice_1.comparator_body_0.outx comparator_slice_1.comparator_body_0.outx.t15 2.46234
R3843 comparator_slice_1.comparator_body_0.outx comparator_slice_1.comparator_body_0.outx.t17 2.46234
R3844 comparator_slice_1.comparator_body_0.outx comparator_slice_1.comparator_body_0.outx.t20 2.46234
R3845 comparator_slice_1.comparator_body_0.outx comparator_slice_1.comparator_body_0.outx.t9 2.46234
R3846 comparator_slice_1.comparator_body_0.outx comparator_slice_1.comparator_body_0.outx.t25 2.46234
R3847 comparator_slice_1.comparator_body_0.outx comparator_slice_1.comparator_body_0.outx.t24 2.46234
R3848 comparator_slice_1.comparator_body_0.outx comparator_slice_1.comparator_body_0.outx.t8 2.46234
R3849 comparator_slice_1.comparator_body_0.outx comparator_slice_1.comparator_body_0.outx.t5 2.46234
R3850 comparator_slice_1.comparator_body_0.outx comparator_slice_1.comparator_body_0.outx.t2 2.46234
R3851 comparator_slice_1.comparator_body_0.outx comparator_slice_1.comparator_body_0.outx.t1 2.46234
R3852 comparator_slice_1.comparator_body_0.outx comparator_slice_1.comparator_body_0.outx.t16 2.46234
R3853 comparator_slice_1.comparator_body_0.outx comparator_slice_1.comparator_body_0.outx.t3 2.46234
R3854 comparator_slice_1.comparator_body_0.outx comparator_slice_1.comparator_body_0.outx.t18 2.46234
R3855 comparator_slice_1.comparator_body_0.outx comparator_slice_1.comparator_body_0.outx.t14 2.46234
R3856 comparator_slice_1.comparator_body_0.outx comparator_slice_1.comparator_body_0.outx.t43 2.45485
R3857 comparator_slice_1.comparator_body_0.outx comparator_slice_1.comparator_body_0.outx.t45 2.45485
R3858 comparator_slice_1.comparator_body_0.outx comparator_slice_1.comparator_body_0.outx.t57 2.45485
R3859 comparator_slice_1.comparator_body_0.outx comparator_slice_1.comparator_body_0.outx.t29 2.45485
R3860 comparator_slice_1.comparator_body_0.outx comparator_slice_1.comparator_body_0.outx.t49 2.45485
R3861 comparator_slice_1.comparator_body_0.outx comparator_slice_1.comparator_body_0.outx.t42 2.45485
R3862 comparator_slice_1.comparator_body_0.outx comparator_slice_1.comparator_body_0.outx.t51 2.45485
R3863 comparator_slice_1.comparator_body_0.outx comparator_slice_1.comparator_body_0.outx.t36 2.45485
R3864 comparator_slice_1.comparator_body_0.outx comparator_slice_1.comparator_body_0.outx.t38 2.45485
R3865 comparator_slice_1.comparator_body_0.outx comparator_slice_1.comparator_body_0.outx.t48 2.45485
R3866 comparator_slice_1.comparator_body_0.outx comparator_slice_1.comparator_body_0.outx.t35 2.45485
R3867 comparator_slice_1.comparator_body_0.outx comparator_slice_1.comparator_body_0.outx.t32 2.45485
R3868 comparator_slice_1.comparator_body_0.outx comparator_slice_1.comparator_body_0.outx.t52 2.45485
R3869 comparator_slice_1.comparator_body_0.outx comparator_slice_1.comparator_body_0.outx.t47 2.45485
R3870 comparator_slice_1.comparator_body_0.outx comparator_slice_1.comparator_body_0.outx.t60 2.45485
R3871 comparator_slice_1.comparator_body_0.outx comparator_slice_1.comparator_body_0.outx.t33 2.45485
R3872 comparator_slice_1.comparator_body_0.outx.n60 comparator_slice_1.comparator_body_0.outx 2.37543
R3873 comparator_slice_1.comparator_body_0.outx.n56 comparator_slice_1.comparator_body_0.outx 2.37543
R3874 comparator_slice_1.comparator_body_0.outx.n58 comparator_slice_1.comparator_body_0.outx 2.37543
R3875 comparator_slice_1.comparator_body_0.outx.n63 comparator_slice_1.comparator_body_0.outx 2.37543
R3876 comparator_slice_1.comparator_body_0.outx.n59 comparator_slice_1.comparator_body_0.outx 2.16951
R3877 comparator_slice_1.comparator_body_0.outx.n62 comparator_slice_1.comparator_body_0.outx 2.16951
R3878 comparator_slice_1.comparator_body_0.outx.n54 comparator_slice_1.comparator_body_0.outx 2.16951
R3879 comparator_slice_1.comparator_body_0.outx.n55 comparator_slice_1.comparator_body_0.outx 2.16951
R3880 comparator_slice_1.comparator_body_0.outx.n45 comparator_slice_1.comparator_body_0.outx 1.90375
R3881 comparator_slice_1.comparator_body_0.outx.n34 comparator_slice_1.comparator_body_0.outx 1.90375
R3882 comparator_slice_1.comparator_body_0.outx.n44 comparator_slice_1.comparator_body_0.outx 1.90375
R3883 comparator_slice_1.comparator_body_0.outx.n43 comparator_slice_1.comparator_body_0.outx 1.90375
R3884 comparator_slice_1.comparator_body_0.outx.n59 comparator_slice_1.comparator_body_0.outx 1.89026
R3885 comparator_slice_1.comparator_body_0.outx.n62 comparator_slice_1.comparator_body_0.outx 1.89026
R3886 comparator_slice_1.comparator_body_0.outx.n54 comparator_slice_1.comparator_body_0.outx 1.89026
R3887 comparator_slice_1.comparator_body_0.outx.n55 comparator_slice_1.comparator_body_0.outx 1.89026
R3888 comparator_slice_1.comparator_body_0.outx.n36 comparator_slice_1.comparator_body_0.outx.n43 1.84762
R3889 comparator_slice_1.comparator_body_0.outx.n30 comparator_slice_1.comparator_body_0.outx.n45 1.84762
R3890 comparator_slice_1.comparator_body_0.outx.n49 comparator_slice_1.comparator_body_0.outx 1.70793
R3891 comparator_slice_1.comparator_body_0.outx.n38 comparator_slice_1.comparator_body_0.outx 1.66175
R3892 comparator_slice_1.comparator_body_0.outx.n37 comparator_slice_1.comparator_body_0.outx 1.66175
R3893 comparator_slice_1.comparator_body_0.outx.n39 comparator_slice_1.comparator_body_0.outx 1.66175
R3894 comparator_slice_1.comparator_body_0.outx.n48 comparator_slice_1.comparator_body_0.outx 1.66175
R3895 comparator_slice_1.comparator_body_0.outx.n14 comparator_slice_1.comparator_body_0.outx 1.65953
R3896 comparator_slice_1.comparator_body_0.outx.n60 comparator_slice_1.comparator_body_0.outx 1.65002
R3897 comparator_slice_1.comparator_body_0.outx.n45 comparator_slice_1.comparator_body_0.outx 1.65002
R3898 comparator_slice_1.comparator_body_0.outx.n56 comparator_slice_1.comparator_body_0.outx 1.65002
R3899 comparator_slice_1.comparator_body_0.outx.n34 comparator_slice_1.comparator_body_0.outx 1.65002
R3900 comparator_slice_1.comparator_body_0.outx.n58 comparator_slice_1.comparator_body_0.outx 1.65002
R3901 comparator_slice_1.comparator_body_0.outx.n44 comparator_slice_1.comparator_body_0.outx 1.65002
R3902 comparator_slice_1.comparator_body_0.outx.n63 comparator_slice_1.comparator_body_0.outx 1.65002
R3903 comparator_slice_1.comparator_body_0.outx.n43 comparator_slice_1.comparator_body_0.outx 1.65002
R3904 comparator_slice_1.comparator_body_0.outx.n27 comparator_slice_1.comparator_body_0.outx 1.62872
R3905 comparator_slice_1.comparator_body_0.outx.n16 comparator_slice_1.comparator_body_0.outx 1.62872
R3906 comparator_slice_1.comparator_body_0.outx.n42 comparator_slice_1.comparator_body_0.outx 1.51873
R3907 comparator_slice_1.comparator_body_0.outx.n41 comparator_slice_1.comparator_body_0.outx 1.51873
R3908 comparator_slice_1.comparator_body_0.outx.n57 comparator_slice_1.comparator_body_0.outx 1.51839
R3909 comparator_slice_1.comparator_body_0.outx.n1 comparator_slice_1.comparator_body_0.outx 1.51785
R3910 comparator_slice_1.comparator_body_0.outx.n26 comparator_slice_1.comparator_body_0.outx 1.51785
R3911 comparator_slice_1.comparator_body_0.outx.n23 comparator_slice_1.comparator_body_0.outx 1.51785
R3912 comparator_slice_1.comparator_body_0.outx.n13 comparator_slice_1.comparator_body_0.outx 1.51785
R3913 comparator_slice_1.comparator_body_0.outx.n9 comparator_slice_1.comparator_body_0.outx 1.51785
R3914 comparator_slice_1.comparator_body_0.outx.n52 comparator_slice_1.comparator_body_0.outx 1.51785
R3915 comparator_slice_1.comparator_body_0.outx.n16 comparator_slice_1.comparator_body_0.outx 1.51785
R3916 comparator_slice_1.comparator_body_0.outx.n21 comparator_slice_1.comparator_body_0.outx 1.51785
R3917 comparator_slice_1.comparator_body_0.outx.n16 comparator_slice_1.comparator_body_0.outx 1.51785
R3918 comparator_slice_1.comparator_body_0.outx.n4 comparator_slice_1.comparator_body_0.outx 1.51785
R3919 comparator_slice_1.comparator_body_0.outx.n11 comparator_slice_1.comparator_body_0.outx 1.51785
R3920 comparator_slice_1.comparator_body_0.outx.n19 comparator_slice_1.comparator_body_0.outx 1.51274
R3921 comparator_slice_1.comparator_body_0.outx.n50 comparator_slice_1.comparator_body_0.outx 1.51274
R3922 comparator_slice_1.comparator_body_0.outx.n7 comparator_slice_1.comparator_body_0.outx 1.51274
R3923 comparator_slice_1.comparator_body_0.outx.n35 comparator_slice_1.comparator_body_0.outx 1.51274
R3924 comparator_slice_1.comparator_body_0.outx.n51 comparator_slice_1.comparator_body_0.outx 1.5038
R3925 comparator_slice_1.comparator_body_0.outx comparator_slice_1.comparator_body_0.outx.n4 1.5038
R3926 comparator_slice_1.comparator_body_0.outx.n26 comparator_slice_1.comparator_body_0.outx 1.50288
R3927 comparator_slice_1.comparator_body_0.outx.n19 comparator_slice_1.comparator_body_0.outx 1.50288
R3928 comparator_slice_1.comparator_body_0.outx.n1 comparator_slice_1.comparator_body_0.outx 1.50288
R3929 comparator_slice_1.comparator_body_0.outx.n0 comparator_slice_1.comparator_body_0.outx 1.50288
R3930 comparator_slice_1.comparator_body_0.outx.n3 comparator_slice_1.comparator_body_0.outx 1.50288
R3931 comparator_slice_1.comparator_body_0.outx.n21 comparator_slice_1.comparator_body_0.outx 1.50288
R3932 comparator_slice_1.comparator_body_0.outx.n8 comparator_slice_1.comparator_body_0.outx 1.50288
R3933 comparator_slice_1.comparator_body_0.outx.n53 comparator_slice_1.comparator_body_0.outx 1.50288
R3934 comparator_slice_1.comparator_body_0.outx.n28 comparator_slice_1.comparator_body_0.outx 1.50288
R3935 comparator_slice_1.comparator_body_0.outx.n16 comparator_slice_1.comparator_body_0.outx 1.50288
R3936 comparator_slice_1.comparator_body_0.outx.n9 comparator_slice_1.comparator_body_0.outx 1.50288
R3937 comparator_slice_1.comparator_body_0.outx.n23 comparator_slice_1.comparator_body_0.outx 1.50288
R3938 comparator_slice_1.comparator_body_0.outx.n48 comparator_slice_1.comparator_body_0.outx.n55 1.49914
R3939 comparator_slice_1.comparator_body_0.outx.n39 comparator_slice_1.comparator_body_0.outx.n54 1.49914
R3940 comparator_slice_1.comparator_body_0.outx.n37 comparator_slice_1.comparator_body_0.outx.n62 1.49914
R3941 comparator_slice_1.comparator_body_0.outx.n38 comparator_slice_1.comparator_body_0.outx.n59 1.49914
R3942 comparator_slice_1.comparator_body_0.outx.n61 comparator_slice_1.comparator_body_0.outx.n19 1.3997
R3943 comparator_slice_1.comparator_body_0.outx.n25 comparator_slice_1.comparator_body_0.outx.n49 0.302271
R3944 comparator_slice_1.comparator_body_0.outx.n13 comparator_slice_1.comparator_body_0.outx.n24 0.516071
R3945 comparator_slice_1.comparator_body_0.outx.n20 comparator_slice_1.comparator_body_0.outx.n3 1.3557
R3946 comparator_slice_1.comparator_body_0.outx.n53 comparator_slice_1.comparator_body_0.outx.n17 1.27352
R3947 comparator_slice_1.comparator_body_0.outx.n52 comparator_slice_1.comparator_body_0.outx.n14 1.3557
R3948 comparator_slice_1.comparator_body_0.outx.n53 comparator_slice_1.comparator_body_0.outx.n57 1.34908
R3949 comparator_slice_1.comparator_body_0.outx.n4 comparator_slice_1.comparator_body_0.outx.n9 1.27782
R3950 comparator_slice_1.comparator_body_0.outx.n4 comparator_slice_1.comparator_body_0.outx.n1 1.26902
R3951 comparator_slice_1.comparator_body_0.outx.n53 comparator_slice_1.comparator_body_0.outx.n9 1.25714
R3952 comparator_slice_1.comparator_body_0.outx.n40 comparator_slice_1.comparator_body_0.outx.n50 1.17266
R3953 comparator_slice_1.comparator_body_0.outx.n51 comparator_slice_1.comparator_body_0.outx.n31 0.309284
R3954 comparator_slice_1.comparator_body_0.outx.n18 comparator_slice_1.comparator_body_0.outx.n30 1.04418
R3955 comparator_slice_1.comparator_body_0.outx.n25 comparator_slice_1.comparator_body_0.outx.n11 0.516071
R3956 comparator_slice_1.comparator_body_0.outx.n10 comparator_slice_1.comparator_body_0.outx.n23 0.455582
R3957 comparator_slice_1.comparator_body_0.outx.n21 comparator_slice_1.comparator_body_0.outx.n12 0.455582
R3958 comparator_slice_1.comparator_body_0.outx.n17 comparator_slice_1.comparator_body_0.outx.n28 0.288387
R3959 comparator_slice_1.comparator_body_0.outx.n26 comparator_slice_1.comparator_body_0.outx.n31 1.23233
R3960 comparator_slice_1.comparator_body_0.outx.n33 comparator_slice_1.comparator_body_0.outx.n52 0.855671
R3961 comparator_slice_1.comparator_body_0.outx.n32 comparator_slice_1.comparator_body_0.outx.n28 0.95002
R3962 comparator_slice_1.comparator_body_0.outx.n22 comparator_slice_1.comparator_body_0.outx.n21 0.288971
R3963 comparator_slice_1.comparator_body_0.outx.n24 comparator_slice_1.comparator_body_0.outx.n23 0.288971
R3964 comparator_slice_1.comparator_body_0.outx.n18 comparator_slice_1.comparator_body_0.outx.n31 0.867103
R3965 comparator_slice_1.comparator_body_0.outx.n19 comparator_slice_1.comparator_body_0.outx.n18 0.92362
R3966 comparator_slice_1.comparator_body_0.outx.n11 comparator_slice_1.comparator_body_0.outx.n10 0.362654
R3967 comparator_slice_1.comparator_body_0.outx.n13 comparator_slice_1.comparator_body_0.outx.n12 0.362654
R3968 comparator_slice_1.comparator_body_0.outx.n14 comparator_slice_1.comparator_body_0.outx.n35 1.06596
R3969 comparator_slice_1.comparator_body_0.outx.n50 comparator_slice_1.comparator_body_0.outx.n27 0.92626
R3970 comparator_slice_1.comparator_body_0.outx.n35 comparator_slice_1.comparator_body_0.outx.n48 0.923681
R3971 comparator_slice_1.comparator_body_0.outx.n16 comparator_slice_1.comparator_body_0.outx.n15 0.88138
R3972 comparator_slice_1.comparator_body_0.outx.n61 comparator_slice_1.comparator_body_0.outx.n49 0.876585
R3973 comparator_slice_1.comparator_body_0.outx.n37 comparator_slice_1.comparator_body_0.outx.n36 0.360581
R3974 comparator_slice_1.comparator_body_0.outx.n44 comparator_slice_1.comparator_body_0.outx.n7 2.09492
R3975 comparator_slice_1.comparator_body_0.outx.n15 comparator_slice_1.comparator_body_0.outx.n34 2.05435
R3976 comparator_slice_1.comparator_body_0.outx.n45 comparator_slice_1.comparator_body_0.outx.n60 2.0069
R3977 comparator_slice_1.comparator_body_0.outx.n34 comparator_slice_1.comparator_body_0.outx.n56 2.0069
R3978 comparator_slice_1.comparator_body_0.outx.n44 comparator_slice_1.comparator_body_0.outx.n58 2.0069
R3979 comparator_slice_1.comparator_body_0.outx.n43 comparator_slice_1.comparator_body_0.outx.n63 2.0069
R3980 comparator_slice_1.comparator_body_0.outx.n1 comparator_slice_1.comparator_body_0.outx.n0 1.70462
R3981 comparator_slice_1.comparator_body_0.outx.n4 comparator_slice_1.comparator_body_0.outx.n3 1.69494
R3982 comparator_slice_1.comparator_body_0.outx.n2 comparator_slice_1.comparator_body_0.outx.n1 0.405463
R3983 comparator_slice_1.comparator_body_0.outx.n4 comparator_slice_1.comparator_body_0.outx.n5 0.473975
R3984 comparator_slice_1.comparator_body_0.outx.n20 comparator_slice_1.comparator_body_0.outx.n9 1.4217
R3985 comparator_slice_1.comparator_body_0.outx.n7 comparator_slice_1.comparator_body_0.outx.n6 1.36966
R3986 comparator_slice_1.comparator_body_0.outx.n16 comparator_slice_1.comparator_body_0.outx.n17 0.283535
R3987 comparator_slice_1.comparator_body_0.outx.n2 comparator_slice_1.comparator_body_0.outx.n51 1.85372
R3988 comparator_slice_1.comparator_body_0.outx.n27 comparator_slice_1.comparator_body_0.outx.n10 0.310753
R3989 comparator_slice_1.comparator_body_0.outx.n12 comparator_slice_1.comparator_body_0.outx.n8 0.310753
R3990 comparator_slice_1.comparator_body_0.outx.n22 comparator_slice_1.comparator_body_0.outx.n16 1.15084
R3991 comparator_slice_1.comparator_body_0.outx.n3 comparator_slice_1.comparator_body_0.outx.n13 1.10574
R3992 comparator_slice_1.comparator_body_0.outx.n0 comparator_slice_1.comparator_body_0.outx.n11 1.10574
R3993 comparator_slice_1.comparator_body_0.outx.n38 comparator_slice_1.comparator_body_0.outx.n29 0.31442
R3994 comparator_slice_1.comparator_body_0.outx.n21 comparator_slice_1.comparator_body_0.outx.n32 1.0829
R3995 comparator_slice_1.comparator_body_0.outx.n5 comparator_slice_1.comparator_body_0.outx.n23 0.251424
R3996 comparator_slice_1.comparator_body_0.outx.n26 comparator_slice_1.comparator_body_0.outx.n2 0.37494
R3997 comparator_slice_1.comparator_body_0.outx.n33 comparator_slice_1.comparator_body_0.outx.n57 0.998407
R3998 comparator_slice_1.comparator_body_0.outx.n19 comparator_slice_1.comparator_body_0.outx.n26 1.08202
R3999 comparator_slice_1.comparator_body_0.outx.n29 comparator_slice_1.comparator_body_0.outx.n19 1.04725
R4000 comparator_slice_1.comparator_body_0.outx.n50 comparator_slice_1.comparator_body_0.outx.n37 1.04587
R4001 comparator_slice_1.comparator_body_0.outx.n7 comparator_slice_1.comparator_body_0.outx.n8 1.02482
R4002 comparator_slice_1.comparator_body_0.outx.n7 comparator_slice_1.comparator_body_0.outx.n39 1.00722
R4003 comparator_slice_1.comparator_body_0.outx.n6 comparator_slice_1.comparator_body_0.outx.n42 0.97906
R4004 comparator_slice_1.comparator_body_0.outx.n41 comparator_slice_1.comparator_body_0.outx.n40 0.97906
R4005 comparator_slice_1.comparator_body_0.outx.n15 comparator_slice_1.comparator_body_0.outx.n35 0.899971
R4006 comparator_slice_1.comparator_body_0.outx.n33 comparator_slice_1.comparator_body_0.outx.n16 0.899838
R4007 comparator_slice_1.comparator_body_0.outx.n47 comparator_slice_1.comparator_body_0.outx.n46 0.854615
R4008 comparator_slice_1.comparator_body_0.outx.n30 comparator_slice_1.comparator_body_0.outx.n29 0.302254
R4009 comparator_slice_1.comparator_body_0.outx.n32 comparator_slice_1.comparator_body_0.outx.n9 0.7595
R4010 comparator_slice_1.comparator_body_0.outx.n16 comparator_slice_1.comparator_body_0.outx.n14 0.75818
R4011 comparator_slice_1.comparator_body_0.outx.n42 comparator_slice_1.comparator_body_0.outx.n22 0.302271
R4012 comparator_slice_1.comparator_body_0.outx.n41 comparator_slice_1.comparator_body_0.outx.n24 0.302271
R4013 comparator_slice_1.comparator_body_0.outx.n26 comparator_slice_1.comparator_body_0.outx.n25 0.288971
R4014 comparator_slice_1.comparator_body_0.outx.n21 comparator_slice_1.comparator_body_0.outx.n20 0.75554
R4015 comparator_slice_1.comparator_body_0.outx.n5 comparator_slice_1.comparator_body_0.outx.n0 1.68613
R4016 comparator_slice_1.comparator_body_0.m3_m4_diff_0.n1.n44 comparator_slice_1.comparator_body_0.m3_m4_diff_0.m3_m4_array_2/p1_2$1_13.D 10.3502
R4017 comparator_slice_1.comparator_body_0.m3_m4_diff_0.m3_m4_array_2/p1_2$1_9.D comparator_slice_1.comparator_body_0.m3_m4_diff_0.n1.n31 10.3502
R4018 comparator_slice_1.comparator_body_0.m3_m4_diff_0.n1.n20 comparator_slice_1.comparator_body_0.m3_m4_diff_0.n1.n0 10.3502
R4019 comparator_slice_1.comparator_body_0.m3_m4_diff_0.m3_m4_array_0/p1_2$1_13.D comparator_slice_1.comparator_body_0.m3_m4_diff_0.n1.n53 10.3502
R4020 comparator_slice_1.comparator_body_0.m3_m4_diff_0.n1.n45 comparator_slice_1.comparator_body_0.m3_m4_diff_0.n1.n30 10.3502
R4021 comparator_slice_1.comparator_body_0.m3_m4_diff_0.m3_m4_array_1/p1_2$1_13.D comparator_slice_1.comparator_body_0.m3_m4_diff_0.n1.n59 10.3502
R4022 comparator_slice_1.comparator_body_0.m3_m4_diff_0.n1.n33 comparator_slice_1.comparator_body_0.m3_m4_diff_0.n1.n56 8.82038
R4023 comparator_slice_1.comparator_body_0.m3_m4_diff_0.n1.n3 comparator_slice_1.comparator_body_0.m3_m4_diff_0.n1.t22 2.16656
R4024 comparator_slice_1.comparator_body_0.m3_m4_diff_0.n1.n0 comparator_slice_1.comparator_body_0.m3_m4_diff_0.n1.t48 4.98207
R4025 comparator_slice_1.comparator_body_0.m3_m4_diff_0.n1.t20 comparator_slice_1.comparator_body_0.m3_m4_diff_0.n1.n0 4.98207
R4026 comparator_slice_1.comparator_body_0.m3_m4_diff_0.n1.n0 comparator_slice_1.comparator_body_0.m3_m4_diff_0.n1.t60 4.98207
R4027 comparator_slice_1.comparator_body_0.m3_m4_diff_0.n1.n1 comparator_slice_1.comparator_body_0.m3_m4_diff_0.n1.t30 2.39981
R4028 comparator_slice_1.comparator_body_0.m3_m4_diff_0.n1.n0 comparator_slice_1.comparator_body_0.m3_m4_diff_0.n1.t44 4.9771
R4029 comparator_slice_1.comparator_body_0.m3_m4_diff_0.n1.n26 comparator_slice_1.comparator_body_0.m3_m4_diff_0.n1.t54 2.21476
R4030 comparator_slice_1.comparator_body_0.m3_m4_diff_0.n1.n0 comparator_slice_1.comparator_body_0.m3_m4_diff_0.n1.n2 0.887768
R4031 comparator_slice_1.comparator_body_0.m3_m4_diff_0.n1.t46 comparator_slice_1.comparator_body_0.m3_m4_diff_0.n1.n25 4.98207
R4032 comparator_slice_1.comparator_body_0.m3_m4_diff_0.n1.n28 comparator_slice_1.comparator_body_0.m3_m4_diff_0.n1.t56 2.19544
R4033 comparator_slice_1.comparator_body_0.m3_m4_diff_0.n1.t26 comparator_slice_1.comparator_body_0.m3_m4_diff_0.n1.n30 4.98207
R4034 comparator_slice_1.comparator_body_0.m3_m4_diff_0.n1.n30 comparator_slice_1.comparator_body_0.m3_m4_diff_0.n1.n29 0.574529
R4035 comparator_slice_1.comparator_body_0.m3_m4_diff_0.n1.n17 comparator_slice_1.comparator_body_0.m3_m4_diff_0.n1.n25 0.264696
R4036 comparator_slice_1.comparator_body_0.m3_m4_diff_0.n1.t24 comparator_slice_1.comparator_body_0.m3_m4_diff_0.n1.n25 4.9771
R4037 comparator_slice_1.comparator_body_0.m3_m4_diff_0.n1.t0 comparator_slice_1.comparator_body_0.m3_m4_diff_0.n1.n32 2.19519
R4038 comparator_slice_1.comparator_body_0.m3_m4_diff_0.n1.n30 comparator_slice_1.comparator_body_0.m3_m4_diff_0.n1.t32 4.9771
R4039 comparator_slice_1.comparator_body_0.m3_m4_diff_0.n1.n36 comparator_slice_1.comparator_body_0.m3_m4_diff_0.n1.t28 4.98207
R4040 comparator_slice_1.comparator_body_0.m3_m4_diff_0.n1.n23 comparator_slice_1.comparator_body_0.m3_m4_diff_0.n1.t50 2.19544
R4041 comparator_slice_1.comparator_body_0.m3_m4_diff_0.n1.n36 comparator_slice_1.comparator_body_0.m3_m4_diff_0.n1.t40 4.98207
R4042 comparator_slice_1.comparator_body_0.m3_m4_diff_0.n1.n36 comparator_slice_1.comparator_body_0.m3_m4_diff_0.n1.n22 0.264696
R4043 comparator_slice_1.comparator_body_0.m3_m4_diff_0.n1.n36 comparator_slice_1.comparator_body_0.m3_m4_diff_0.n1.t12 4.9771
R4044 comparator_slice_1.comparator_body_0.m3_m4_diff_0.n1.n21 comparator_slice_1.comparator_body_0.m3_m4_diff_0.n1.t10 2.53633
R4045 comparator_slice_1.comparator_body_0.m3_m4_diff_0.n1.n36 comparator_slice_1.comparator_body_0.m3_m4_diff_0.n1.t6 4.9771
R4046 comparator_slice_1.comparator_body_0.m3_m4_diff_0.m3_m4_array_2/p1_2$1_14.D comparator_slice_1.comparator_body_0.m3_m4_diff_0.n1.n23 0.569877
R4047 comparator_slice_1.comparator_body_0.m3_m4_diff_0.m3_m4_array_3/p1_2$1_14.D comparator_slice_1.comparator_body_0.m3_m4_diff_0.n1.t14 4.93952
R4048 comparator_slice_1.comparator_body_0.m3_m4_diff_0.n1.n28 comparator_slice_1.comparator_body_0.m3_m4_diff_0.m3_m4_array_1/p1_2$1_14.D 0.569877
R4049 comparator_slice_1.comparator_body_0.m3_m4_diff_0.n1.t48 comparator_slice_1.comparator_body_0.m3_m4_diff_0.m3_m4_array_0/p1_2$1_14.D 4.93952
R4050 comparator_slice_1.comparator_body_0.m3_m4_diff_0.n1.n42 comparator_slice_1.comparator_body_0.m3_m4_diff_0.n1.n49 5.17146
R4051 comparator_slice_1.comparator_body_0.m3_m4_diff_0.n1.t36 comparator_slice_1.comparator_body_0.m3_m4_diff_0.n1.n43 2.21646
R4052 comparator_slice_1.comparator_body_0.m3_m4_diff_0.n1.n10 comparator_slice_1.comparator_body_0.m3_m4_diff_0.n1.t34 2.18191
R4053 comparator_slice_1.comparator_body_0.m3_m4_diff_0.n1.n34 comparator_slice_1.comparator_body_0.m3_m4_diff_0.n1.t2 4.96805
R4054 comparator_slice_1.comparator_body_0.m3_m4_diff_0.n1.n46 comparator_slice_1.comparator_body_0.m3_m4_diff_0.n1.t16 4.96805
R4055 comparator_slice_1.comparator_body_0.m3_m4_diff_0.n1.n35 comparator_slice_1.comparator_body_0.m3_m4_diff_0.n1.t38 4.96805
R4056 comparator_slice_1.comparator_body_0.m3_m4_diff_0.n1.t14 comparator_slice_1.comparator_body_0.m3_m4_diff_0.n1.n35 4.96805
R4057 comparator_slice_1.comparator_body_0.m3_m4_diff_0.n1.n47 comparator_slice_1.comparator_body_0.m3_m4_diff_0.n1.t62 4.96805
R4058 comparator_slice_1.comparator_body_0.m3_m4_diff_0.n1.n42 comparator_slice_1.comparator_body_0.m3_m4_diff_0.n1.t18 4.96805
R4059 comparator_slice_1.comparator_body_0.m3_m4_diff_0.m3_m4_array_3/p1_2$1_13.D comparator_slice_1.comparator_body_0.m3_m4_diff_0.n1.t18 4.9444
R4060 comparator_slice_1.comparator_body_0.m3_m4_diff_0.n1.n19 comparator_slice_1.comparator_body_0.m3_m4_diff_0.n1.t60 4.9444
R4061 comparator_slice_1.comparator_body_0.m3_m4_diff_0.m3_m4_array_2/p1_2$1_13.D comparator_slice_1.comparator_body_0.m3_m4_diff_0.n1.t58 2.30962
R4062 comparator_slice_1.comparator_body_0.m3_m4_diff_0.n1.t42 comparator_slice_1.comparator_body_0.m3_m4_diff_0.n1.n29 2.19666
R4063 comparator_slice_1.comparator_body_0.m3_m4_diff_0.m3_m4_array_2/p1_2$1_4.D comparator_slice_1.comparator_body_0.m3_m4_diff_0.n1.t2 4.94339
R4064 comparator_slice_1.comparator_body_0.m3_m4_diff_0.n1.t4 comparator_slice_1.comparator_body_0.m3_m4_diff_0.n1.n17 2.39981
R4065 comparator_slice_1.comparator_body_0.m3_m4_diff_0.n1.n22 comparator_slice_1.comparator_body_0.m3_m4_diff_0.n1.t52 2.39981
R4066 comparator_slice_1.comparator_body_0.m3_m4_diff_0.m3_m4_array_2/p1_2$1_4.D comparator_slice_1.comparator_body_0.m3_m4_diff_0.n1.t16 4.89895
R4067 comparator_slice_1.comparator_body_0.m3_m4_diff_0.n1.n4 comparator_slice_1.comparator_body_0.m3_m4_diff_0.n1.n10 0.567966
R4068 comparator_slice_1.comparator_body_0.m3_m4_diff_0.n1.t40 comparator_slice_1.comparator_body_0.m3_m4_diff_0.n1.n57 4.89895
R4069 comparator_slice_1.comparator_body_0.m3_m4_diff_0.n1.t44 comparator_slice_1.comparator_body_0.m3_m4_diff_0.n1.n11 4.89895
R4070 comparator_slice_1.comparator_body_0.m3_m4_diff_0.n1.n2 comparator_slice_1.comparator_body_0.m3_m4_diff_0.n1.t8 2.02973
R4071 comparator_slice_1.comparator_body_0.m3_m4_diff_0.n1.t32 comparator_slice_1.comparator_body_0.m3_m4_diff_0.m3_m4_array_0/p1_2$1_4.D 4.89895
R4072 comparator_slice_1.comparator_body_0.m3_m4_diff_0.m3_m4_array_1/p1_2$1_4.D comparator_slice_1.comparator_body_0.m3_m4_diff_0.n1.t6 4.89895
R4073 comparator_slice_1.comparator_body_0.m3_m4_diff_0.n1.t26 comparator_slice_1.comparator_body_0.m3_m4_diff_0.n1.n12 4.89895
R4074 comparator_slice_1.comparator_body_0.m3_m4_diff_0.n1.t62 comparator_slice_1.comparator_body_0.m3_m4_diff_0.n1.n13 4.89895
R4075 comparator_slice_1.comparator_body_0.m3_m4_diff_0.n1.t38 comparator_slice_1.comparator_body_0.m3_m4_diff_0.m3_m4_array_3/p1_2$1_14.D 4.89895
R4076 comparator_slice_1.comparator_body_0.m3_m4_diff_0.n1.n3 comparator_slice_1.comparator_body_0.m3_m4_diff_0.n1.n7 0.60447
R4077 comparator_slice_1.comparator_body_0.m3_m4_diff_0.n1.t46 comparator_slice_1.comparator_body_0.m3_m4_diff_0.m3_m4_array_1/p1_2$1_14.D 4.89895
R4078 comparator_slice_1.comparator_body_0.m3_m4_diff_0.m3_m4_array_2/p1_2$1_14.D comparator_slice_1.comparator_body_0.m3_m4_diff_0.n1.t28 4.89895
R4079 comparator_slice_1.comparator_body_0.m3_m4_diff_0.n1.t12 comparator_slice_1.comparator_body_0.m3_m4_diff_0.n1.n24 4.89895
R4080 comparator_slice_1.comparator_body_0.m3_m4_diff_0.n1.n5 comparator_slice_1.comparator_body_0.m3_m4_diff_0.n1.t24 4.89895
R4081 comparator_slice_1.comparator_body_0.m3_m4_diff_0.n1.t20 comparator_slice_1.comparator_body_0.m3_m4_diff_0.n1.n19 4.89895
R4082 comparator_slice_1.comparator_body_0.m3_m4_diff_0.m3_m4_array_2/p1_2$1_4.D comparator_slice_1.comparator_body_0.m3_m4_diff_0.n1.t3 2.4119
R4083 comparator_slice_1.comparator_body_0.m3_m4_diff_0.m3_m4_array_2/p1_2$1_10.D comparator_slice_1.comparator_body_0.m3_m4_diff_0.n1.t35 2.4119
R4084 comparator_slice_1.comparator_body_0.m3_m4_diff_0.m3_m4_array_2/p1_2$1_9.D comparator_slice_1.comparator_body_0.m3_m4_diff_0.n1.t17 2.4119
R4085 comparator_slice_1.comparator_body_0.m3_m4_diff_0.m3_m4_array_0/p1_2$1_9.D comparator_slice_1.comparator_body_0.m3_m4_diff_0.n1.t33 2.4119
R4086 comparator_slice_1.comparator_body_0.m3_m4_diff_0.m3_m4_array_1/p1_2$1_9.D comparator_slice_1.comparator_body_0.m3_m4_diff_0.n1.t7 2.4119
R4087 comparator_slice_1.comparator_body_0.m3_m4_diff_0.m3_m4_array_1/p1_2$1_4.D comparator_slice_1.comparator_body_0.m3_m4_diff_0.n1.t11 2.4119
R4088 comparator_slice_1.comparator_body_0.m3_m4_diff_0.m3_m4_array_3/p1_2$1_9.D comparator_slice_1.comparator_body_0.m3_m4_diff_0.n1.t9 2.4119
R4089 comparator_slice_1.comparator_body_0.m3_m4_diff_0.m3_m4_array_3/p1_2$1_4.D comparator_slice_1.comparator_body_0.m3_m4_diff_0.n1.t55 2.4119
R4090 comparator_slice_1.comparator_body_0.m3_m4_diff_0.m3_m4_array_3/p1_2$1_10.D comparator_slice_1.comparator_body_0.m3_m4_diff_0.n1.t45 2.4119
R4091 comparator_slice_1.comparator_body_0.m3_m4_diff_0.m3_m4_array_3/p1_2$1_1.D comparator_slice_1.comparator_body_0.m3_m4_diff_0.n1.t31 2.4119
R4092 comparator_slice_1.comparator_body_0.m3_m4_diff_0.m3_m4_array_0/p1_2$1_1.D comparator_slice_1.comparator_body_0.m3_m4_diff_0.n1.t5 2.4119
R4093 comparator_slice_1.comparator_body_0.m3_m4_diff_0.m3_m4_array_1/p1_2$1_1.D comparator_slice_1.comparator_body_0.m3_m4_diff_0.n1.t53 2.4119
R4094 comparator_slice_1.comparator_body_0.m3_m4_diff_0.m3_m4_array_2/p1_2$1_1.D comparator_slice_1.comparator_body_0.m3_m4_diff_0.n1.t37 2.4119
R4095 comparator_slice_1.comparator_body_0.m3_m4_diff_0.m3_m4_array_1/p1_2$1_10.D comparator_slice_1.comparator_body_0.m3_m4_diff_0.n1.t13 2.4119
R4096 comparator_slice_1.comparator_body_0.m3_m4_diff_0.m3_m4_array_0/p1_2$1_10.D comparator_slice_1.comparator_body_0.m3_m4_diff_0.n1.t25 2.4119
R4097 comparator_slice_1.comparator_body_0.m3_m4_diff_0.n1.n49 comparator_slice_1.comparator_body_0.m1_m2_diff_0.m1_m2_array_3/n1_2_11.D 3.74354
R4098 comparator_slice_1.comparator_body_0.m3_m4_diff_0.n1.n37 comparator_slice_1.comparator_body_0.m1_m2_diff_0.m1_m2_array_1/n1_2_14.D 3.40063
R4099 comparator_slice_1.comparator_body_0.m3_m4_diff_0.n1.n38 comparator_slice_1.comparator_body_0.m1_m2_diff_0.m1_m2_array_3/n1_2_14.D 3.40063
R4100 comparator_slice_1.comparator_body_0.m3_m4_diff_0.n1.n39 comparator_slice_1.comparator_body_0.m1_m2_diff_0.m1_m2_array_2/n1_2_14.D 3.40063
R4101 comparator_slice_1.comparator_body_0.m3_m4_diff_0.n1.n40 comparator_slice_1.comparator_body_0.m1_m2_diff_0.m1_m2_array_0/n1_2_14.D 3.40063
R4102 comparator_slice_1.comparator_body_0.m3_m4_diff_0.n1.n50 comparator_slice_1.comparator_body_0.m3_m4_diff_0.n1.n60 2.90186
R4103 comparator_slice_1.comparator_body_0.m1_m2_diff_0.m1_m2_array_1/n1_2_10.D comparator_slice_1.comparator_body_0.m3_m4_diff_0.n1.t70 2.46703
R4104 comparator_slice_1.comparator_body_0.m1_m2_diff_0.m1_m2_array_1/n1_2_7.D comparator_slice_1.comparator_body_0.m3_m4_diff_0.n1.t90 2.46703
R4105 comparator_slice_1.comparator_body_0.m1_m2_diff_0.m1_m2_array_1/n1_2_4.D comparator_slice_1.comparator_body_0.m3_m4_diff_0.n1.t93 2.46703
R4106 comparator_slice_1.comparator_body_0.m1_m2_diff_0.m1_m2_array_3/n1_2_10.D comparator_slice_1.comparator_body_0.m3_m4_diff_0.n1.t91 2.46703
R4107 comparator_slice_1.comparator_body_0.m1_m2_diff_0.m1_m2_array_3/n1_2_7.D comparator_slice_1.comparator_body_0.m3_m4_diff_0.n1.t77 2.46703
R4108 comparator_slice_1.comparator_body_0.m1_m2_diff_0.m1_m2_array_3/n1_2_4.D comparator_slice_1.comparator_body_0.m3_m4_diff_0.n1.t84 2.46703
R4109 comparator_slice_1.comparator_body_0.m1_m2_diff_0.m1_m2_array_2/n1_2_10.D comparator_slice_1.comparator_body_0.m3_m4_diff_0.n1.t95 2.46703
R4110 comparator_slice_1.comparator_body_0.m1_m2_diff_0.m1_m2_array_2/n1_2_11.D comparator_slice_1.comparator_body_0.m3_m4_diff_0.n1.t68 2.46703
R4111 comparator_slice_1.comparator_body_0.m1_m2_diff_0.m1_m2_array_2/n1_2_7.D comparator_slice_1.comparator_body_0.m3_m4_diff_0.n1.t71 2.46703
R4112 comparator_slice_1.comparator_body_0.m1_m2_diff_0.m1_m2_array_2/n1_2_4.D comparator_slice_1.comparator_body_0.m3_m4_diff_0.n1.t81 2.46703
R4113 comparator_slice_1.comparator_body_0.m1_m2_diff_0.m1_m2_array_0/n1_2_10.D comparator_slice_1.comparator_body_0.m3_m4_diff_0.n1.t89 2.46703
R4114 comparator_slice_1.comparator_body_0.m1_m2_diff_0.m1_m2_array_0/n1_2_11.D comparator_slice_1.comparator_body_0.m3_m4_diff_0.n1.t72 2.46703
R4115 comparator_slice_1.comparator_body_0.m1_m2_diff_0.m1_m2_array_0/n1_2_7.D comparator_slice_1.comparator_body_0.m3_m4_diff_0.n1.t67 2.46703
R4116 comparator_slice_1.comparator_body_0.m1_m2_diff_0.m1_m2_array_0/n1_2_4.D comparator_slice_1.comparator_body_0.m3_m4_diff_0.n1.t86 2.46703
R4117 comparator_slice_1.comparator_body_0.m1_m2_diff_0.m1_m2_array_1/n1_2_11.D comparator_slice_1.comparator_body_0.m3_m4_diff_0.n1.t78 2.46703
R4118 comparator_slice_1.comparator_body_0.m1_m2_diff_0.m1_m2_array_3/n1_2_11.D comparator_slice_1.comparator_body_0.m3_m4_diff_0.n1.t79 2.46703
R4119 comparator_slice_1.comparator_body_0.m1_m2_diff_0.m1_m2_array_1/n1_2_1.D comparator_slice_1.comparator_body_0.m3_m4_diff_0.n1.t66 2.45485
R4120 comparator_slice_1.comparator_body_0.m1_m2_diff_0.m1_m2_array_1/n1_2_2.D comparator_slice_1.comparator_body_0.m3_m4_diff_0.n1.t85 2.45485
R4121 comparator_slice_1.comparator_body_0.m1_m2_diff_0.m1_m2_array_3/n1_2_1.D comparator_slice_1.comparator_body_0.m3_m4_diff_0.n1.t76 2.45485
R4122 comparator_slice_1.comparator_body_0.m1_m2_diff_0.m1_m2_array_3/n1_2_2.D comparator_slice_1.comparator_body_0.m3_m4_diff_0.n1.t75 2.45485
R4123 comparator_slice_1.comparator_body_0.m1_m2_diff_0.m1_m2_array_3/n1_2_13.D comparator_slice_1.comparator_body_0.m3_m4_diff_0.n1.t69 2.45485
R4124 comparator_slice_1.comparator_body_0.m1_m2_diff_0.m1_m2_array_2/n1_2_1.D comparator_slice_1.comparator_body_0.m3_m4_diff_0.n1.t73 2.45485
R4125 comparator_slice_1.comparator_body_0.m1_m2_diff_0.m1_m2_array_2/n1_2_2.D comparator_slice_1.comparator_body_0.m3_m4_diff_0.n1.t94 2.45485
R4126 comparator_slice_1.comparator_body_0.m1_m2_diff_0.m1_m2_array_2/n1_2_13.D comparator_slice_1.comparator_body_0.m3_m4_diff_0.n1.t74 2.45485
R4127 comparator_slice_1.comparator_body_0.m1_m2_diff_0.m1_m2_array_0/n1_2_1.D comparator_slice_1.comparator_body_0.m3_m4_diff_0.n1.t88 2.45485
R4128 comparator_slice_1.comparator_body_0.m1_m2_diff_0.m1_m2_array_0/n1_2_2.D comparator_slice_1.comparator_body_0.m3_m4_diff_0.n1.t80 2.45485
R4129 comparator_slice_1.comparator_body_0.m1_m2_diff_0.m1_m2_array_0/n1_2_13.D comparator_slice_1.comparator_body_0.m3_m4_diff_0.n1.t92 2.45485
R4130 comparator_slice_1.comparator_body_0.m1_m2_diff_0.m1_m2_array_1/n1_2_13.D comparator_slice_1.comparator_body_0.m3_m4_diff_0.n1.t64 2.45485
R4131 comparator_slice_1.comparator_body_0.m1_m2_diff_0.m1_m2_array_0/n1_2_14.D comparator_slice_1.comparator_body_0.m3_m4_diff_0.n1.t82 2.45485
R4132 comparator_slice_1.comparator_body_0.m1_m2_diff_0.m1_m2_array_2/n1_2_14.D comparator_slice_1.comparator_body_0.m3_m4_diff_0.n1.t65 2.45485
R4133 comparator_slice_1.comparator_body_0.m1_m2_diff_0.m1_m2_array_3/n1_2_14.D comparator_slice_1.comparator_body_0.m3_m4_diff_0.n1.t83 2.45485
R4134 comparator_slice_1.comparator_body_0.m1_m2_diff_0.m1_m2_array_1/n1_2_14.D comparator_slice_1.comparator_body_0.m3_m4_diff_0.n1.t87 2.45485
R4135 comparator_slice_1.comparator_body_0.m3_m4_diff_0.m3_m4_array_0/p1_2$1_4.D comparator_slice_1.comparator_body_0.m3_m4_diff_0.n1.t1 2.42165
R4136 comparator_slice_1.comparator_body_0.m3_m4_diff_0.m3_m4_array_2/p1_2$1_13.D comparator_slice_1.comparator_body_0.m3_m4_diff_0.n1.t59 2.40997
R4137 comparator_slice_1.comparator_body_0.m3_m4_diff_0.m3_m4_array_3/p1_2$1_13.D comparator_slice_1.comparator_body_0.m3_m4_diff_0.n1.t19 2.40997
R4138 comparator_slice_1.comparator_body_0.m3_m4_diff_0.m3_m4_array_0/p1_2$1_13.D comparator_slice_1.comparator_body_0.m3_m4_diff_0.n1.t61 2.40997
R4139 comparator_slice_1.comparator_body_0.m3_m4_diff_0.m3_m4_array_1/p1_2$1_13.D comparator_slice_1.comparator_body_0.m3_m4_diff_0.n1.t43 2.40997
R4140 comparator_slice_1.comparator_body_0.m3_m4_diff_0.m3_m4_array_2/p1_2$1_7.D comparator_slice_1.comparator_body_0.m3_m4_diff_0.n1.t41 2.40957
R4141 comparator_slice_1.comparator_body_0.m3_m4_diff_0.m3_m4_array_3/p1_2$1_7.D comparator_slice_1.comparator_body_0.m3_m4_diff_0.n1.t63 2.40957
R4142 comparator_slice_1.comparator_body_0.m3_m4_diff_0.m3_m4_array_1/p1_2$1_7.D comparator_slice_1.comparator_body_0.m3_m4_diff_0.n1.t27 2.40957
R4143 comparator_slice_1.comparator_body_0.m3_m4_diff_0.m3_m4_array_3/p1_2$1_0.D comparator_slice_1.comparator_body_0.m3_m4_diff_0.n1.t39 2.40957
R4144 comparator_slice_1.comparator_body_0.m3_m4_diff_0.m3_m4_array_0/p1_2$1_0.D comparator_slice_1.comparator_body_0.m3_m4_diff_0.n1.t23 2.40957
R4145 comparator_slice_1.comparator_body_0.m3_m4_diff_0.m3_m4_array_1/p1_2$1_0.D comparator_slice_1.comparator_body_0.m3_m4_diff_0.n1.t47 2.40957
R4146 comparator_slice_1.comparator_body_0.m3_m4_diff_0.m3_m4_array_2/p1_2$1_0.D comparator_slice_1.comparator_body_0.m3_m4_diff_0.n1.t29 2.40957
R4147 comparator_slice_1.comparator_body_0.m3_m4_diff_0.m3_m4_array_0/p1_2$1_7.D comparator_slice_1.comparator_body_0.m3_m4_diff_0.n1.t21 2.40957
R4148 comparator_slice_1.comparator_body_0.m3_m4_diff_0.m3_m4_array_2/p1_2$1_14.D comparator_slice_1.comparator_body_0.m3_m4_diff_0.n1.t51 2.40519
R4149 comparator_slice_1.comparator_body_0.m3_m4_diff_0.m3_m4_array_3/p1_2$1_14.D comparator_slice_1.comparator_body_0.m3_m4_diff_0.n1.t15 2.40519
R4150 comparator_slice_1.comparator_body_0.m3_m4_diff_0.m3_m4_array_1/p1_2$1_14.D comparator_slice_1.comparator_body_0.m3_m4_diff_0.n1.t57 2.40519
R4151 comparator_slice_1.comparator_body_0.m3_m4_diff_0.m3_m4_array_0/p1_2$1_14.D comparator_slice_1.comparator_body_0.m3_m4_diff_0.n1.t49 2.40519
R4152 comparator_slice_1.comparator_body_0.m3_m4_diff_0.n1.n56 comparator_slice_1.comparator_body_0.m3_m4_diff_0.n1.n55 2.23218
R4153 comparator_slice_1.comparator_body_0.m3_m4_diff_0.n1.n59 comparator_slice_1.comparator_body_0.m1_m2_diff_0.m1_m2_array_0/n1_2_11.D 2.1525
R4154 comparator_slice_1.comparator_body_0.m3_m4_diff_0.m3_m4_array_0/p1_2$1_4.D comparator_slice_1.comparator_body_0.m3_m4_diff_0.n1.n30 2.14163
R4155 comparator_slice_1.comparator_body_0.m3_m4_diff_0.n1.n2 comparator_slice_1.comparator_body_0.m3_m4_diff_0.m3_m4_array_3/p1_2$1_4.D 0.873842
R4156 comparator_slice_1.comparator_body_0.m3_m4_diff_0.n1.n31 comparator_slice_1.comparator_body_0.m1_m2_diff_0.m1_m2_array_1/n1_2_11.D 2.10674
R4157 comparator_slice_1.comparator_body_0.m3_m4_diff_0.n1.n58 comparator_slice_1.comparator_body_0.m3_m4_diff_0.n1.n41 2.0949
R4158 comparator_slice_1.comparator_body_0.m3_m4_diff_0.n1.n14 comparator_slice_1.comparator_body_0.m3_m4_diff_0.n1.n13 0.593316
R4159 comparator_slice_1.comparator_body_0.m3_m4_diff_0.m3_m4_array_0/p1_2$1_4.D comparator_slice_1.comparator_body_0.m3_m4_diff_0.n1.n5 2.06956
R4160 comparator_slice_1.comparator_body_0.m3_m4_diff_0.n1.n21 comparator_slice_1.comparator_body_0.m3_m4_diff_0.m3_m4_array_1/p1_2$1_4.D 2.06507
R4161 comparator_slice_1.comparator_body_0.m3_m4_diff_0.n1.n4 comparator_slice_1.comparator_body_0.m3_m4_diff_0.m3_m4_array_2/p1_2$1_4.D 2.05082
R4162 comparator_slice_1.comparator_body_0.m3_m4_diff_0.n1.n52 comparator_slice_1.comparator_body_0.m3_m4_diff_0.n1.n40 2.04298
R4163 comparator_slice_1.comparator_body_0.m3_m4_diff_0.n1.n51 comparator_slice_1.comparator_body_0.m3_m4_diff_0.n1.n39 2.04298
R4164 comparator_slice_1.comparator_body_0.m3_m4_diff_0.n1.n50 comparator_slice_1.comparator_body_0.m3_m4_diff_0.n1.n38 2.04298
R4165 comparator_slice_1.comparator_body_0.m3_m4_diff_0.n1.n48 comparator_slice_1.comparator_body_0.m3_m4_diff_0.n1.n37 2.04298
R4166 comparator_slice_1.comparator_body_0.m3_m4_diff_0.n1.n60 comparator_slice_1.comparator_body_0.m1_m2_diff_0.n1 2.02362
R4167 comparator_slice_1.comparator_body_0.m3_m4_diff_0.n1.n20 comparator_slice_1.comparator_body_0.m3_m4_diff_0.n1.n53 2.0025
R4168 comparator_slice_1.comparator_body_0.m3_m4_diff_0.n1.n7 comparator_slice_1.comparator_body_0.m3_m4_diff_0.n1.n16 2.00061
R4169 comparator_slice_1.comparator_body_0.m1_m2_diff_0.n1 comparator_slice_1.comparator_body_0.m3_m4_diff_0.n1.n54 1.9761
R4170 comparator_slice_1.comparator_body_0.m3_m4_diff_0.n1.n52 comparator_slice_1.comparator_body_0.m1_m2_diff_0.n1 1.93914
R4171 comparator_slice_1.comparator_body_0.m3_m4_diff_0.n1.n40 comparator_slice_1.comparator_body_0.m1_m2_diff_0.m1_m2_array_0/n1_2_1.D 1.90199
R4172 comparator_slice_1.comparator_body_0.m3_m4_diff_0.n1.n39 comparator_slice_1.comparator_body_0.m1_m2_diff_0.m1_m2_array_2/n1_2_1.D 1.90199
R4173 comparator_slice_1.comparator_body_0.m3_m4_diff_0.n1.n38 comparator_slice_1.comparator_body_0.m1_m2_diff_0.m1_m2_array_3/n1_2_1.D 1.90199
R4174 comparator_slice_1.comparator_body_0.m3_m4_diff_0.n1.n37 comparator_slice_1.comparator_body_0.m1_m2_diff_0.m1_m2_array_1/n1_2_1.D 1.90199
R4175 comparator_slice_1.comparator_body_0.m1_m2_diff_0.n1 comparator_slice_1.comparator_body_0.m3_m4_diff_0.n1.n51 1.89866
R4176 comparator_slice_1.comparator_body_0.m3_m4_diff_0.n1.n40 comparator_slice_1.comparator_body_0.m1_m2_diff_0.m1_m2_array_0/n1_2_4.D 1.8885
R4177 comparator_slice_1.comparator_body_0.m3_m4_diff_0.n1.n52 comparator_slice_1.comparator_body_0.m1_m2_diff_0.m1_m2_array_0/n1_2_7.D 1.8885
R4178 comparator_slice_1.comparator_body_0.m3_m4_diff_0.n1.n39 comparator_slice_1.comparator_body_0.m1_m2_diff_0.m1_m2_array_2/n1_2_4.D 1.8885
R4179 comparator_slice_1.comparator_body_0.m3_m4_diff_0.n1.n51 comparator_slice_1.comparator_body_0.m1_m2_diff_0.m1_m2_array_2/n1_2_7.D 1.8885
R4180 comparator_slice_1.comparator_body_0.m3_m4_diff_0.n1.n38 comparator_slice_1.comparator_body_0.m1_m2_diff_0.m1_m2_array_3/n1_2_4.D 1.8885
R4181 comparator_slice_1.comparator_body_0.m3_m4_diff_0.n1.n50 comparator_slice_1.comparator_body_0.m1_m2_diff_0.m1_m2_array_3/n1_2_7.D 1.8885
R4182 comparator_slice_1.comparator_body_0.m3_m4_diff_0.n1.n37 comparator_slice_1.comparator_body_0.m1_m2_diff_0.m1_m2_array_1/n1_2_4.D 1.8885
R4183 comparator_slice_1.comparator_body_0.m3_m4_diff_0.n1.n48 comparator_slice_1.comparator_body_0.m1_m2_diff_0.m1_m2_array_1/n1_2_7.D 1.8885
R4184 comparator_slice_1.comparator_body_0.m3_m4_diff_0.n1.n41 comparator_slice_1.comparator_body_0.m3_m4_diff_0.n1.n55 1.87314
R4185 comparator_slice_1.comparator_body_0.m1_m2_diff_0.n1 comparator_slice_1.comparator_body_0.m3_m4_diff_0.n1.n54 1.87314
R4186 comparator_slice_1.comparator_body_0.m1_m2_diff_0.n1 comparator_slice_1.comparator_body_0.m3_m4_diff_0.n1.n58 1.87314
R4187 comparator_slice_1.comparator_body_0.m3_m4_diff_0.n1.n41 comparator_slice_1.comparator_body_0.m3_m4_diff_0.n1.n48 1.81066
R4188 comparator_slice_1.comparator_body_0.m3_m4_diff_0.n1.n53 comparator_slice_1.comparator_body_0.m1_m2_diff_0.m1_m2_array_2/n1_2_11.D 1.74154
R4189 comparator_slice_1.comparator_body_0.m3_m4_diff_0.m3_m4_array_2/p1_2$1_0.D comparator_slice_1.comparator_body_0.m3_m4_diff_0.n1.n18 1.82939
R4190 comparator_slice_1.comparator_body_0.m3_m4_diff_0.m3_m4_array_1/p1_2$1_0.D comparator_slice_1.comparator_body_0.m3_m4_diff_0.n1.n6 1.82939
R4191 comparator_slice_1.comparator_body_0.m3_m4_diff_0.m3_m4_array_3/p1_2$1_0.D comparator_slice_1.comparator_body_0.m3_m4_diff_0.n1.n15 1.88718
R4192 comparator_slice_1.comparator_body_0.m3_m4_diff_0.m3_m4_array_3/p1_2$1_4.D comparator_slice_1.comparator_body_0.m3_m4_diff_0.n1.n11 1.88003
R4193 comparator_slice_1.comparator_body_0.m3_m4_diff_0.m3_m4_array_0/p1_2$1_7.D comparator_slice_1.comparator_body_0.m3_m4_diff_0.m3_m4_array_0/p1_2$1_10.D 1.815
R4194 comparator_slice_1.comparator_body_0.m3_m4_diff_0.m3_m4_array_1/p1_2$1_10.D comparator_slice_1.comparator_body_0.m3_m4_diff_0.m3_m4_array_1/p1_2$1_7.D 1.815
R4195 comparator_slice_1.comparator_body_0.m3_m4_diff_0.m3_m4_array_3/p1_2$1_10.D comparator_slice_1.comparator_body_0.m3_m4_diff_0.m3_m4_array_3/p1_2$1_7.D 1.815
R4196 comparator_slice_1.comparator_body_0.m3_m4_diff_0.m3_m4_array_2/p1_2$1_10.D comparator_slice_1.comparator_body_0.m3_m4_diff_0.m3_m4_array_2/p1_2$1_7.D 1.815
R4197 comparator_slice_1.comparator_body_0.m3_m4_diff_0.m3_m4_array_2/p1_2$1_4.D comparator_slice_1.comparator_body_0.m3_m4_diff_0.n1.n9 1.67969
R4198 comparator_slice_1.comparator_body_0.m3_m4_diff_0.n1.n41 comparator_slice_1.comparator_body_0.m1_m2_diff_0.m1_m2_array_0/n1_2_13.D 1.66263
R4199 comparator_slice_1.comparator_body_0.m3_m4_diff_0.n1.n58 comparator_slice_1.comparator_body_0.m1_m2_diff_0.m1_m2_array_0/n1_2_2.D 1.66263
R4200 comparator_slice_1.comparator_body_0.m1_m2_diff_0.n1 comparator_slice_1.comparator_body_0.m1_m2_diff_0.m1_m2_array_2/n1_2_13.D 1.66263
R4201 comparator_slice_1.comparator_body_0.m3_m4_diff_0.n1.n54 comparator_slice_1.comparator_body_0.m1_m2_diff_0.m1_m2_array_2/n1_2_2.D 1.66263
R4202 comparator_slice_1.comparator_body_0.m1_m2_diff_0.n1 comparator_slice_1.comparator_body_0.m1_m2_diff_0.m1_m2_array_3/n1_2_13.D 1.66263
R4203 comparator_slice_1.comparator_body_0.m3_m4_diff_0.n1.n60 comparator_slice_1.comparator_body_0.m1_m2_diff_0.m1_m2_array_3/n1_2_2.D 1.66263
R4204 comparator_slice_1.comparator_body_0.m3_m4_diff_0.n1.n55 comparator_slice_1.comparator_body_0.m1_m2_diff_0.m1_m2_array_1/n1_2_2.D 1.66263
R4205 comparator_slice_1.comparator_body_0.m3_m4_diff_0.n1.n25 comparator_slice_1.comparator_body_0.m3_m4_diff_0.n1.n30 1.65805
R4206 comparator_slice_1.comparator_body_0.m3_m4_diff_0.n1.n45 comparator_slice_1.comparator_body_0.m1_m2_diff_0.m1_m2_array_0/n1_2_10.D 1.64914
R4207 comparator_slice_1.comparator_body_0.m3_m4_diff_0.n1.n20 comparator_slice_1.comparator_body_0.m1_m2_diff_0.m1_m2_array_2/n1_2_10.D 1.64914
R4208 comparator_slice_1.comparator_body_0.m3_m4_diff_0.n1.n49 comparator_slice_1.comparator_body_0.m1_m2_diff_0.m1_m2_array_3/n1_2_10.D 1.64914
R4209 comparator_slice_1.comparator_body_0.m3_m4_diff_0.n1.n44 comparator_slice_1.comparator_body_0.m1_m2_diff_0.m1_m2_array_1/n1_2_10.D 1.64914
R4210 comparator_slice_1.comparator_body_0.m3_m4_diff_0.n1.n44 comparator_slice_1.comparator_body_0.m3_m4_diff_0.n1.n31 1.6373
R4211 comparator_slice_1.comparator_body_0.m3_m4_diff_0.m3_m4_array_2/p1_2$1_9.D comparator_slice_1.comparator_body_0.m3_m4_diff_0.m3_m4_array_2/p1_2$1_13.D 1.6293
R4212 comparator_slice_1.comparator_body_0.m3_m4_diff_0.n1.n15 comparator_slice_1.comparator_body_0.m3_m4_diff_0.n1.n35 0.456729
R4213 comparator_slice_1.comparator_body_0.m3_m4_diff_0.n1.n9 comparator_slice_1.comparator_body_0.m3_m4_diff_0.n1.n46 1.6205
R4214 comparator_slice_1.comparator_body_0.m3_m4_diff_0.n1.n49 comparator_slice_1.comparator_body_0.m3_m4_diff_0.n1.n50 1.59946
R4215 comparator_slice_1.comparator_body_0.m3_m4_diff_0.m3_m4_array_0/p1_2$1_14.D comparator_slice_1.comparator_body_0.m3_m4_diff_0.n1.n19 1.5946
R4216 comparator_slice_1.comparator_body_0.m3_m4_diff_0.n1.n12 comparator_slice_1.comparator_body_0.m3_m4_diff_0.m3_m4_array_1/p1_2$1_14.D 1.5946
R4217 comparator_slice_1.comparator_body_0.m3_m4_diff_0.m3_m4_array_3/p1_2$1_14.D comparator_slice_1.comparator_body_0.m3_m4_diff_0.n1.n13 1.5946
R4218 comparator_slice_1.comparator_body_0.m3_m4_diff_0.n1.n57 comparator_slice_1.comparator_body_0.m3_m4_diff_0.m3_m4_array_2/p1_2$1_14.D 1.5946
R4219 comparator_slice_1.comparator_body_0.m3_m4_diff_0.n1.n59 comparator_slice_1.comparator_body_0.m3_m4_diff_0.n1.n45 1.59154
R4220 comparator_slice_1.comparator_body_0.m3_m4_diff_0.m3_m4_array_2/p1_2$1_1.D comparator_slice_1.comparator_body_0.m3_m4_diff_0.n1.n4 1.58748
R4221 comparator_slice_1.comparator_body_0.m3_m4_diff_0.m3_m4_array_1/p1_2$1_1.D comparator_slice_1.comparator_body_0.m3_m4_diff_0.n1.n24 1.58748
R4222 comparator_slice_1.comparator_body_0.m3_m4_diff_0.m3_m4_array_0/p1_2$1_1.D comparator_slice_1.comparator_body_0.m3_m4_diff_0.n1.n5 1.58748
R4223 comparator_slice_1.comparator_body_0.m3_m4_diff_0.n1.n11 comparator_slice_1.comparator_body_0.m3_m4_diff_0.m3_m4_array_3/p1_2$1_1.D 1.58748
R4224 comparator_slice_1.comparator_body_0.m3_m4_diff_0.m3_m4_array_1/p1_2$1_4.D comparator_slice_1.comparator_body_0.m3_m4_diff_0.n1.n24 1.58713
R4225 comparator_slice_1.comparator_body_0.m3_m4_diff_0.n1.n57 comparator_slice_1.comparator_body_0.m3_m4_diff_0.m3_m4_array_2/p1_2$1_13.D 1.5855
R4226 comparator_slice_1.comparator_body_0.m3_m4_diff_0.m3_m4_array_2/p1_2$1_10.D comparator_slice_1.comparator_body_0.m3_m4_diff_0.m3_m4_array_2/p1_2$1_0.D 1.57788
R4227 comparator_slice_1.comparator_body_0.m3_m4_diff_0.m3_m4_array_1/p1_2$1_10.D comparator_slice_1.comparator_body_0.m3_m4_diff_0.m3_m4_array_1/p1_2$1_0.D 1.57788
R4228 comparator_slice_1.comparator_body_0.m3_m4_diff_0.n1.n8 comparator_slice_1.comparator_body_0.m3_m4_diff_0.m3_m4_array_0/p1_2$1_0.D 0.490965
R4229 comparator_slice_1.comparator_body_0.m3_m4_diff_0.m3_m4_array_3/p1_2$1_10.D comparator_slice_1.comparator_body_0.m3_m4_diff_0.m3_m4_array_3/p1_2$1_0.D 1.57788
R4230 comparator_slice_1.comparator_body_0.m3_m4_diff_0.m3_m4_array_3/p1_2$1_7.D comparator_slice_1.comparator_body_0.m3_m4_diff_0.m3_m4_array_3/p1_2$1_9.D 1.57788
R4231 comparator_slice_1.comparator_body_0.m3_m4_diff_0.n1.n12 comparator_slice_1.comparator_body_0.m3_m4_diff_0.m3_m4_array_1/p1_2$1_13.D 1.5592
R4232 comparator_slice_1.comparator_body_0.m3_m4_diff_0.n1.n27 comparator_slice_1.comparator_body_0.m3_m4_diff_0.m3_m4_array_0/p1_2$1_13.D 0.433469
R4233 comparator_slice_1.comparator_body_0.m3_m4_diff_0.n1.n56 comparator_slice_1.comparator_body_0.m1_m2_diff_0.m1_m2_array_1/n1_2_13.D 1.52535
R4234 comparator_slice_1.comparator_body_0.m3_m4_diff_0.m3_m4_array_0/p1_2$1_4.D comparator_slice_1.comparator_body_0.m3_m4_diff_0.n1.n32 1.39983
R4235 comparator_slice_1.comparator_body_0.m3_m4_diff_0.n1.n29 comparator_slice_1.comparator_body_0.m3_m4_diff_0.n1.n12 1.3993
R4236 comparator_slice_1.comparator_body_0.m3_m4_diff_0.n1.n0 comparator_slice_1.comparator_body_0.m3_m4_diff_0.n1.n3 0.61471
R4237 comparator_slice_1.comparator_body_0.m3_m4_diff_0.n1.n26 comparator_slice_1.comparator_body_0.m3_m4_diff_0.m3_m4_array_3/p1_2$1_4.D 1.36082
R4238 comparator_slice_1.comparator_body_0.m3_m4_diff_0.n1.n18 comparator_slice_1.comparator_body_0.m3_m4_diff_0.m3_m4_array_2/p1_2$1_14.D 1.35083
R4239 comparator_slice_1.comparator_body_0.m3_m4_diff_0.m3_m4_array_1/p1_2$1_14.D comparator_slice_1.comparator_body_0.m3_m4_diff_0.n1.n6 1.35083
R4240 comparator_slice_1.comparator_body_0.m3_m4_diff_0.n1.n6 comparator_slice_1.comparator_body_0.m3_m4_diff_0.n1.n25 0.412289
R4241 comparator_slice_1.comparator_body_0.m3_m4_diff_0.n1.n36 comparator_slice_1.comparator_body_0.m3_m4_diff_0.n1.n18 0.412289
R4242 comparator_slice_1.comparator_body_0.m3_m4_diff_0.m3_m4_array_0/p1_2$1_9.D comparator_slice_1.comparator_body_0.m3_m4_diff_0.m3_m4_array_0/p1_2$1_13.D 1.3455
R4243 comparator_slice_1.comparator_body_0.m3_m4_diff_0.n1.n27 comparator_slice_1.comparator_body_0.m3_m4_diff_0.n1.n19 1.3328
R4244 comparator_slice_1.comparator_body_0.m3_m4_diff_0.n1.n15 comparator_slice_1.comparator_body_0.m3_m4_diff_0.m3_m4_array_3/p1_2$1_14.D 1.32571
R4245 comparator_slice_1.comparator_body_0.m3_m4_diff_0.m3_m4_array_1/p1_2$1_13.D comparator_slice_1.comparator_body_0.m3_m4_diff_0.m3_m4_array_1/p1_2$1_9.D 1.318
R4246 comparator_slice_1.comparator_body_0.m3_m4_diff_0.n1.n48 comparator_slice_1.comparator_body_0.m3_m4_diff_0.n1.n44 1.31346
R4247 comparator_slice_1.comparator_body_0.m3_m4_diff_0.n1.n51 comparator_slice_1.comparator_body_0.m3_m4_diff_0.n1.n20 1.31346
R4248 comparator_slice_1.comparator_body_0.m3_m4_diff_0.n1.n45 comparator_slice_1.comparator_body_0.m3_m4_diff_0.n1.n52 1.31346
R4249 comparator_slice_1.comparator_body_0.m3_m4_diff_0.m3_m4_array_0/p1_2$1_7.D comparator_slice_1.comparator_body_0.m3_m4_diff_0.m3_m4_array_0/p1_2$1_4.D 1.3095
R4250 comparator_slice_1.comparator_body_0.m3_m4_diff_0.m3_m4_array_3/p1_2$1_10.D comparator_slice_1.comparator_body_0.m3_m4_diff_0.m3_m4_array_3/p1_2$1_1.D 1.3095
R4251 comparator_slice_1.comparator_body_0.m3_m4_diff_0.m3_m4_array_0/p1_2$1_1.D comparator_slice_1.comparator_body_0.m3_m4_diff_0.m3_m4_array_0/p1_2$1_10.D 1.3095
R4252 comparator_slice_1.comparator_body_0.m3_m4_diff_0.m3_m4_array_0/p1_2$1_7.D comparator_slice_1.comparator_body_0.m3_m4_diff_0.n1.n5 1.3095
R4253 comparator_slice_1.comparator_body_0.m3_m4_diff_0.m3_m4_array_1/p1_2$1_10.D comparator_slice_1.comparator_body_0.m3_m4_diff_0.m3_m4_array_1/p1_2$1_4.D 1.3095
R4254 comparator_slice_1.comparator_body_0.m3_m4_diff_0.m3_m4_array_1/p1_2$1_10.D comparator_slice_1.comparator_body_0.m3_m4_diff_0.m3_m4_array_1/p1_2$1_1.D 1.3095
R4255 comparator_slice_1.comparator_body_0.m3_m4_diff_0.m3_m4_array_2/p1_2$1_1.D comparator_slice_1.comparator_body_0.m3_m4_diff_0.m3_m4_array_2/p1_2$1_10.D 1.3095
R4256 comparator_slice_1.comparator_body_0.m3_m4_diff_0.n1.n9 comparator_slice_1.comparator_body_0.m3_m4_diff_0.m3_m4_array_2/p1_2$1_9.D 1.3095
R4257 comparator_slice_1.comparator_body_0.m3_m4_diff_0.m3_m4_array_2/p1_2$1_7.D comparator_slice_1.comparator_body_0.m3_m4_diff_0.m3_m4_array_2/p1_2$1_4.D 1.3095
R4258 comparator_slice_1.comparator_body_0.m3_m4_diff_0.m3_m4_array_2/p1_2$1_10.D comparator_slice_1.comparator_body_0.m3_m4_diff_0.n1.n4 1.3095
R4259 comparator_slice_1.comparator_body_0.m3_m4_diff_0.m3_m4_array_3/p1_2$1_1.D comparator_slice_1.comparator_body_0.m3_m4_diff_0.m3_m4_array_3/p1_2$1_0.D 1.3095
R4260 comparator_slice_1.comparator_body_0.m3_m4_diff_0.m3_m4_array_0/p1_2$1_0.D comparator_slice_1.comparator_body_0.m3_m4_diff_0.m3_m4_array_0/p1_2$1_1.D 1.3095
R4261 comparator_slice_1.comparator_body_0.m3_m4_diff_0.m3_m4_array_1/p1_2$1_1.D comparator_slice_1.comparator_body_0.m3_m4_diff_0.m3_m4_array_1/p1_2$1_0.D 1.3095
R4262 comparator_slice_1.comparator_body_0.m3_m4_diff_0.m3_m4_array_2/p1_2$1_0.D comparator_slice_1.comparator_body_0.m3_m4_diff_0.m3_m4_array_2/p1_2$1_1.D 1.3095
R4263 comparator_slice_1.comparator_body_0.m3_m4_diff_0.m3_m4_array_3/p1_2$1_10.D comparator_slice_1.comparator_body_0.m3_m4_diff_0.n1.n11 1.3095
R4264 comparator_slice_1.comparator_body_0.m3_m4_diff_0.m3_m4_array_3/p1_2$1_4.D comparator_slice_1.comparator_body_0.m3_m4_diff_0.m3_m4_array_3/p1_2$1_7.D 1.3095
R4265 comparator_slice_1.comparator_body_0.m3_m4_diff_0.m3_m4_array_3/p1_2$1_9.D comparator_slice_1.comparator_body_0.m3_m4_diff_0.m3_m4_array_3/p1_2$1_4.D 1.3095
R4266 comparator_slice_1.comparator_body_0.m3_m4_diff_0.m3_m4_array_0/p1_2$1_9.D comparator_slice_1.comparator_body_0.m3_m4_diff_0.m3_m4_array_0/p1_2$1_4.D 1.3095
R4267 comparator_slice_1.comparator_body_0.m3_m4_diff_0.m3_m4_array_1/p1_2$1_4.D comparator_slice_1.comparator_body_0.m3_m4_diff_0.m3_m4_array_1/p1_2$1_9.D 1.3095
R4268 comparator_slice_1.comparator_body_0.m3_m4_diff_0.m3_m4_array_1/p1_2$1_4.D comparator_slice_1.comparator_body_0.m3_m4_diff_0.m3_m4_array_1/p1_2$1_7.D 1.3095
R4269 comparator_slice_1.comparator_body_0.m3_m4_diff_0.n1.n0 comparator_slice_1.comparator_body_0.m3_m4_diff_0.n1.n27 1.30329
R4270 comparator_slice_1.comparator_body_0.m3_m4_diff_0.n1.n19 comparator_slice_1.comparator_body_0.m3_m4_diff_0.m3_m4_array_0/p1_2$1_7.D 1.2941
R4271 comparator_slice_1.comparator_body_0.m3_m4_diff_0.m3_m4_array_3/p1_2$1_14.D comparator_slice_1.comparator_body_0.m3_m4_diff_0.m3_m4_array_3/p1_2$1_10.D 1.2941
R4272 comparator_slice_1.comparator_body_0.m3_m4_diff_0.m3_m4_array_0/p1_2$1_10.D comparator_slice_1.comparator_body_0.m3_m4_diff_0.n1.n8 0.490965
R4273 comparator_slice_1.comparator_body_0.m3_m4_diff_0.m3_m4_array_0/p1_2$1_7.D comparator_slice_1.comparator_body_0.m3_m4_diff_0.m3_m4_array_0/p1_2$1_14.D 1.2941
R4274 comparator_slice_1.comparator_body_0.m3_m4_diff_0.m3_m4_array_1/p1_2$1_14.D comparator_slice_1.comparator_body_0.m3_m4_diff_0.m3_m4_array_1/p1_2$1_10.D 1.2941
R4275 comparator_slice_1.comparator_body_0.m3_m4_diff_0.m3_m4_array_1/p1_2$1_14.D comparator_slice_1.comparator_body_0.m3_m4_diff_0.m3_m4_array_1/p1_2$1_10.D 1.2941
R4276 comparator_slice_1.comparator_body_0.m3_m4_diff_0.m3_m4_array_2/p1_2$1_10.D comparator_slice_1.comparator_body_0.m3_m4_diff_0.m3_m4_array_2/p1_2$1_14.D 1.2941
R4277 comparator_slice_1.comparator_body_0.m3_m4_diff_0.m3_m4_array_2/p1_2$1_13.D comparator_slice_1.comparator_body_0.m3_m4_diff_0.m3_m4_array_2/p1_2$1_7.D 1.2941
R4278 comparator_slice_1.comparator_body_0.m3_m4_diff_0.m3_m4_array_2/p1_2$1_10.D comparator_slice_1.comparator_body_0.m3_m4_diff_0.m3_m4_array_2/p1_2$1_14.D 1.2941
R4279 comparator_slice_1.comparator_body_0.m3_m4_diff_0.n1.n7 comparator_slice_1.comparator_body_0.m3_m4_diff_0.n1.n8 0.402818
R4280 comparator_slice_1.comparator_body_0.m3_m4_diff_0.m3_m4_array_3/p1_2$1_10.D comparator_slice_1.comparator_body_0.m3_m4_diff_0.m3_m4_array_3/p1_2$1_14.D 1.2941
R4281 comparator_slice_1.comparator_body_0.m3_m4_diff_0.m3_m4_array_3/p1_2$1_7.D comparator_slice_1.comparator_body_0.m3_m4_diff_0.n1.n13 1.2941
R4282 comparator_slice_1.comparator_body_0.m3_m4_diff_0.m3_m4_array_3/p1_2$1_9.D comparator_slice_1.comparator_body_0.m3_m4_diff_0.m3_m4_array_3/p1_2$1_13.D 1.2941
R4283 comparator_slice_1.comparator_body_0.m3_m4_diff_0.m3_m4_array_1/p1_2$1_7.D comparator_slice_1.comparator_body_0.m3_m4_diff_0.n1.n12 1.2941
R4284 comparator_slice_1.comparator_body_0.m3_m4_diff_0.n1.n30 comparator_slice_1.comparator_body_0.m3_m4_diff_0.n1.n32 0.574262
R4285 comparator_slice_1.comparator_body_0.m3_m4_diff_0.n1.n0 comparator_slice_1.comparator_body_0.m3_m4_diff_0.n1.n1 0.264696
R4286 comparator_slice_1.comparator_body_0.m3_m4_diff_0.n1.n16 comparator_slice_1.comparator_body_0.m3_m4_diff_0.n1.n0 0.486488
R4287 comparator_slice_1.comparator_body_0.m3_m4_diff_0.m3_m4_array_0/p1_2$1_1.D comparator_slice_1.comparator_body_0.m3_m4_diff_0.n1.n17 0.471778
R4288 comparator_slice_1.comparator_body_0.m3_m4_diff_0.m3_m4_array_0/p1_2$1_14.D comparator_slice_1.comparator_body_0.m3_m4_diff_0.n1.n16 0.321424
R4289 comparator_slice_1.comparator_body_0.m3_m4_diff_0.n1.n30 comparator_slice_1.comparator_body_0.m3_m4_diff_0.n1.n5 1.2919
R4290 comparator_slice_1.comparator_body_0.m3_m4_diff_0.n1.n28 comparator_slice_1.comparator_body_0.m3_m4_diff_0.n1.n30 0.574779
R4291 comparator_slice_1.comparator_body_0.m3_m4_diff_0.n1.n21 comparator_slice_1.comparator_body_0.m3_m4_diff_0.n1.n36 0.42662
R4292 comparator_slice_1.comparator_body_0.m3_m4_diff_0.n1.n22 comparator_slice_1.comparator_body_0.m3_m4_diff_0.m3_m4_array_1/p1_2$1_1.D 0.471778
R4293 comparator_slice_1.comparator_body_0.m3_m4_diff_0.n1.n34 comparator_slice_1.comparator_body_0.m3_m4_diff_0.m3_m4_array_2/p1_2$1_1.D 1.2919
R4294 comparator_slice_1.comparator_body_0.m3_m4_diff_0.m3_m4_array_2/p1_2$1_4.D comparator_slice_1.comparator_body_0.m3_m4_diff_0.n1.n46 1.2919
R4295 comparator_slice_1.comparator_body_0.m3_m4_diff_0.n1.n36 comparator_slice_1.comparator_body_0.m3_m4_diff_0.n1.n23 0.574779
R4296 comparator_slice_1.comparator_body_0.m3_m4_diff_0.n1.n34 comparator_slice_1.comparator_body_0.m3_m4_diff_0.n1.n10 0.575963
R4297 comparator_slice_1.comparator_body_0.m3_m4_diff_0.m3_m4_array_3/p1_2$1_14.D comparator_slice_1.comparator_body_0.m3_m4_diff_0.n1.n47 1.2919
R4298 comparator_slice_1.comparator_body_0.m3_m4_diff_0.n1.n42 comparator_slice_1.comparator_body_0.m3_m4_diff_0.n1.n14 0.331716
R4299 comparator_slice_1.comparator_body_0.m3_m4_diff_0.m3_m4_array_2/p1_2$1_13.D comparator_slice_1.comparator_body_0.m3_m4_diff_0.m3_m4_array_1/p1_2$1_4.D 1.2919
R4300 comparator_slice_1.comparator_body_0.m3_m4_diff_0.n1.n46 comparator_slice_1.comparator_body_0.m3_m4_diff_0.n1.n34 1.28781
R4301 comparator_slice_1.comparator_body_0.m3_m4_diff_0.n1.n47 comparator_slice_1.comparator_body_0.m3_m4_diff_0.n1.n35 1.28747
R4302 comparator_slice_1.comparator_body_0.m3_m4_diff_0.m3_m4_array_0/p1_2$1_7.D comparator_slice_1.comparator_body_0.m3_m4_diff_0.m3_m4_array_0/p1_2$1_9.D 1.24268
R4303 comparator_slice_1.comparator_body_0.m3_m4_diff_0.m3_m4_array_1/p1_2$1_7.D comparator_slice_1.comparator_body_0.m3_m4_diff_0.m3_m4_array_1/p1_2$1_9.D 1.24268
R4304 comparator_slice_1.comparator_body_0.m3_m4_diff_0.m3_m4_array_2/p1_2$1_7.D comparator_slice_1.comparator_body_0.m3_m4_diff_0.m3_m4_array_2/p1_2$1_9.D 1.24268
R4305 comparator_slice_1.comparator_body_0.m3_m4_diff_0.m3_m4_array_2/p1_2$1_13.D comparator_slice_1.comparator_body_0.m3_m4_diff_0.n1.n36 1.23969
R4306 comparator_slice_1.comparator_body_0.m3_m4_diff_0.n1.n0 comparator_slice_1.comparator_body_0.m3_m4_diff_0.n1.n26 0.534979
R4307 comparator_slice_1.comparator_body_0.m3_m4_diff_0.n1.n43 comparator_slice_1.comparator_body_0.m3_m4_diff_0.n1.n33 0.526573
R4308 comparator_slice_1.comparator_body_0.m3_m4_diff_0.n1.n14 comparator_slice_1.comparator_body_0.m3_m4_diff_0.m3_m4_array_3/p1_2$1_13.D 0.532773
R4309 comparator_slice_1.comparator_body_0.m3_m4_diff_0.n1.n47 comparator_slice_1.comparator_body_0.m3_m4_diff_0.n1.n42 1.10475
R4310 comparator_slice_1.comparator_body_0.m3_m4_diff_0.n1.n1 comparator_slice_1.comparator_body_0.m3_m4_diff_0.m3_m4_array_3/p1_2$1_1.D 0.471778
R4311 comparator_slice_1.comparator_body_0.m3_m4_diff_0.n1.n34 comparator_slice_1.comparator_body_0.m3_m4_diff_0.n1.n33 1.09121
R4312 comparator_slice_1.comparator_body_0.m3_m4_diff_0.m3_m4_array_1/p1_2$1_13.D comparator_slice_1.comparator_body_0.m3_m4_diff_0.n1.n30 1.084
R4313 comparator_slice_1.comparator_body_0.m3_m4_diff_0.m3_m4_array_2/p1_2$1_1.D comparator_slice_1.comparator_body_0.m3_m4_diff_0.n1.n43 1.00828
C0 resistor_network_0.p1 a_41622_30180# 0.0478f
C1 a_51802_22314# comparator_slice_0.comparator_body_0.outx 0.07727f
C2 a_56766_21450# ibias0 0.727f
C3 AVDD a_38210_33198# 1.50718f
C4 a_53873_7784# trigger 0.05337f
C5 threshold a_53289_44737# 0.24476f
C6 a_41622_11544# a_41892_11544# 0.30437f
C7 a_39020_20598# a_39290_20598# 0.30437f
C8 a_56182_19070# ibias0 0.81667f
C9 trigger a_53873_23927# 0.05337f
C10 a_51218_19934# comparator_slice_0.comparator_body_0.outx 0.1953f
C11 AVDD a_40100_33198# 1.5824f
C12 a_53289_5304# trigger 0.25665f
C13 a_42432_17580# resistor_network_0.resistor_leg_1.pt 0.04651f
C14 threshold a_54772_43497# 0.27988f
C15 AVDD set_b 0.55002f
C16 a_42702_14562# resistor_network_0.pb 0.0727f
C17 AVDD resistor_network_0.resistor_leg_1.p2 6.42628f
C18 resistor_network_0.pb a_42702_20598# 0.03874f
C19 a_50902_17424# comparator_slice_0.comparator_body_0.outx 0.09413f
C20 a_57666_17644# ibias0 0.81527f
C21 AVDD a_39830_30180# 1.55905f
C22 a_54772_4064# trigger 0.24262f
C23 AVDD comparator_slice_0.comparator_body_0.outx 53.2133f
C24 threshold a_54186_40606# 0.0522f
C25 a_41352_8526# a_41622_8526# 0.30437f
C26 a_42162_14562# resistor_network_0.resistor_leg_1.pt 0.06804f
C27 resistor_network_0.resistor_leg_1.pt a_42162_20598# 0.12211f
C28 a_57082_9078# ibias0 0.81675f
C29 a_38750_17580# a_39020_17580# 0.30437f
C30 a_54772_22687# vctrl 0.18708f
C31 a_42432_11544# resistor_network_0.pb 0.11372f
C32 a_57082_15264# ibias0 0.74383f
C33 a_50318_15044# comparator_slice_0.comparator_body_0.outx 0.19162f
C34 a_41622_17580# AVDD 1.33134f
C35 AVDD a_39560_27162# 1.33134f
C36 resistor_network_0.resistor_leg_2.p1 a_41622_39234# 0.16844f
C37 resistor_network_0.p1 resistor_network_0.resistor_leg_0.pt 2.69694f
C38 resistor_network_0.p1 a_54186_45977# 0.24247f
C39 threshold a_53873_38126# 0.25354f
C40 a_41892_11544# resistor_network_0.resistor_leg_1.pt 0.05194f
C41 a_56766_6462# ibias0 0.727f
C42 AVDD a_51802_47207# 0.21562f
C43 a_54186_20207# vctrl 0.25371f
C44 resistor_network_0.pb a_39560_17580# 0.06142f
C45 a_56766_12648# ibias0 0.81535f
C46 a_60176_37898# a_62350_39143# 0.26078f
C47 a_51802_13854# comparator_slice_0.comparator_body_0.outx 0.1941f
C48 a_41352_14562# AVDD 1.33487f
C49 resistor_network_0.p1 a_53873_43497# 0.05337f
C50 threshold a_53289_35224# 0.05769f
C51 a_56182_4082# ibias0 0.81895f
C52 a_38480_14562# a_38750_14562# 0.30437f
C53 AVDD a_42432_42252# 1.33134f
C54 resistor_network_0.pb a_39290_14562# 0.06469f
C55 a_53873_17297# vctrl 0.05182f
C56 a_51218_11344# comparator_slice_0.comparator_body_0.outx 0.10658f
C57 a_41082_11544# AVDD 1.5824f
C58 resistor_network_0.resistor_leg_0.pt a_38480_36216# 0.05228f
C59 resistor_network_0.p1 a_53289_40606# 0.25924f
C60 threshold a_54772_33984# 0.18752f
C61 a_53290_14817# vctrl 0.25569f
C62 a_50902_8964# comparator_slice_0.comparator_body_0.outx 0.21109f
C63 a_42972_11544# AVDD 1.50711f
C64 resistor_network_0.pb a_39020_11544# 0.08925f
C65 AVDD a_38210_17580# 1.50718f
C66 a_53873_39366# a_54186_39366# 0.11313f
C67 resistor_network_0.resistor_leg_2.p1 a_42702_36216# 0.17395f
C68 resistor_network_0.p1 a_54772_39366# 0.22474f
C69 comparator_slice_1.comparator_body_0.outx a_51218_46017# 0.19529f
C70 threshold a_54186_31074# 0.25371f
C71 AVDD a_60474_39143# 0.32967f
C72 a_54772_13155# vctrl 0.27988f
C73 a_38210_11544# a_38480_11544# 0.30437f
C74 a_50318_6454# comparator_slice_0.comparator_body_0.outx 0.10522f
C75 a_42702_8526# AVDD 1.33134f
C76 a_53873_16057# a_54186_16057# 0.11313f
C77 AVDD a_40100_17580# 1.5824f
C78 resistor_network_0.resistor_leg_3.p1 a_39830_36216# 0.02314f
C79 AVDD resistor_network_0.pb 13.816f
C80 resistor_network_0.p1 a_39560_39234# 0.26899f
C81 resistor_network_0.p1 a_54186_36464# 0.05336f
C82 resistor_network_0.resistor_leg_2.p1 a_42432_33198# 0.07826f
C83 a_41892_39234# a_42162_39234# 0.30437f
C84 threshold a_53873_28594# 0.05182f
C85 a_54186_10675# vctrl 0.0522f
C86 AVDD a_41622_39234# 1.46563f
C87 a_51802_5264# comparator_slice_0.comparator_body_0.outx 0.104f
C88 a_50902_21124# AVDD 0.2406f
C89 AVDD a_39830_14562# 1.33487f
C90 resistor_network_0.resistor_leg_0.pt a_39830_30180# 0.01183f
C91 resistor_network_0.resistor_leg_2.p1 a_42162_30180# 0.35346f
C92 resistor_network_0.p1 a_53873_33984# 0.24254f
C93 resistor_network_0.resistor_leg_3.p1 a_39560_33198# 0.16171f
C94 resistor_network_0.resistor_leg_1.pt a_41622_36216# 0.06142f
C95 ibias1 a_56766_46009# 0.83223f
C96 a_39020_39234# a_39290_39234# 0.30437f
C97 resistor_network_0.p1 a_39290_36216# 0.2364f
C98 a_60176_13955# a_62934_12138# 0.31253f
C99 a_53873_7784# vctrl 0.25354f
C100 a_50318_18744# AVDD 0.23986f
C101 AVDD a_39560_11544# 1.33532f
C102 a_54186_22687# comparator_slice_0.comparator_body_0.outx 0.08298f
C103 resistor_network_0.resistor_leg_0.p2 a_39560_20598# 0.26261f
C104 resistor_network_0.resistor_leg_3.p1 a_39290_30180# 0.05737f
C105 resistor_network_0.p1 a_53290_31074# 0.06849f
C106 resistor_network_0.p1 a_39020_33198# 0.26245f
C107 ibias1 a_56182_43629# 0.72802f
C108 comparator_slice_1.comparator_body_0.outx a_51218_42317# 0.09565f
C109 vctrl a_53873_23927# 0.25363f
C110 a_53289_5304# vctrl 0.05498f
C111 a_51802_17424# AVDD 0.24036f
C112 AVDD a_42972_39234# 1.50711f
C113 comparator_slice_1.comparator_body_0.outx a_53873_45977# 0.08299f
C114 AVDD a_39290_8526# 1.33134f
C115 ibias1 a_56766_41013# 0.83223f
C116 resistor_network_0.p1 a_54772_29834# 0.05339f
C117 a_38750_36216# a_39020_36216# 0.30437f
C118 resistor_network_0.p1 a_38750_30180# 0.34222f
C119 resistor_network_0.resistor_leg_0.p2 a_39290_17580# 0.2364f
C120 comparator_slice_1.comparator_body_0.outx a_50902_39937# 0.19516f
C121 a_41352_36216# a_41622_36216# 0.30437f
C122 a_39830_8526# a_40100_8526# 0.30437f
C123 a_54772_4064# vctrl 0.06676f
C124 AVDD a_42702_36216# 1.36025f
C125 ibias1 a_56182_38633# 0.72802f
C126 a_51218_15044# AVDD 0.24107f
C127 a_53289_17297# comparator_slice_0.comparator_body_0.outx 0.25863f
C128 AVDD a_41892_23616# 1.33134f
C129 comparator_slice_1.comparator_body_0.outx a_53289_43497# 0.18276f
C130 a_42702_17580# vctrl 0.17395f
C131 resistor_network_0.p1 a_54186_27354# 0.24252f
C132 resistor_network_0.resistor_leg_0.p2 a_39020_14562# 0.26245f
C133 comparator_slice_1.comparator_body_0.outx a_50318_37427# 0.07811f
C134 resistor_network_0.resistor_leg_1.pt a_42972_30180# 0.01655f
C135 a_54772_16057# comparator_slice_0.comparator_body_0.outx 0.258f
C136 a_50902_12534# AVDD 0.24955f
C137 comparator_slice_1.comparator_body_0.outx a_54772_41846# 0.18066f
C138 AVDD a_42432_33198# 1.43502f
C139 vctrl a_42432_20598# 0.37132f
C140 resistor_network_0.resistor_leg_0.p2 a_38750_11544# 0.34222f
C141 a_42432_14562# vctrl 0.07826f
C142 a_38480_33198# a_38750_33198# 0.30437f
C143 comparator_slice_1.comparator_body_0.outx a_51802_36237# 0.10386f
C144 AVDD a_38480_23616# 1.33134f
C145 a_41082_33198# a_41352_33198# 0.30437f
C146 a_42432_23616# a_42702_23616# 0.30437f
C147 AVDD a_50902_44827# 0.2406f
C148 resistor_network_0.resistor_leg_3.p1 resistor_network_0.resistor_leg_2.p1 0.16611f
C149 ibias1 a_56766_36017# 0.83223f
C150 AVDD a_42162_30180# 1.38254f
C151 a_50318_10154# AVDD 0.21775f
C152 comparator_slice_1.comparator_body_0.outx a_54186_39366# 0.08298f
C153 a_42162_11544# vctrl 0.35346f
C154 resistor_network_0.resistor_leg_0.pt resistor_network_0.pb 0.67953f
C155 vctrl a_39560_20598# 0.17262f
C156 a_62904_13955# reset_b 0.10091f
C157 comparator_slice_1.comparator_body_0.outx a_51218_33857# 0.20936f
C158 AVDD a_38210_20598# 1.50718f
C159 AVDD a_39290_42252# 1.33134f
C160 a_51802_8964# AVDD 0.2306f
C161 AVDD a_41892_27162# 1.33134f
C162 a_53873_10675# comparator_slice_0.comparator_body_0.outx 0.08299f
C163 ibias1 a_56182_34827# 0.81417f
C164 resistor_network_0.resistor_leg_0.pt a_39830_14562# 0.09503f
C165 a_53873_29834# a_54186_29834# 0.11313f
C166 a_62350_12138# reset_b 0.20312f
C167 a_38210_30180# a_38480_30180# 0.30437f
C168 vctrl a_39290_17580# 0.22969f
C169 comparator_slice_1.comparator_body_0.outx a_50902_31347# 0.10672f
C170 AVDD a_51218_43637# 0.24138f
C171 comparator_slice_1.comparator_body_0.outx a_53289_33984# 0.25863f
C172 a_53289_7784# comparator_slice_0.comparator_body_0.outx 0.18276f
C173 ibias1 a_57666_33637# 0.81527f
C174 a_51218_6454# AVDD 0.2488f
C175 a_53873_6544# a_54186_6544# 0.11313f
C176 resistor_network_0.resistor_leg_0.pt a_39560_11544# 0.07966f
C177 vctrl a_39020_14562# 0.16071f
C178 comparator_slice_1.comparator_body_0.outx a_50318_28967# 0.19262f
C179 a_53873_22687# trigger 0.24254f
C180 AVDD threshold 4.59584f
C181 a_54772_6544# comparator_slice_0.comparator_body_0.outx 0.1814f
C182 AVDD a_50902_41127# 0.2495f
C183 a_39020_23616# a_39290_23616# 0.30437f
C184 comparator_slice_1.comparator_body_0.outx a_54772_32744# 0.25799f
C185 a_50902_4074# AVDD 0.24138f
C186 ibias1 a_57082_31021# 0.74383f
C187 vctrl a_38750_11544# 0.09812f
C188 a_42702_30180# a_42972_30180# 0.30437f
C189 a_53290_20207# trigger 0.06849f
C190 a_42432_17580# resistor_network_0.resistor_leg_1.p2 0.1294f
C191 AVDD a_50318_38747# 0.23311f
C192 ibias1 a_56766_28641# 0.81535f
C193 a_54186_4064# comparator_slice_0.comparator_body_0.outx 0.09117f
C194 AVDD resistor_network_0.resistor_leg_3.p1 12.0591f
C195 a_54772_18537# trigger 0.05339f
C196 a_41892_17580# a_42162_17580# 0.30437f
C197 a_42162_14562# resistor_network_0.resistor_leg_1.p2 0.26245f
C198 resistor_network_0.resistor_leg_1.p2 a_42162_20598# 0.05369f
C199 AVDD a_51802_37427# 0.23171f
C200 comparator_slice_1.comparator_body_0.outx a_53873_27354# 0.08299f
C201 a_39830_27162# a_40100_27162# 0.30437f
C202 a_42432_27162# a_42702_27162# 0.30437f
C203 AVDD a_40100_42246# 1.56399f
C204 a_54186_16057# trigger 0.24249f
C205 a_41892_11544# resistor_network_0.resistor_leg_1.p2 0.12153f
C206 AVDD a_51218_35047# 0.2488f
C207 a_40100_20598# a_41082_20598# 0.07769f
C208 resistor_network_0.p1 a_41622_36216# 0.09078f
C209 a_53873_13155# trigger 0.05337f
C210 AVDD a_50902_32537# 0.24138f
C211 a_41622_42252# a_41892_42252# 0.30437f
C212 a_41622_14562# a_41892_14562# 0.30437f
C213 AVDD AVDD1V2 8.08895f
C214 resistor_network_0.p1 a_41352_33198# 0.1983f
C215 set_b a_62350_39143# 0.20312f
C216 a_53289_10675# trigger 0.25924f
C217 AVDD a_40100_39234# 1.5859f
C218 AVDD a_50318_30157# 0.22127f
C219 a_50902_22314# comparator_slice_0.comparator_body_0.outx 0.09366f
C220 a_57666_22640# ibias0 0.81527f
C221 a_42702_42252# a_42972_42252# 0.30437f
C222 AVDD a_39830_36216# 1.41839f
C223 a_54772_9435# trigger 0.24262f
C224 threshold a_54186_45977# 0.05196f
C225 a_41352_11544# a_41622_11544# 0.30437f
C226 AVDD a_51802_28967# 0.22338f
C227 a_38750_20598# a_39020_20598# 0.30437f
C228 a_42432_17580# resistor_network_0.pb 0.02932f
C229 a_50318_19934# comparator_slice_0.comparator_body_0.outx 0.19162f
C230 a_57082_20260# ibias0 0.74383f
C231 comparator_slice_1.comparator_body_0.outx a_60176_37898# 2.17064f
C232 a_54186_6544# trigger 0.05336f
C233 AVDD a_39560_33198# 1.35892f
C234 a_41892_17580# resistor_network_0.resistor_leg_1.pt 0.04982f
C235 threshold a_53873_43497# 0.25354f
C236 AVDD a_41352_20598# 1.33622f
C237 a_42162_14562# resistor_network_0.pb 0.06919f
C238 resistor_network_0.resistor_leg_0.pt resistor_network_0.resistor_leg_3.p1 2.6753f
C239 a_56766_17644# ibias0 0.81535f
C240 a_51802_18744# comparator_slice_0.comparator_body_0.outx 0.1941f
C241 AVDD a_39290_30180# 1.38329f
C242 a_53873_4064# trigger 0.24243f
C243 a_41622_14562# resistor_network_0.resistor_leg_1.pt 0.02531f
C244 a_41082_8526# a_41352_8526# 0.30437f
C245 threshold a_53289_40606# 0.05769f
C246 a_38480_17580# a_38750_17580# 0.30437f
C247 a_41892_11544# resistor_network_0.pb 0.32442f
C248 resistor_network_0.pb a_39290_20598# 0.28809f
C249 a_53873_22687# vctrl 0.05182f
C250 a_51218_16234# comparator_slice_0.comparator_body_0.outx 0.10658f
C251 a_56182_15264# ibias0 0.74374f
C252 a_41082_17580# AVDD 1.5824f
C253 AVDD a_39020_27162# 1.33134f
C254 a_38210_39234# a_38480_39234# 0.30437f
C255 resistor_network_0.p1 a_53289_45977# 0.25665f
C256 a_41352_11544# resistor_network_0.resistor_leg_1.pt 0.21859f
C257 threshold a_54772_39366# 0.19107f
C258 a_53290_20207# vctrl 0.25569f
C259 a_57666_7652# ibias0 0.81527f
C260 AVDD a_50902_47207# 0.24138f
C261 a_61058_39143# a_60176_37898# 0.10837f
C262 a_42972_17580# AVDD 1.50711f
C263 a_50902_13854# comparator_slice_0.comparator_body_0.outx 0.21109f
C264 resistor_network_0.pb a_39020_17580# 0.12716f
C265 a_57666_14074# ibias0 0.72802f
C266 a_53873_41846# a_54186_41846# 0.11313f
C267 AVDD a_41622_42252# 1.33134f
C268 resistor_network_0.p1 a_54772_44737# 0.22664f
C269 threshold a_54186_36464# 0.25371f
C270 a_57082_5272# ibias0 0.74383f
C271 a_38210_14562# a_38480_14562# 0.30437f
C272 AVDD a_41892_42252# 1.33134f
C273 a_54772_18537# vctrl 0.27988f
C274 resistor_network_0.pb a_38750_14562# 0.14996f
C275 AVDD a_42702_20598# 1.33867f
C276 a_42702_14562# AVDD 1.37061f
C277 a_50318_11344# comparator_slice_0.comparator_body_0.outx 0.10522f
C278 a_53873_18537# a_54186_18537# 0.11313f
C279 resistor_network_0.p1 a_54186_41846# 0.05336f
C280 resistor_network_0.resistor_leg_2.p1 a_42432_39234# 0.37132f
C281 trigger ibias0 0.19793f
C282 threshold a_53873_33984# 0.05182f
C283 AVDD resistor_network_0.resistor_leg_2.p1 11.9011f
C284 a_60176_37898# a_62320_37326# 0.24012f
C285 a_54186_16057# vctrl 0.0522f
C286 resistor_network_0.pb a_38480_11544# 0.38267f
C287 a_51802_10154# comparator_slice_0.comparator_body_0.outx 0.104f
C288 AVDD a_39830_20598# 1.33622f
C289 a_42432_11544# AVDD 1.33984f
C290 resistor_network_0.resistor_leg_0.pt a_39830_36216# 0.19811f
C291 resistor_network_0.p1 a_53873_39366# 0.24254f
C292 resistor_network_0.resistor_leg_3.p1 a_39560_39234# 0.16844f
C293 resistor_network_0.resistor_leg_2.p1 a_42162_36216# 0.1948f
C294 comparator_slice_1.comparator_body_0.outx a_50318_46017# 0.19162f
C295 a_41892_39234# resistor_network_0.resistor_leg_1.pt 0.28809f
C296 threshold a_53290_31074# 0.25569f
C297 a_53873_13155# vctrl 0.25354f
C298 AVDD a_39560_17580# 1.33134f
C299 a_42162_8526# AVDD 1.33134f
C300 a_57666_10268# ibias0 0.83215f
C301 a_51218_7644# comparator_slice_0.comparator_body_0.outx 0.20936f
C302 resistor_network_0.resistor_leg_3.p1 a_39290_36216# 0.22844f
C303 resistor_network_0.resistor_leg_0.pt a_39560_33198# 0.14031f
C304 resistor_network_0.resistor_leg_2.p1 a_41892_33198# 0.16894f
C305 resistor_network_0.p1 a_39020_39234# 0.05369f
C306 resistor_network_0.p1 a_53290_36464# 0.06849f
C307 comparator_slice_1.comparator_body_0.outx a_51802_44827# 0.19148f
C308 threshold a_54772_29834# 0.27049f
C309 a_53289_10675# vctrl 0.05769f
C310 a_60176_13955# a_62320_13955# 0.24012f
C311 a_50902_5264# comparator_slice_0.comparator_body_0.outx 0.10672f
C312 a_51802_22314# AVDD 0.22338f
C313 AVDD a_39290_14562# 1.33276f
C314 resistor_network_0.resistor_leg_0.pt a_39290_30180# 0.32442f
C315 resistor_network_0.resistor_leg_3.p1 a_39020_33198# 0.15772f
C316 a_38750_39234# a_39020_39234# 0.30437f
C317 resistor_network_0.p1 a_54772_35224# 0.05339f
C318 resistor_network_0.p1 a_38750_36216# 0.1294f
C319 resistor_network_0.resistor_leg_2.p1 a_41622_30180# 0.19648f
C320 threshold a_54186_27354# 0.0609f
C321 ibias1 a_57666_47199# 0.72802f
C322 a_39830_11544# a_40100_11544# 0.30437f
C323 a_60176_13955# a_61058_12138# 0.10837f
C324 a_54772_9435# vctrl 0.09261f
C325 a_53289_22687# comparator_slice_0.comparator_body_0.outx 0.25863f
C326 a_51218_19934# AVDD 0.24107f
C327 AVDD a_39020_11544# 1.33651f
C328 resistor_network_0.resistor_leg_3.p1 a_38750_30180# 0.09812f
C329 ibias1 comparator_slice_1.comparator_body_0.outx 0.18907f
C330 resistor_network_0.resistor_leg_0.p2 a_39020_20598# 0.05369f
C331 resistor_network_0.p1 a_54186_32744# 0.24252f
C332 resistor_network_0.p1 a_38480_33198# 0.0179f
C333 ibias1 a_57082_44819# 0.81425f
C334 comparator_slice_1.comparator_body_0.outx a_50318_42317# 0.07811f
C335 a_54186_6544# vctrl 0.24288f
C336 AVDD a_38750_8526# 1.33134f
C337 comparator_slice_1.comparator_body_0.outx a_54772_47217# 0.18066f
C338 a_50902_17424# AVDD 0.24955f
C339 ibias1 a_57666_42203# 0.72802f
C340 AVDD a_42432_39234# 1.33558f
C341 a_54772_21447# comparator_slice_0.comparator_body_0.outx 0.258f
C342 resistor_network_0.resistor_leg_0.p2 a_38750_17580# 0.1294f
C343 resistor_network_0.p1 a_53873_29834# 0.05337f
C344 resistor_network_0.resistor_leg_1.pt a_42702_33198# 0.0727f
C345 comparator_slice_1.comparator_body_0.outx a_51802_41127# 0.104f
C346 a_38480_36216# a_38750_36216# 0.30437f
C347 a_41082_36216# a_41352_36216# 0.30437f
C348 a_39560_8526# a_39830_8526# 0.30437f
C349 AVDD a_42162_36216# 1.38556f
C350 a_53873_4064# vctrl 0.06056f
C351 a_50318_15044# AVDD 0.21796f
C352 AVDD a_41352_23616# 1.33134f
C353 comparator_slice_1.comparator_body_0.outx a_54186_44737# 0.08298f
C354 ibias1 a_57082_39823# 0.81425f
C355 a_42162_17580# vctrl 0.19657f
C356 resistor_network_0.p1 a_53289_27354# 0.25432f
C357 resistor_network_0.resistor_leg_0.p2 a_38480_14562# 0.0179f
C358 comparator_slice_1.comparator_body_0.outx a_51218_38747# 0.20936f
C359 resistor_network_0.resistor_leg_1.pt a_42432_30180# 0.10801f
C360 AVDD a_41892_33198# 1.41679f
C361 a_53873_16057# comparator_slice_0.comparator_body_0.outx 0.08299f
C362 a_51802_13854# AVDD 0.23171f
C363 resistor_network_0.resistor_leg_0.pt a_39830_20598# 0.25598f
C364 a_41892_14562# vctrl 0.17087f
C365 a_53873_32744# a_54186_32744# 0.11313f
C366 vctrl a_41892_20598# 0.13504f
C367 a_40100_42246# a_41082_42246# 0.07769f
C368 a_38210_33198# a_38480_33198# 0.30437f
C369 comparator_slice_1.comparator_body_0.outx a_50902_36237# 0.10672f
C370 a_42162_23616# a_42432_23616# 0.30437f
C371 AVDD a_51802_46017# 0.22189f
C372 a_51218_11344# AVDD 0.2488f
C373 a_53289_13155# comparator_slice_0.comparator_body_0.outx 0.18271f
C374 comparator_slice_1.comparator_body_0.outx a_53289_39366# 0.25863f
C375 ibias1 a_57666_37207# 0.72802f
C376 AVDD a_41622_30180# 1.41499f
C377 resistor_network_0.resistor_leg_0.pt a_39560_17580# 0.09693f
C378 a_53873_9435# a_54186_9435# 0.11313f
C379 comparator_slice_1.comparator_body_0.outx resistor_network_0.p1 7.93003f
C380 vctrl a_39020_20598# 0.41099f
C381 a_41622_11544# vctrl 0.19648f
C382 a_60176_13955# reset_b 2.09223f
C383 comparator_slice_1.comparator_body_0.outx a_50318_33857# 0.19162f
C384 AVDD a_39830_23616# 1.33134f
C385 AVDD a_38750_42252# 1.33134f
C386 a_50902_8964# AVDD 0.24138f
C387 a_54772_11915# comparator_slice_0.comparator_body_0.outx 0.1814f
C388 comparator_slice_1.comparator_body_0.outx a_54772_38126# 0.25799f
C389 AVDD a_41352_27162# 1.33134f
C390 resistor_network_0.resistor_leg_0.pt a_39290_14562# 0.08403f
C391 vctrl ibias0 2.57516f
C392 a_40100_23610# a_41082_23610# 0.07769f
C393 vctrl a_38750_17580# 0.29404f
C394 comparator_slice_1.comparator_body_0.outx a_51802_32537# 0.1941f
C395 ibias1 trigger 1.19317f
C396 a_42702_33198# a_42972_33198# 0.30437f
C397 a_50318_6454# AVDD 0.22401f
C398 AVDD a_50318_43637# 0.23421f
C399 ibias1 a_56766_33637# 0.81535f
C400 resistor_network_0.resistor_leg_0.pt a_39020_11544# 0.04603f
C401 a_54186_9435# comparator_slice_0.comparator_body_0.outx 0.09117f
C402 vctrl a_38480_14562# 0.11493f
C403 comparator_slice_1.comparator_body_0.outx a_51218_30157# 0.10658f
C404 a_38750_23616# a_39020_23616# 0.30437f
C405 AVDD a_51802_42317# 0.2306f
C406 ibias1 a_56182_31021# 0.74584f
C407 a_51802_5264# AVDD 0.22189f
C408 a_40100_39234# a_41082_39234# 0.07769f
C409 comparator_slice_1.comparator_body_0.outx a_53873_32744# 0.08299f
C410 vctrl resistor_network_0.resistor_leg_1.pt 5.84098f
C411 AVDD resistor_network_0.resistor_leg_0.pt 16.4831f
C412 a_39830_30180# a_40100_30180# 0.30437f
C413 a_42432_30180# a_42702_30180# 0.30437f
C414 a_54186_21447# trigger 0.24249f
C415 a_41892_17580# resistor_network_0.resistor_leg_1.p2 0.2364f
C416 comparator_slice_1.comparator_body_0.outx a_53289_29834# 0.18262f
C417 AVDD a_51218_39937# 0.2488f
C418 a_53290_4064# comparator_slice_0.comparator_body_0.outx 0.2698f
C419 ibias1 a_57666_29831# 0.72692f
C420 resistor_network_0.p1 a_41892_39234# 0.05817f
C421 AVDD1V2 a_62350_39143# 0.33285f
C422 set_b comparator_slice_1.comparator_body_0.outx 0.01846f
C423 a_53873_18537# trigger 0.05337f
C424 a_41622_14562# resistor_network_0.resistor_leg_1.p2 0.13619f
C425 a_41622_20598# a_41892_20598# 0.30437f
C426 AVDD a_50902_37427# 0.24138f
C427 comparator_slice_1.comparator_body_0.outx a_54772_28594# 0.1814f
C428 a_41622_17580# a_41892_17580# 0.30437f
C429 a_39560_42252# a_39830_42252# 0.30437f
C430 a_39560_27162# a_39830_27162# 0.30437f
C431 a_53289_16057# trigger 0.25924f
C432 a_42162_27162# a_42432_27162# 0.30437f
C433 AVDD a_50318_35047# 0.22384f
C434 a_54772_14817# trigger 0.24262f
C435 a_51802_47207# comparator_slice_1.comparator_body_0.outx 0.20948f
C436 AVDD a_51802_33857# 0.24036f
C437 a_41352_14562# a_41622_14562# 0.30437f
C438 a_62350_12138# AVDD1V2 0.33285f
C439 AVDD a_39560_39234# 1.48282f
C440 a_54186_11915# trigger 0.05336f
C441 AVDD a_51218_31347# 0.24107f
C442 resistor_network_0.p1 a_42702_33198# 0.0179f
C443 a_56766_22640# ibias0 0.81535f
C444 a_42432_42252# a_42702_42252# 0.30437f
C445 a_53873_9435# trigger 0.24254f
C446 AVDD a_39290_36216# 1.38178f
C447 resistor_network_0.resistor_leg_1.pt a_41622_20598# 0.13682f
C448 threshold a_53289_45977# 0.05498f
C449 a_41082_11544# a_41352_11544# 0.30437f
C450 AVDD a_50902_28967# 0.24955f
C451 resistor_network_0.p1 a_42432_30180# 0.34222f
C452 a_41892_17580# resistor_network_0.pb 0.06101f
C453 set_b a_62320_37326# 0.19008f
C454 a_51218_21124# comparator_slice_0.comparator_body_0.outx 0.10658f
C455 a_56182_20260# ibias0 0.74584f
C456 AVDD a_39020_33198# 1.40861f
C457 a_53289_6544# trigger 0.06821f
C458 comparator_slice_1.comparator_body_0.outx a_60474_39143# 0.25632f
C459 threshold a_54772_44737# 0.1797f
C460 ibias1 vctrl 0.39976f
C461 a_41352_17580# resistor_network_0.resistor_leg_1.pt 0.0825f
C462 a_60176_13955# comparator_slice_0.comparator_body_0.outx 2.17064f
C463 a_41622_14562# resistor_network_0.pb 0.14031f
C464 a_57666_19070# ibias0 0.72802f
C465 a_50902_18744# comparator_slice_0.comparator_body_0.outx 0.21109f
C466 trigger comparator_slice_0.comparator_body_0.outx 8.05176f
C467 AVDD a_38750_30180# 1.33984f
C468 a_54772_5304# trigger 0.05339f
C469 a_53873_44737# a_54186_44737# 0.11313f
C470 a_60474_12138# comparator_slice_0.comparator_body_0.outx 0.25632f
C471 threshold a_54186_41846# 0.25371f
C472 a_38210_17580# a_38480_17580# 0.30437f
C473 a_41352_11544# resistor_network_0.pb 0.01183f
C474 a_50318_16234# comparator_slice_0.comparator_body_0.outx 0.10522f
C475 a_57082_16454# ibias0 0.81425f
C476 a_53873_21447# a_54186_21447# 0.11313f
C477 AVDD a_38480_27162# 1.33134f
C478 comparator_slice_1.comparator_body_0.outx a_61028_37326# 0.3017f
C479 resistor_network_0.p1 a_54186_47217# 0.05326f
C480 threshold a_53873_39366# 0.05182f
C481 a_56766_7652# ibias0 0.81535f
C482 a_54186_21447# vctrl 0.0522f
C483 resistor_network_0.pb a_38480_17580# 0.05228f
C484 a_42432_17580# AVDD 1.34725f
C485 a_51802_15044# comparator_slice_0.comparator_body_0.outx 0.10386f
C486 a_56766_14074# ibias0 0.7281f
C487 AVDD a_41082_42246# 1.56399f
C488 resistor_network_0.p1 a_53873_44737# 0.24254f
C489 threshold a_53290_36464# 0.25569f
C490 a_42702_8526# a_42972_8526# 0.30437f
C491 a_53873_18537# vctrl 0.25354f
C492 a_56182_5272# ibias0 0.74374f
C493 a_51218_12534# comparator_slice_0.comparator_body_0.outx 0.20936f
C494 a_42162_14562# AVDD 1.34056f
C495 AVDD a_42162_20598# 1.33134f
C496 resistor_network_0.p1 a_53290_41846# 0.06849f
C497 threshold a_54772_35224# 0.27049f
C498 a_57666_4082# ibias0 0.72802f
C499 AVDD a_41082_39234# 1.58506f
C500 a_53289_16057# vctrl 0.05769f
C501 a_60176_37898# a_60444_37326# 0.18937f
C502 a_41892_11544# AVDD 1.33134f
C503 a_50902_10154# comparator_slice_0.comparator_body_0.outx 0.10672f
C504 a_57082_11458# ibias0 0.81425f
C505 AVDD a_39290_20598# 1.33357f
C506 resistor_network_0.resistor_leg_3.p1 a_39020_39234# 0.41099f
C507 resistor_network_0.resistor_leg_0.pt a_39290_36216# 0.06101f
C508 resistor_network_0.p1 a_54772_40606# 0.05339f
C509 a_41622_39234# a_41892_39234# 0.30437f
C510 resistor_network_0.resistor_leg_2.p1 a_41622_36216# 0.28205f
C511 threshold a_54186_32744# 0.06079f
C512 a_39830_14562# a_40100_14562# 0.30437f
C513 resistor_network_0.pb a_39830_11544# 0.01183f
C514 a_54772_14817# vctrl 0.09261f
C515 a_56766_10268# ibias0 0.83223f
C516 a_41622_8526# AVDD 1.33134f
C517 AVDD a_39020_17580# 1.33454f
C518 a_50318_7644# comparator_slice_0.comparator_body_0.outx 0.19162f
C519 resistor_network_0.resistor_leg_0.pt a_39020_33198# 0.06919f
C520 resistor_network_0.resistor_leg_3.p1 a_38750_36216# 0.29404f
C521 comparator_slice_1.comparator_body_0.outx a_50902_44827# 0.19516f
C522 resistor_network_0.resistor_leg_2.p1 a_41352_33198# 0.1023f
C523 resistor_network_0.p1 a_54186_38126# 0.24252f
C524 threshold a_53873_29834# 0.24272f
C525 a_61028_13955# a_60176_13955# 0.10063f
C526 a_54186_11915# vctrl 0.24288f
C527 a_51802_6454# comparator_slice_0.comparator_body_0.outx 0.19148f
C528 AVDD a_38750_14562# 1.34951f
C529 a_50902_22314# AVDD 0.24955f
C530 resistor_network_0.resistor_leg_3.p1 a_38480_33198# 0.11493f
C531 resistor_network_0.resistor_leg_0.pt a_38750_30180# 0.10801f
C532 resistor_network_0.p1 a_53873_35224# 0.05337f
C533 resistor_network_0.resistor_leg_1.pt a_42702_39234# 0.03874f
C534 ibias1 a_56766_47199# 0.7281f
C535 a_39560_11544# a_39830_11544# 0.30437f
C536 a_53873_9435# vctrl 0.06065f
C537 a_51218_4074# comparator_slice_0.comparator_body_0.outx 0.09513f
C538 a_50318_19934# AVDD 0.21791f
C539 AVDD a_38480_11544# 1.34592f
C540 a_53289_23927# comparator_slice_0.comparator_body_0.outx 0.18188f
C541 resistor_network_0.p1 a_53289_32744# 0.25848f
C542 ibias1 a_56182_44819# 0.81417f
C543 comparator_slice_1.comparator_body_0.outx a_51218_43637# 0.20936f
C544 resistor_network_0.resistor_leg_1.pt a_42432_36216# 0.02932f
C545 a_53289_6544# vctrl 0.24476f
C546 a_51802_18744# AVDD 0.23146f
C547 ibias1 a_56766_42203# 0.7281f
C548 a_53873_21447# comparator_slice_0.comparator_body_0.outx 0.08299f
C549 AVDD a_38210_8526# 1.49752f
C550 vctrl resistor_network_0.resistor_leg_1.p2 8.44882f
C551 threshold comparator_slice_1.comparator_body_0.outx 10.7314f
C552 a_53873_35224# a_54186_35224# 0.11313f
C553 resistor_network_0.p1 a_39830_33198# 0.1983f
C554 resistor_network_0.p1 a_54772_31074# 0.24262f
C555 comparator_slice_1.comparator_body_0.outx a_50902_41127# 0.10672f
C556 a_38210_36216# a_38480_36216# 0.30437f
C557 resistor_network_0.resistor_leg_1.pt a_42162_33198# 0.06919f
C558 vctrl comparator_slice_0.comparator_body_0.outx 10.7314f
C559 a_39290_8526# a_39560_8526# 0.30437f
C560 a_54772_5304# vctrl 0.24749f
C561 a_51218_16234# AVDD 0.2488f
C562 AVDD a_41622_36216# 1.42827f
C563 ibias1 a_56182_39823# 0.81417f
C564 AVDD a_40100_8526# 1.56394f
C565 a_53289_18537# comparator_slice_0.comparator_body_0.outx 0.18269f
C566 comparator_slice_1.comparator_body_0.outx a_53289_44737# 0.25863f
C567 a_53873_11915# a_54186_11915# 0.11313f
C568 a_41622_17580# vctrl 0.28205f
C569 resistor_network_0.p1 a_54186_28594# 0.05336f
C570 resistor_network_0.resistor_leg_0.p2 resistor_network_0.pb 2.74865f
C571 resistor_network_0.resistor_leg_1.pt a_41892_30180# 0.32442f
C572 comparator_slice_1.comparator_body_0.outx a_50318_38747# 0.19162f
C573 resistor_network_0.p1 a_39560_30180# 0.0478f
C574 a_54772_17297# comparator_slice_0.comparator_body_0.outx 0.1814f
C575 AVDD a_41352_33198# 1.4299f
C576 ibias1 a_57666_38633# 0.81527f
C577 comparator_slice_1.comparator_body_0.outx a_54772_43497# 0.25799f
C578 AVDD a_42702_23616# 1.33134f
C579 resistor_network_0.resistor_leg_0.pt a_39290_20598# 0.1131f
C580 a_50902_13854# AVDD 0.24138f
C581 a_41352_14562# vctrl 0.10496f
C582 resistor_network_0.resistor_leg_0.p2 a_39830_14562# 0.1983f
C583 comparator_slice_1.comparator_body_0.outx a_51802_37427# 0.1941f
C584 a_42702_36216# a_42972_36216# 0.30437f
C585 a_41892_23616# a_42162_23616# 0.30437f
C586 AVDD a_50902_46017# 0.2495f
C587 a_50318_11344# AVDD 0.22379f
C588 a_54186_14817# comparator_slice_0.comparator_body_0.outx 0.09117f
C589 ibias1 a_56766_37207# 0.7281f
C590 AVDD a_41082_30180# 1.5824f
C591 resistor_network_0.resistor_leg_0.pt a_39020_17580# 0.05102f
C592 resistor_network_0.resistor_leg_0.p2 a_39560_11544# 0.0478f
C593 comparator_slice_1.comparator_body_0.outx a_51218_35047# 0.10658f
C594 AVDD a_39290_23616# 1.33134f
C595 AVDD a_38210_42252# 1.49271f
C596 a_51802_10154# AVDD 0.22421f
C597 AVDD a_42972_30180# 1.50711f
C598 comparator_slice_1.comparator_body_0.outx a_53873_38126# 0.08299f
C599 resistor_network_0.resistor_leg_0.pt a_38750_14562# 0.08551f
C600 comparator_slice_1.comparator_body_0.outx a_50902_32537# 0.21109f
C601 a_39830_33198# a_40100_33198# 0.30437f
C602 a_42432_33198# a_42702_33198# 0.30437f
C603 AVDD1V2 comparator_slice_1.comparator_body_0.outx 0.04409f
C604 a_51218_7644# AVDD 0.24138f
C605 a_53290_9435# comparator_slice_0.comparator_body_0.outx 0.26946f
C606 comparator_slice_1.comparator_body_0.outx a_53289_35224# 0.18347f
C607 ibias1 a_57666_34827# 0.72692f
C608 AVDD a_42702_27162# 1.33134f
C609 comparator_slice_1.comparator_body_0.outx a_50318_30157# 0.10522f
C610 vctrl resistor_network_0.pb 5.52412f
C611 a_41622_20598# resistor_network_0.resistor_leg_1.p2 0.26261f
C612 a_38480_23616# a_38750_23616# 0.30437f
C613 a_50902_5264# AVDD 0.2495f
C614 a_54772_7784# comparator_slice_0.comparator_body_0.outx 0.25799f
C615 AVDD a_50902_42317# 0.24138f
C616 ibias1 a_57082_32211# 0.81675f
C617 comparator_slice_1.comparator_body_0.outx a_54772_33984# 0.1814f
C618 vctrl a_39830_14562# 0.10496f
C619 a_39560_30180# a_39830_30180# 0.30437f
C620 a_42162_30180# a_42432_30180# 0.30437f
C621 comparator_slice_1.comparator_body_0.outx a_51802_28967# 0.07727f
C622 a_53289_21447# trigger 0.25924f
C623 a_54772_23927# comparator_slice_0.comparator_body_0.outx 0.25799f
C624 AVDD a_50318_39937# 0.22379f
C625 a_41352_17580# resistor_network_0.resistor_leg_1.p2 0.13538f
C626 ibias1 a_56766_29831# 0.727f
C627 comparator_slice_1.comparator_body_0.outx a_54186_31074# 0.09117f
C628 vctrl a_39560_11544# 0.19648f
C629 a_54772_20207# trigger 0.24262f
C630 AVDD a_51802_38747# 0.2401f
C631 a_41352_17580# a_41622_17580# 0.30437f
C632 a_39290_42252# a_39560_42252# 0.30437f
C633 a_39290_27162# a_39560_27162# 0.30437f
C634 a_41892_27162# a_42162_27162# 0.30437f
C635 a_54186_17297# trigger 0.05336f
C636 AVDD a_51218_36237# 0.24107f
C637 resistor_network_0.p1 a_42702_39234# 0.33801f
C638 a_60176_13955# AVDD1V2 3.87503f
C639 a_53873_14817# trigger 0.24254f
C640 a_50902_47207# comparator_slice_1.comparator_body_0.outx 0.21057f
C641 a_42702_11544# resistor_network_0.resistor_leg_1.p2 0.13689f
C642 a_41082_14562# a_41352_14562# 0.30437f
C643 AVDD a_50902_33857# 0.24955f
C644 resistor_network_0.p1 a_42432_36216# 0.1294f
C645 AVDD a_39020_39234# 1.45683f
C646 a_53289_11915# trigger 0.06821f
C647 AVDD a_50318_31347# 0.21791f
C648 resistor_network_0.p1 a_42162_33198# 0.26245f
C649 AVDD a_38750_36216# 1.39376f
C650 a_42162_42252# a_42432_42252# 0.30437f
C651 a_54772_10675# trigger 0.05339f
C652 a_53873_47217# a_54186_47217# 0.11313f
C653 AVDD a_51802_30157# 0.2148f
C654 threshold a_54186_47217# 0.25344f
C655 resistor_network_0.p1 a_41892_30180# 0.12153f
C656 a_41352_17580# resistor_network_0.pb 0.19811f
C657 a_57082_21450# ibias0 0.81425f
C658 a_50318_21124# comparator_slice_0.comparator_body_0.outx 0.10522f
C659 AVDD a_38480_33198# 1.50628f
C660 a_54186_7784# trigger 0.24252f
C661 a_60444_13955# comparator_slice_0.comparator_body_0.outx 0.24897f
C662 threshold a_53873_44737# 0.05182f
C663 trigger a_54186_23927# 0.24252f
C664 a_51802_19934# comparator_slice_0.comparator_body_0.outx 0.1038f
C665 a_56766_19070# ibias0 0.7281f
C666 AVDD a_38210_30180# 1.50718f
C667 a_53873_5304# trigger 0.05335f
C668 threshold a_53290_41846# 0.25569f
C669 a_42702_11544# a_42972_11544# 0.30437f
C670 threshold vctrl 1.69714f
C671 a_51218_17424# comparator_slice_0.comparator_body_0.outx 0.20936f
C672 a_56182_16454# ibias0 0.81417f
C673 AVDD a_40100_30180# 1.5824f
C674 resistor_network_0.p1 a_53290_47217# 0.05329f
C675 threshold a_54772_40606# 0.27049f
C676 a_42432_14562# resistor_network_0.resistor_leg_1.pt 0.08551f
C677 a_57666_9078# ibias0 0.72802f
C678 a_53289_21447# vctrl 0.05769f
C679 a_42702_11544# resistor_network_0.pb 0.38267f
C680 a_41892_17580# AVDD 1.33196f
C681 a_57666_15264# ibias0 0.83215f
C682 a_50902_15044# comparator_slice_0.comparator_body_0.outx 0.10672f
C683 AVDD a_39830_27162# 1.33134f
C684 resistor_network_0.resistor_leg_2.p1 a_41892_39234# 0.13154f
C685 resistor_network_0.p1 a_54772_45977# 0.05339f
C686 a_42162_11544# resistor_network_0.resistor_leg_1.pt 0.04603f
C687 threshold a_54186_38126# 0.06079f
C688 a_42432_8526# a_42702_8526# 0.30437f
C689 a_57082_6462# ibias0 0.81425f
C690 a_39830_17580# a_40100_17580# 0.30437f
C691 resistor_network_0.pb a_39830_17580# 0.19811f
C692 a_54772_20207# vctrl 0.09261f
C693 a_60176_37898# a_62934_39143# 0.31253f
C694 AVDD comparator_slice_1.comparator_body_0.outx 53.4353f
C695 a_41622_14562# AVDD 1.33361f
C696 a_38480_20598# resistor_network_0.pb 0.03874f
C697 a_50318_12534# comparator_slice_0.comparator_body_0.outx 0.19162f
C698 a_57082_12648# ibias0 0.7281f
C699 resistor_network_0.p1 a_54186_43497# 0.24252f
C700 threshold a_53873_35224# 0.24272f
C701 a_56766_4082# ibias0 0.7281f
C702 AVDD a_42702_42252# 1.33134f
C703 a_41352_11544# AVDD 1.34046f
C704 resistor_network_0.pb a_39560_14562# 0.14031f
C705 a_54186_17297# vctrl 0.24288f
C706 a_51802_11344# comparator_slice_0.comparator_body_0.outx 0.19148f
C707 a_56182_11458# ibias0 0.81417f
C708 AVDD a_38750_20598# 1.33509f
C709 resistor_network_0.resistor_leg_0.pt a_38750_36216# 0.02932f
C710 resistor_network_0.p1 a_53873_40606# 0.05337f
C711 a_53873_14817# vctrl 0.06065f
C712 a_39560_14562# a_39830_14562# 0.30437f
C713 a_51218_8964# comparator_slice_0.comparator_body_0.outx 0.09565f
C714 a_41082_8526# AVDD 1.56394f
C715 resistor_network_0.pb a_39290_11544# 0.32442f
C716 AVDD a_38480_17580# 1.36025f
C717 resistor_network_0.resistor_leg_0.pt a_38480_33198# 0.0727f
C718 comparator_slice_1.comparator_body_0.outx a_51802_46017# 0.104f
C719 resistor_network_0.p1 a_53289_38126# 0.25848f
C720 threshold a_54772_31074# 0.09261f
C721 AVDD a_61058_39143# 0.33544f
C722 a_40100_27162# a_41082_27162# 0.07769f
C723 a_53289_11915# vctrl 0.24476f
C724 a_50902_6454# comparator_slice_0.comparator_body_0.outx 0.19516f
C725 a_42972_8526# AVDD 1.49746f
C726 resistor_network_0.resistor_leg_0.pt a_38210_30180# 0.01655f
C727 AVDD a_38210_14562# 1.50718f
C728 resistor_network_0.resistor_leg_2.p1 a_42702_33198# 0.11493f
C729 a_53873_38126# a_54186_38126# 0.11313f
C730 resistor_network_0.p1 a_54772_36464# 0.24262f
C731 threshold a_54186_28594# 0.24288f
C732 a_39290_11544# a_39560_11544# 0.30437f
C733 AVDD a_41892_39234# 1.44733f
C734 a_54772_10675# vctrl 0.27049f
C735 a_50318_4074# comparator_slice_0.comparator_body_0.outx 0.0777f
C736 a_51218_21124# AVDD 0.2488f
C737 AVDD a_40100_14562# 1.5824f
C738 a_53873_14817# a_54186_14817# 0.11313f
C739 resistor_network_0.p1 a_54186_33984# 0.05336f
C740 resistor_network_0.resistor_leg_3.p1 a_39830_33198# 0.1023f
C741 resistor_network_0.resistor_leg_2.p1 a_42432_30180# 0.09812f
C742 resistor_network_0.resistor_leg_1.pt a_41892_36216# 0.06101f
C743 comparator_slice_1.comparator_body_0.outx a_50318_43637# 0.19162f
C744 resistor_network_0.p1 a_39560_36216# 0.09078f
C745 ibias1 a_57082_46009# 0.74383f
C746 a_60176_13955# AVDD 0.83211f
C747 a_54186_7784# vctrl 0.06079f
C748 a_50902_18744# AVDD 0.24138f
C749 AVDD trigger 2.31016f
C750 AVDD a_39830_11544# 1.34046f
C751 a_54772_22687# comparator_slice_0.comparator_body_0.outx 0.1814f
C752 ibias1 a_57666_43629# 0.81527f
C753 resistor_network_0.resistor_leg_3.p1 a_39560_30180# 0.19648f
C754 vctrl a_41352_20598# 0.31778f
C755 resistor_network_0.p1 a_53873_31074# 0.24254f
C756 resistor_network_0.p1 a_39290_33198# 0.22002f
C757 a_42702_39234# a_42972_39234# 0.30437f
C758 resistor_network_0.resistor_leg_1.pt a_41622_33198# 0.14031f
C759 comparator_slice_1.comparator_body_0.outx a_51802_42317# 0.19393f
C760 a_60474_12138# AVDD 0.32967f
C761 ibias1 a_56766_43629# 0.81535f
C762 vctrl a_54186_23927# 0.0609f
C763 a_39020_8526# a_39290_8526# 0.30437f
C764 a_53873_5304# vctrl 0.24262f
C765 a_50318_16234# AVDD 0.22384f
C766 AVDD a_41082_36216# 1.5824f
C767 ibias1 a_57082_41013# 0.74383f
C768 a_54186_20207# comparator_slice_0.comparator_body_0.outx 0.09117f
C769 AVDD a_39560_8526# 1.33134f
C770 resistor_network_0.p1 a_53289_28594# 0.06821f
C771 resistor_network_0.resistor_leg_0.p2 a_39560_17580# 0.09078f
C772 resistor_network_0.p1 a_39020_30180# 0.09085f
C773 a_38210_20598# a_38480_20598# 0.30437f
C774 comparator_slice_1.comparator_body_0.outx a_51218_39937# 0.10658f
C775 resistor_network_0.resistor_leg_1.pt a_41352_30180# 0.01183f
C776 ibias1 a_56766_38633# 0.81535f
C777 a_51802_15044# AVDD 0.22442f
C778 AVDD a_42972_36216# 1.50711f
C779 comparator_slice_1.comparator_body_0.outx a_53873_43497# 0.08299f
C780 AVDD a_42162_23616# 1.33134f
C781 resistor_network_0.p1 a_54772_27354# 0.05339f
C782 resistor_network_0.resistor_leg_0.p2 a_39290_14562# 0.22002f
C783 comparator_slice_1.comparator_body_0.outx a_50902_37427# 0.21109f
C784 a_39830_36216# a_40100_36216# 0.30437f
C785 a_42432_36216# a_42702_36216# 0.30437f
C786 a_41622_23616# a_41892_23616# 0.30437f
C787 AVDD a_42702_33198# 1.50628f
C788 a_53290_14817# comparator_slice_0.comparator_body_0.outx 0.26946f
C789 a_51218_12534# AVDD 0.24138f
C790 comparator_slice_1.comparator_body_0.outx a_53289_40606# 0.18347f
C791 a_42702_14562# vctrl 0.11493f
C792 vctrl a_42702_20598# 0.02874f
C793 resistor_network_0.resistor_leg_0.p2 a_39020_11544# 0.09085f
C794 comparator_slice_1.comparator_body_0.outx a_50318_35047# 0.10522f
C795 AVDD a_38750_23616# 1.33134f
C796 AVDD a_51218_44827# 0.2488f
C797 a_50902_10154# AVDD 0.2495f
C798 AVDD a_42432_30180# 1.33984f
C799 ibias1 a_57082_36017# 0.74383f
C800 a_54772_13155# comparator_slice_0.comparator_body_0.outx 0.25799f
C801 comparator_slice_1.comparator_body_0.outx a_54772_39366# 0.1814f
C802 a_42432_11544# vctrl 0.09812f
C803 a_39560_33198# a_39830_33198# 0.30437f
C804 vctrl a_39830_20598# 0.31778f
C805 comparator_slice_1.comparator_body_0.outx a_51802_33857# 0.07819f
C806 a_42162_33198# a_42432_33198# 0.30437f
C807 AVDD resistor_network_0.resistor_leg_0.p2 6.42628f
C808 AVDD a_39560_42252# 1.33134f
C809 ibias1 a_56766_34827# 0.727f
C810 a_50318_7644# AVDD 0.23421f
C811 AVDD a_42162_27162# 1.33134f
C812 comparator_slice_1.comparator_body_0.outx a_54186_36464# 0.09117f
C813 a_62934_12138# reset_b 0.10865f
C814 vctrl a_39560_17580# 0.28205f
C815 comparator_slice_1.comparator_body_0.outx a_51218_31347# 0.1953f
C816 a_41352_20598# a_41622_20598# 0.30437f
C817 a_53873_7784# comparator_slice_0.comparator_body_0.outx 0.08299f
C818 ibias1 a_56182_32211# 0.81667f
C819 AVDD a_51802_43637# 0.24123f
C820 resistor_network_0.resistor_leg_0.pt a_39830_11544# 0.21859f
C821 a_51802_6454# AVDD 0.21755f
C822 a_38210_23616# a_38480_23616# 0.30437f
C823 vctrl a_39290_14562# 0.17087f
C824 a_53873_28594# a_54186_28594# 0.11313f
C825 a_39290_30180# a_39560_30180# 0.30437f
C826 comparator_slice_1.comparator_body_0.outx a_50902_28967# 0.09366f
C827 a_41892_30180# a_42162_30180# 0.30437f
C828 a_54186_22687# trigger 0.05336f
C829 a_53873_23927# comparator_slice_0.comparator_body_0.outx 0.08299f
C830 ibias1 a_57666_31021# 0.83215f
C831 a_53289_5304# comparator_slice_0.comparator_body_0.outx 0.18347f
C832 AVDD a_51218_41127# 0.24107f
C833 comparator_slice_1.comparator_body_0.outx a_53290_31074# 0.2686f
C834 a_51218_4074# AVDD 0.24966f
C835 a_53873_5304# a_54186_5304# 0.11313f
C836 vctrl a_39020_11544# 0.35346f
C837 a_53873_20207# trigger 0.24254f
C838 AVDD a_50902_38747# 0.24955f
C839 a_42702_17580# resistor_network_0.resistor_leg_1.p2 0.12223f
C840 a_41082_17580# a_41352_17580# 0.30437f
C841 comparator_slice_1.comparator_body_0.outx a_54772_29834# 0.258f
C842 ibias1 a_57082_28641# 0.7281f
C843 a_54772_4064# comparator_slice_0.comparator_body_0.outx 0.18066f
C844 a_39020_42252# a_39290_42252# 0.30437f
C845 a_39020_27162# a_39290_27162# 0.30437f
C846 a_41622_27162# a_41892_27162# 0.30437f
C847 a_53289_17297# trigger 0.06821f
C848 AVDD vctrl 19.8427f
C849 a_42432_14562# resistor_network_0.resistor_leg_1.p2 0.14836f
C850 AVDD a_50318_36237# 0.21796f
C851 resistor_network_0.resistor_leg_1.p2 a_42432_20598# 0.12431f
C852 resistor_network_0.p1 a_42162_39234# 0.05369f
C853 AVDD a_38210_39234# 1.51544f
C854 a_54772_16057# trigger 0.05339f
C855 a_42162_11544# resistor_network_0.resistor_leg_1.p2 0.09085f
C856 AVDD a_51802_35047# 0.21738f
C857 resistor_network_0.p1 a_41892_36216# 0.2364f
C858 a_54186_13155# trigger 0.24252f
C859 resistor_network_0.resistor_leg_0.pt resistor_network_0.resistor_leg_0.p2 2.03515f
C860 AVDD a_51218_32537# 0.24966f
C861 resistor_network_0.p1 a_41622_33198# 0.13619f
C862 set_b a_62934_39143# 0.10865f
C863 a_41892_42252# a_42162_42252# 0.30437f
C864 AVDD a_38210_36216# 1.50718f
C865 a_53873_10675# trigger 0.05337f
C866 a_42702_14562# a_42972_14562# 0.30437f
C867 AVDD a_50902_30157# 0.2406f
C868 threshold a_53290_47217# 0.25325f
C869 a_56182_21450# ibias0 0.81417f
C870 a_51218_22314# comparator_slice_0.comparator_body_0.outx 0.20889f
C871 a_53289_7784# trigger 0.25848f
C872 AVDD a_40100_36216# 1.5824f
C873 threshold a_54772_45977# 0.24749f
C874 a_42702_17580# resistor_network_0.pb 0.05228f
C875 a_50902_19934# comparator_slice_0.comparator_body_0.outx 0.10672f
C876 a_57666_20260# ibias0 0.83215f
C877 AVDD a_39830_33198# 1.4299f
C878 a_54772_6544# trigger 0.22664f
C879 a_42162_17580# resistor_network_0.resistor_leg_1.pt 0.05102f
C880 threshold a_54186_43497# 0.06079f
C881 a_42432_11544# a_42702_11544# 0.30437f
C882 a_42432_14562# resistor_network_0.pb 0.14996f
C883 a_39830_20598# a_40100_20598# 0.30437f
C884 AVDD a_41622_20598# 1.33743f
C885 a_50318_17424# comparator_slice_0.comparator_body_0.outx 0.19162f
C886 a_57082_17644# ibias0 0.7281f
C887 a_54186_4064# trigger 0.05326f
C888 AVDD a_39560_30180# 1.41499f
C889 vctrl resistor_network_0.resistor_leg_0.pt 5.38236f
C890 a_41892_14562# resistor_network_0.resistor_leg_1.pt 0.08403f
C891 resistor_network_0.resistor_leg_1.pt a_41892_20598# 0.1131f
C892 threshold a_53873_40606# 0.24272f
C893 a_54186_22687# vctrl 0.24288f
C894 a_42162_11544# resistor_network_0.pb 0.08925f
C895 a_56766_9078# ibias0 0.7281f
C896 a_51802_16234# comparator_slice_0.comparator_body_0.outx 0.19148f
C897 a_41352_17580# AVDD 1.33589f
C898 a_56766_15264# ibias0 0.83223f
C899 resistor_network_0.p1 a_38480_39234# 0.33801f
C900 a_41352_39234# a_41622_39234# 0.30437f
C901 AVDD a_39290_27162# 1.33134f
C902 resistor_network_0.p1 a_53873_45977# 0.05335f
C903 a_41622_11544# resistor_network_0.resistor_leg_1.pt 0.07966f
C904 a_42162_8526# a_42432_8526# 0.30437f
C905 a_56182_6462# ibias0 0.81417f
C906 a_53873_20207# vctrl 0.06065f
C907 a_39560_17580# a_39830_17580# 0.30437f
C908 a_56182_12648# ibias0 0.72802f
C909 resistor_network_0.pb a_39290_17580# 0.06101f
C910 a_51218_13854# comparator_slice_0.comparator_body_0.outx 0.09565f
C911 a_41082_14562# AVDD 1.5824f
C912 AVDD a_51218_47207# 0.24966f
C913 a_38480_39234# a_38750_39234# 0.30437f
C914 resistor_network_0.p1 a_53289_43497# 0.25848f
C915 threshold a_54772_36464# 0.09261f
C916 a_40100_30180# a_41082_30180# 0.07769f
C917 AVDD a_42162_42252# 1.33134f
C918 a_57666_5272# ibias0 0.83215f
C919 resistor_network_0.pb a_39020_14562# 0.06919f
C920 a_53289_17297# vctrl 0.24476f
C921 a_42972_14562# AVDD 1.50711f
C922 a_50902_11344# comparator_slice_0.comparator_body_0.outx 0.19516f
C923 resistor_network_0.resistor_leg_2.p1 a_42702_39234# 0.02874f
C924 a_53873_40606# a_54186_40606# 0.11313f
C925 resistor_network_0.p1 a_54772_41846# 0.24262f
C926 threshold a_54186_33984# 0.24288f
C927 a_39290_14562# a_39560_14562# 0.30437f
C928 a_60176_37898# a_62904_37326# 0.3019f
C929 resistor_network_0.pb a_38750_11544# 0.11372f
C930 a_54772_16057# vctrl 0.27049f
C931 a_42702_11544# AVDD 1.34592f
C932 a_50318_8964# comparator_slice_0.comparator_body_0.outx 0.07811f
C933 AVDD a_40100_20598# 1.5824f
C934 a_53873_17297# a_54186_17297# 0.11313f
C935 resistor_network_0.resistor_leg_3.p1 a_39830_39234# 0.31682f
C936 comparator_slice_1.comparator_body_0.outx a_50902_46017# 0.10672f
C937 resistor_network_0.p1 a_54186_39366# 0.05336f
C938 resistor_network_0.resistor_leg_2.p1 a_42432_36216# 0.29404f
C939 threshold a_53873_31074# 0.06065f
C940 a_41082_8526# a_40100_8526# 0.07769f
C941 a_54186_13155# vctrl 0.06079f
C942 a_51802_7644# comparator_slice_0.comparator_body_0.outx 0.07809f
C943 a_42432_8526# AVDD 1.33134f
C944 AVDD a_39830_17580# 1.33589f
C945 a_56182_9078# ibias0 0.81667f
C946 resistor_network_0.resistor_leg_3.p1 a_39560_36216# 0.28205f
C947 AVDD a_38480_20598# 1.33867f
C948 resistor_network_0.resistor_leg_2.p1 a_42162_33198# 0.15772f
C949 resistor_network_0.p1 a_39290_39234# 0.05815f
C950 resistor_network_0.p1 a_53873_36464# 0.24254f
C951 threshold a_53289_28594# 0.24476f
C952 a_39020_11544# a_39290_11544# 0.30437f
C953 a_53873_10675# vctrl 0.24272f
C954 a_60176_13955# a_62904_13955# 0.3019f
C955 a_50318_21124# AVDD 0.22127f
C956 a_51218_5264# comparator_slice_0.comparator_body_0.outx 0.19529f
C957 AVDD a_39560_14562# 1.33361f
C958 resistor_network_0.resistor_leg_0.pt a_39560_30180# 0.04774f
C959 resistor_network_0.resistor_leg_2.p1 a_41892_30180# 0.05737f
C960 resistor_network_0.p1 a_53289_33984# 0.06821f
C961 resistor_network_0.resistor_leg_3.p1 a_39290_33198# 0.16894f
C962 resistor_network_0.resistor_leg_1.pt a_41352_36216# 0.19811f
C963 ibias1 a_56182_46009# 0.74374f
C964 resistor_network_0.p1 a_39020_36216# 0.23663f
C965 threshold a_54772_27354# 0.2837f
C966 a_60176_13955# a_62350_12138# 0.26078f
C967 AVDD a_39290_11544# 1.33134f
C968 a_51802_19934# AVDD 0.22437f
C969 resistor_network_0.resistor_leg_3.p1 a_39020_30180# 0.35346f
C970 resistor_network_0.p1 a_54772_32744# 0.05339f
C971 resistor_network_0.resistor_leg_0.p2 a_39290_20598# 0.05204f
C972 resistor_network_0.p1 a_38750_33198# 0.14836f
C973 a_39830_39234# a_40100_39234# 0.30437f
C974 ibias1 a_57666_44819# 0.72692f
C975 comparator_slice_1.comparator_body_0.outx a_50902_42317# 0.21109f
C976 a_42432_39234# a_42702_39234# 0.30437f
C977 a_38750_8526# a_39020_8526# 0.30437f
C978 a_54772_6544# vctrl 0.1797f
C979 AVDD a_42702_39234# 1.33867f
C980 a_51218_17424# AVDD 0.24138f
C981 AVDD a_39020_8526# 1.33134f
C982 ibias1 a_56182_41013# 0.74374f
C983 a_53290_20207# comparator_slice_0.comparator_body_0.outx 0.2686f
C984 comparator_slice_1.comparator_body_0.outx a_53289_45977# 0.18347f
C985 resistor_network_0.p1 a_38480_30180# 0.13689f
C986 resistor_network_0.resistor_leg_0.p2 a_39020_17580# 0.23663f
C987 resistor_network_0.p1 a_54186_29834# 0.24249f
C988 comparator_slice_1.comparator_body_0.outx a_50318_39937# 0.10522f
C989 a_54186_4064# vctrl 0.25344f
C990 ibias1 a_57666_39823# 0.72692f
C991 a_50902_15044# AVDD 0.2495f
C992 a_54772_18537# comparator_slice_0.comparator_body_0.outx 0.25799f
C993 AVDD a_42432_36216# 1.39376f
C994 AVDD a_41622_23616# 1.33134f
C995 comparator_slice_1.comparator_body_0.outx a_54772_44737# 0.1814f
C996 ibias1 ibias0 6.44169f
C997 a_42432_17580# vctrl 0.29404f
C998 resistor_network_0.resistor_leg_0.p2 a_38750_14562# 0.14836f
C999 a_39560_36216# a_39830_36216# 0.30437f
C1000 resistor_network_0.p1 a_53873_27354# 0.05337f
C1001 resistor_network_0.resistor_leg_1.pt a_42702_30180# 0.37645f
C1002 comparator_slice_1.comparator_body_0.outx a_51802_38747# 0.07819f
C1003 a_42162_36216# a_42432_36216# 0.30437f
C1004 a_41352_23616# a_41622_23616# 0.30437f
C1005 comparator_slice_1.comparator_body_0.outx a_54186_41846# 0.09117f
C1006 AVDD a_42162_33198# 1.40861f
C1007 a_50318_12534# AVDD 0.23311f
C1008 a_42162_14562# vctrl 0.16071f
C1009 vctrl a_42162_20598# 0.41099f
C1010 resistor_network_0.resistor_leg_0.p2 a_38480_11544# 0.13689f
C1011 comparator_slice_1.comparator_body_0.outx a_51218_36237# 0.1953f
C1012 AVDD a_38210_23616# 1.50718f
C1013 AVDD a_50318_44827# 0.22401f
C1014 a_53873_13155# comparator_slice_0.comparator_body_0.outx 0.08299f
C1015 AVDD a_41892_30180# 1.38329f
C1016 resistor_network_0.resistor_leg_0.pt a_39830_17580# 0.0825f
C1017 a_51802_11344# AVDD 0.21733f
C1018 ibias1 a_56182_36017# 0.74374f
C1019 a_62320_13955# reset_b 0.19008f
C1020 vctrl a_39290_20598# 0.13504f
C1021 a_41892_11544# vctrl 0.05737f
C1022 a_53873_31074# a_54186_31074# 0.11313f
C1023 comparator_slice_1.comparator_body_0.outx a_50902_33857# 0.09413f
C1024 a_39290_33198# a_39560_33198# 0.30437f
C1025 AVDD a_40100_23610# 1.5558f
C1026 a_41892_33198# a_42162_33198# 0.30437f
C1027 AVDD a_39020_42252# 1.33134f
C1028 AVDD a_41622_27162# 1.33134f
C1029 resistor_network_0.resistor_leg_0.pt a_39560_14562# 0.02531f
C1030 a_51218_8964# AVDD 0.24966f
C1031 a_53289_10675# comparator_slice_0.comparator_body_0.outx 0.18347f
C1032 comparator_slice_1.comparator_body_0.outx a_53290_36464# 0.26946f
C1033 a_53873_7784# a_54186_7784# 0.11313f
C1034 vctrl a_39020_17580# 0.19657f
C1035 comparator_slice_1.comparator_body_0.outx a_50318_31347# 0.19162f
C1036 a_41082_20598# a_41352_20598# 0.30437f
C1037 ibias1 a_57082_33637# 0.7281f
C1038 a_54772_9435# comparator_slice_0.comparator_body_0.outx 0.18066f
C1039 a_50902_6454# AVDD 0.2406f
C1040 AVDD a_50902_43637# 0.24955f
C1041 resistor_network_0.resistor_leg_0.pt a_39290_11544# 0.05194f
C1042 comparator_slice_1.comparator_body_0.outx a_54772_35224# 0.258f
C1043 a_39020_30180# a_39290_30180# 0.30437f
C1044 vctrl a_38750_14562# 0.07826f
C1045 comparator_slice_1.comparator_body_0.outx a_51802_30157# 0.19099f
C1046 a_41622_30180# a_41892_30180# 0.30437f
C1047 a_53289_22687# trigger 0.06821f
C1048 a_53873_23927# a_54186_23927# 0.11313f
C1049 a_50318_4074# AVDD 0.22363f
C1050 AVDD a_50318_41127# 0.21775f
C1051 ibias1 a_56766_31021# 0.83223f
C1052 a_54186_6544# comparator_slice_0.comparator_body_0.outx 0.08298f
C1053 a_54772_21447# trigger 0.05339f
C1054 a_42162_17580# resistor_network_0.resistor_leg_1.p2 0.23663f
C1055 a_39830_23616# a_40100_23610# 0.30369f
C1056 comparator_slice_1.comparator_body_0.outx a_53873_29834# 0.08299f
C1057 ibias1 a_56182_28641# 0.72989f
C1058 AVDD a_51802_39937# 0.21733f
C1059 resistor_network_0.p1 resistor_network_0.resistor_leg_1.pt 2.69712f
C1060 AVDD1V2 a_62934_39143# 0.34685f
C1061 a_38750_42252# a_39020_42252# 0.30437f
C1062 a_38750_27162# a_39020_27162# 0.30437f
C1063 a_41352_27162# a_41622_27162# 0.30437f
C1064 a_54186_18537# trigger 0.24252f
C1065 a_41892_14562# resistor_network_0.resistor_leg_1.p2 0.22002f
C1066 AVDD a_51218_37427# 0.24966f
C1067 resistor_network_0.resistor_leg_1.p2 a_41892_20598# 0.05204f
C1068 comparator_slice_1.comparator_body_0.outx a_53289_27354# 0.18188f
C1069 a_53873_16057# trigger 0.05337f
C1070 a_41622_11544# resistor_network_0.resistor_leg_1.p2 0.0478f
C1071 AVDD a_50902_35047# 0.2406f
C1072 a_42702_17580# a_42972_17580# 0.30437f
C1073 a_42972_20598# a_42702_20598# 0.30437f
C1074 resistor_network_0.p1 a_41352_36216# 0.13538f
C1075 a_41352_42252# a_41622_42252# 0.30437f
C1076 a_53289_13155# trigger 0.25848f
C1077 AVDD a_50318_32537# 0.23986f
C1078 ibias0 comparator_slice_0.comparator_body_0.outx 0.18908f
C1079 set_b a_60176_37898# 2.09223f
C1080 a_62934_12138# AVDD1V2 0.34685f
C1081 AVDD a_39830_39234# 1.58843f
C1082 a_54772_11915# trigger 0.22474f
C1083 a_42432_14562# a_42702_14562# 0.30437f
C1084 a_42432_20598# a_42702_20598# 0.30437f
C1085 AVDD a_51802_31347# 0.22437f
C1086 a_50318_22314# comparator_slice_0.comparator_body_0.outx 0.19262f
C1087 a_57082_22640# ibias0 0.7281f
C1088 a_54186_9435# trigger 0.05336f
C1089 AVDD a_39560_36216# 1.42827f
C1090 resistor_network_0.resistor_leg_1.pt resistor_network_0.resistor_leg_1.p2 2.03515f
C1091 threshold a_53873_45977# 0.24262f
C1092 AVDD a_51218_28967# 0.24138f
C1093 resistor_network_0.p1 a_42702_30180# 0.13689f
C1094 a_42162_17580# resistor_network_0.pb 0.12716f
C1095 set_b a_62904_37326# 0.10091f
C1096 a_51802_21124# comparator_slice_0.comparator_body_0.outx 0.19099f
C1097 a_41352_39234# resistor_network_0.resistor_leg_2.p1 0.31682f
C1098 a_56766_20260# ibias0 0.83223f
C1099 comparator_slice_1.comparator_body_0.outx a_61058_39143# 0.3131f
C1100 AVDD a_39290_33198# 1.41679f
C1101 a_53873_6544# trigger 0.24254f
C1102 a_42162_11544# a_42432_11544# 0.30437f
C1103 a_41622_17580# resistor_network_0.resistor_leg_1.pt 0.09693f
C1104 a_39560_20598# a_39830_20598# 0.30437f
C1105 resistor_network_0.pb a_41892_20598# 0.28809f
C1106 AVDD a_41082_20598# 1.5824f
C1107 a_41892_14562# resistor_network_0.pb 0.06469f
C1108 a_38480_39234# resistor_network_0.resistor_leg_3.p1 0.02874f
C1109 a_51218_18744# comparator_slice_0.comparator_body_0.outx 0.09565f
C1110 a_56182_17644# ibias0 0.72802f
C1111 AVDD a_39020_30180# 1.38254f
C1112 a_53290_4064# trigger 0.05329f
C1113 a_41352_14562# resistor_network_0.resistor_leg_1.pt 0.09503f
C1114 a_61058_12138# comparator_slice_0.comparator_body_0.outx 0.3131f
C1115 ibias1 resistor_network_0.p1 0.04274f
C1116 threshold a_54772_41846# 0.09261f
C1117 a_40100_33198# a_41082_33198# 0.07769f
C1118 a_41622_11544# resistor_network_0.pb 0.04774f
C1119 a_53289_22687# vctrl 0.24476f
C1120 a_42972_20598# AVDD 1.50711f
C1121 a_50902_16234# comparator_slice_0.comparator_body_0.outx 0.19516f
C1122 a_57666_16454# ibias0 0.72692f
C1123 AVDD a_38750_27162# 1.33134f
C1124 resistor_network_0.p1 a_54772_47217# 0.24262f
C1125 a_53873_43497# a_54186_43497# 0.11313f
C1126 threshold a_54186_39366# 0.24288f
C1127 a_41892_8526# a_42162_8526# 0.30437f
C1128 a_54772_21447# vctrl 0.27049f
C1129 a_57082_7652# ibias0 0.7281f
C1130 a_39290_17580# a_39560_17580# 0.30437f
C1131 AVDD a_50318_47207# 0.22747f
C1132 a_60474_39143# a_60176_37898# 0.20295f
C1133 a_42702_17580# AVDD 1.36025f
C1134 resistor_network_0.pb a_38750_17580# 0.02932f
C1135 a_57082_14074# ibias0 0.81675f
C1136 a_50318_13854# comparator_slice_0.comparator_body_0.outx 0.07811f
C1137 AVDD a_41352_42252# 1.33134f
C1138 a_53873_20207# a_54186_20207# 0.11313f
C1139 resistor_network_0.p1 a_54186_44737# 0.05336f
C1140 threshold a_53873_36464# 0.06065f
C1141 a_41082_11544# a_40100_11544# 0.07769f
C1142 a_54186_18537# vctrl 0.06079f
C1143 a_56766_5272# ibias0 0.83223f
C1144 resistor_network_0.pb a_38480_14562# 0.0727f
C1145 a_51802_12534# comparator_slice_0.comparator_body_0.outx 0.07819f
C1146 a_42432_14562# AVDD 1.34951f
C1147 AVDD a_42432_20598# 1.33509f
C1148 resistor_network_0.p1 a_53873_41846# 0.24254f
C1149 resistor_network_0.resistor_leg_2.p1 a_42162_39234# 0.41099f
C1150 threshold a_53289_33984# 0.24476f
C1151 a_39020_14562# a_39290_14562# 0.30437f
C1152 AVDD a_41352_39234# 1.58419f
C1153 resistor_network_0.resistor_leg_1.pt resistor_network_0.pb 0.67953f
C1154 resistor_network_0.pb a_38210_11544# 0.01655f
C1155 a_53873_16057# vctrl 0.24272f
C1156 a_57666_11458# ibias0 0.72692f
C1157 a_42162_11544# AVDD 1.33651f
C1158 a_60176_37898# a_61028_37326# 0.10063f
C1159 a_51218_10154# comparator_slice_0.comparator_body_0.outx 0.1953f
C1160 AVDD a_39560_20598# 1.33743f
C1161 resistor_network_0.resistor_leg_0.pt a_39560_36216# 0.06142f
C1162 resistor_network_0.resistor_leg_2.p1 a_41892_36216# 0.22844f
C1163 resistor_network_0.resistor_leg_3.p1 a_39290_39234# 0.13154f
C1164 resistor_network_0.p1 a_53289_39366# 0.06821f
C1165 threshold a_54772_32744# 0.27988f
C1166 a_41892_8526# AVDD 1.33134f
C1167 a_57082_10268# ibias0 0.74383f
C1168 AVDD a_39290_17580# 1.33196f
C1169 a_50902_7644# comparator_slice_0.comparator_body_0.outx 0.09413f
C1170 reset_b comparator_slice_0.comparator_body_0.outx 0.01846f
C1171 resistor_network_0.resistor_leg_0.pt a_39290_33198# 0.06469f
C1172 resistor_network_0.resistor_leg_2.p1 a_41622_33198# 0.16171f
C1173 resistor_network_0.p1 a_54772_38126# 0.05339f
C1174 resistor_network_0.resistor_leg_3.p1 a_39020_36216# 0.1948f
C1175 comparator_slice_1.comparator_body_0.outx a_51218_44827# 0.10658f
C1176 threshold a_54186_29834# 0.0522f
C1177 resistor_network_0.p1 a_38750_39234# 0.12949f
C1178 a_38750_11544# a_39020_11544# 0.30437f
C1179 a_54772_11915# vctrl 0.19107f
C1180 a_51218_22314# AVDD 0.24138f
C1181 a_50318_5264# comparator_slice_0.comparator_body_0.outx 0.19162f
C1182 AVDD a_39020_14562# 1.34056f
C1183 resistor_network_0.resistor_leg_0.pt a_39020_30180# 0.08253f
C1184 resistor_network_0.resistor_leg_3.p1 a_38750_33198# 0.07826f
C1185 resistor_network_0.p1 a_54186_35224# 0.24249f
C1186 resistor_network_0.p1 a_38480_36216# 0.12223f
C1187 resistor_network_0.resistor_leg_2.p1 a_41352_30180# 0.04257f
C1188 threshold a_53873_27354# 0.25363f
C1189 ibias1 a_57082_47199# 0.81675f
C1190 a_54186_9435# vctrl 0.25371f
C1191 a_60176_13955# a_60474_12138# 0.20295f
C1192 a_51802_4074# comparator_slice_0.comparator_body_0.outx 0.20948f
C1193 a_50902_19934# AVDD 0.2495f
C1194 AVDD a_38750_11544# 1.33984f
C1195 resistor_network_0.resistor_leg_0.p2 a_38750_20598# 0.12431f
C1196 a_39560_39234# a_39830_39234# 0.30437f
C1197 resistor_network_0.p1 a_53873_32744# 0.05337f
C1198 ibias1 a_56766_44819# 0.727f
C1199 a_42162_39234# a_42432_39234# 0.30437f
C1200 resistor_network_0.resistor_leg_1.pt a_42702_36216# 0.05228f
C1201 comparator_slice_1.comparator_body_0.outx a_51802_43637# 0.07809f
C1202 a_38480_8526# a_38750_8526# 0.30437f
C1203 a_53873_6544# vctrl 0.05182f
C1204 comparator_slice_1.comparator_body_0.outx a_54186_47217# 0.09117f
C1205 a_50318_17424# AVDD 0.23336f
C1206 AVDD a_42162_39234# 1.45346f
C1207 ibias1 a_57082_42203# 0.81675f
C1208 AVDD a_38480_8526# 1.33134f
C1209 resistor_network_0.p1 a_53289_29834# 0.25924f
C1210 resistor_network_0.resistor_leg_0.p2 a_38480_17580# 0.12223f
C1211 comparator_slice_1.comparator_body_0.outx a_51218_41127# 0.1953f
C1212 resistor_network_0.resistor_leg_1.pt a_42432_33198# 0.14996f
C1213 a_53290_4064# vctrl 0.25325f
C1214 AVDD a_41892_36216# 1.38178f
C1215 AVDD a_41082_23610# 1.5558f
C1216 ibias1 a_56766_39823# 0.727f
C1217 a_53873_18537# comparator_slice_0.comparator_body_0.outx 0.08299f
C1218 a_51802_16234# AVDD 0.21738f
C1219 a_41892_17580# vctrl 0.22969f
C1220 a_53873_33984# a_54186_33984# 0.11313f
C1221 resistor_network_0.p1 a_54772_28594# 0.22554f
C1222 comparator_slice_1.comparator_body_0.outx a_50902_38747# 0.09413f
C1223 resistor_network_0.resistor_leg_1.pt a_42162_30180# 0.08253f
C1224 a_39290_36216# a_39560_36216# 0.30437f
C1225 a_41892_36216# a_42162_36216# 0.30437f
C1226 a_41082_23610# a_41352_23616# 0.30369f
C1227 AVDD a_41622_33198# 1.35892f
C1228 a_51218_13854# AVDD 0.24966f
C1229 a_53289_16057# comparator_slice_0.comparator_body_0.outx 0.18347f
C1230 resistor_network_0.resistor_leg_0.pt a_39560_20598# 0.13682f
C1231 comparator_slice_1.comparator_body_0.outx a_53290_41846# 0.26946f
C1232 AVDD a_42972_23616# 1.50711f
C1233 threshold ibias0 0.04169f
C1234 a_41622_14562# vctrl 0.16171f
C1235 a_53873_10675# a_54186_10675# 0.11313f
C1236 comparator_slice_1.comparator_body_0.outx a_50318_36237# 0.19162f
C1237 AVDD a_51218_46017# 0.24107f
C1238 ibias1 a_57082_37207# 0.81675f
C1239 a_50902_11344# AVDD 0.2406f
C1240 a_54772_14817# comparator_slice_0.comparator_body_0.outx 0.18066f
C1241 AVDD a_41352_30180# 1.55905f
C1242 resistor_network_0.resistor_leg_0.pt a_39290_17580# 0.04982f
C1243 comparator_slice_1.comparator_body_0.outx a_54772_40606# 0.258f
C1244 a_41352_11544# vctrl 0.04257f
C1245 a_39020_33198# a_39290_33198# 0.30437f
C1246 vctrl a_38750_20598# 0.37132f
C1247 comparator_slice_1.comparator_body_0.outx a_51802_35047# 0.19148f
C1248 a_41622_33198# a_41892_33198# 0.30437f
C1249 AVDD a_39560_23616# 1.33134f
C1250 AVDD a_38480_42252# 1.33134f
C1251 resistor_network_0.resistor_leg_0.pt a_39020_14562# 0.06804f
C1252 a_50318_8964# AVDD 0.23898f
C1253 AVDD a_41082_27162# 1.56394f
C1254 a_54186_11915# comparator_slice_0.comparator_body_0.outx 0.08298f
C1255 vctrl a_38480_17580# 0.17395f
C1256 comparator_slice_1.comparator_body_0.outx a_51218_32537# 0.09565f
C1257 a_51802_7644# AVDD 0.24123f
C1258 AVDD a_42972_27162# 1.50711f
C1259 comparator_slice_1.comparator_body_0.outx a_53873_35224# 0.08299f
C1260 ibias1 a_56182_33637# 0.72802f
C1261 comparator_slice_1.comparator_body_0.outx a_50902_30157# 0.19515f
C1262 a_38750_30180# a_39020_30180# 0.30437f
C1263 a_41352_30180# a_41622_30180# 0.30437f
C1264 a_51218_5264# AVDD 0.24107f
C1265 a_53289_6544# comparator_slice_0.comparator_body_0.outx 0.25863f
C1266 AVDD a_51218_42317# 0.24966f
C1267 trigger a_53289_23927# 0.25432f
C1268 ibias1 a_57666_32211# 0.72802f
C1269 comparator_slice_1.comparator_body_0.outx a_53289_32744# 0.18269f
C1270 AVDD a_38480_39234# 1.33867f
C1271 a_53873_21447# trigger 0.05337f
C1272 a_41622_17580# resistor_network_0.resistor_leg_1.p2 0.09078f
C1273 AVDD a_50902_39937# 0.2406f
C1274 ibias1 a_57082_29831# 0.81425f
C1275 a_39560_23616# a_39830_23616# 0.30437f
C1276 a_54772_5304# comparator_slice_0.comparator_body_0.outx 0.258f
C1277 comparator_slice_1.comparator_body_0.outx a_54772_31074# 0.18066f
C1278 resistor_network_0.p1 a_41622_39234# 0.269f
C1279 a_38480_42252# a_38750_42252# 0.30437f
C1280 vctrl trigger 13.9425f
C1281 AVDD1V2 a_60176_37898# 3.86417f
C1282 a_38480_27162# a_38750_27162# 0.30437f
C1283 vctrl a_39830_11544# 0.04257f
C1284 a_41082_27162# a_41352_27162# 0.30437f
C1285 a_53289_18537# trigger 0.25848f
C1286 a_41352_14562# resistor_network_0.resistor_leg_1.p2 0.1983f
C1287 comparator_slice_1.comparator_body_0.outx a_54186_28594# 0.08298f
C1288 AVDD a_50318_37427# 0.24012f
C1289 a_54772_17297# trigger 0.2254f
C1290 a_42432_17580# a_42702_17580# 0.30437f
C1291 AVDD a_51802_36237# 0.22442f
C1292 a_41082_42246# a_41352_42252# 0.30369f
C1293 a_54186_14817# trigger 0.05336f
C1294 a_51218_47207# comparator_slice_1.comparator_body_0.outx 0.09513f
C1295 AVDD a_51218_33857# 0.24138f
C1296 resistor_network_0.p1 a_42702_36216# 0.12223f
C1297 AVDD a_39290_39234# 1.4653f
C1298 a_53873_11915# trigger 0.24254f
C1299 AVDD a_50902_31347# 0.2495f
C1300 a_42162_14562# a_42432_14562# 0.30437f
C1301 a_42162_20598# a_42432_20598# 0.30437f
C1302 resistor_network_0.p1 a_42432_33198# 0.14836f
C1303 threshold ibias1 3.02565f
C1304 resistor_network_0.pb resistor_network_0.resistor_leg_1.p2 2.74865f
C1305 a_56182_22640# ibias0 0.72989f
C1306 AVDD a_39020_36216# 1.38556f
C1307 a_53290_9435# trigger 0.06849f
C1308 resistor_network_0.resistor_leg_1.pt a_41352_20598# 0.25598f
C1309 vctrl resistor_network_0.resistor_leg_0.p2 8.44882f
C1310 AVDD a_50318_28967# 0.21688f
C1311 threshold a_54772_47217# 0.06676f
C1312 a_40100_36216# a_41082_36216# 0.07769f
C1313 a_41622_17580# resistor_network_0.pb 0.06142f
C1314 resistor_network_0.p1 a_42162_30180# 0.09085f
C1315 a_38480_39234# resistor_network_0.resistor_leg_0.pt 0.03874f
C1316 a_57666_21450# ibias0 0.72692f
C1317 a_50902_21124# comparator_slice_0.comparator_body_0.outx 0.19515f
C1318 a_41082_39234# a_41352_39234# 0.30437f
C1319 a_54772_7784# trigger 0.05339f
C1320 AVDD a_38750_33198# 1.43502f
C1321 a_53873_45977# a_54186_45977# 0.11313f
C1322 threshold a_54186_44737# 0.24288f
C1323 a_40100_42246# a_39830_42252# 0.30369f
C1324 a_61028_13955# comparator_slice_0.comparator_body_0.outx 0.3017f
C1325 a_41892_11544# a_42162_11544# 0.30437f
C1326 a_39290_20598# a_39560_20598# 0.30437f
C1327 a_50318_18744# comparator_slice_0.comparator_body_0.outx 0.07811f
C1328 a_57082_19070# ibias0 0.81675f
C1329 trigger a_54772_23927# 0.05339f
C1330 a_53873_22687# a_54186_22687# 0.11313f
C1331 a_54186_5304# trigger 0.24247f
C1332 AVDD a_38480_30180# 1.34592f
C1333 threshold a_53873_41846# 0.06065f
C1334 a_41082_14562# a_40100_14562# 0.07769f
C1335 a_38480_20598# a_38750_20598# 0.30437f
C1336 a_51802_17424# comparator_slice_0.comparator_body_0.outx 0.07819f
C1337 a_56766_16454# ibias0 0.727f
C1338 comparator_slice_1.comparator_body_0.outx a_60444_37326# 0.24897f
C1339 resistor_network_0.p1 a_53873_47217# 0.24243f
C1340 AVDD a_38210_27162# 1.50718f
C1341 a_42702_14562# resistor_network_0.resistor_leg_1.pt 0.13568f
C1342 AVDD1V2 reset_b 1.19598f
C1343 threshold a_53289_39366# 0.24476f
C1344 a_41622_8526# a_41892_8526# 0.30437f
C1345 threshold resistor_network_0.p1 11.213f
C1346 a_56182_7652# ibias0 0.72802f
C1347 a_39020_17580# a_39290_17580# 0.30437f
C1348 a_53873_21447# vctrl 0.24272f
C1349 a_42972_11544# resistor_network_0.pb 0.01655f
C1350 a_42162_17580# AVDD 1.33454f
C1351 a_51218_15044# comparator_slice_0.comparator_body_0.outx 0.1953f
C1352 a_56182_14074# ibias0 0.81806f
C1353 AVDD a_40100_27162# 1.56394f
C1354 resistor_network_0.p1 a_53289_44737# 0.06821f
C1355 resistor_network_0.resistor_leg_2.p1 resistor_network_0.resistor_leg_1.pt 2.6752f
C1356 threshold a_54772_38126# 0.27988f
C1357 a_57666_6462# ibias0 0.72692f
C1358 a_41892_14562# AVDD 1.33276f
C1359 a_57666_12648# ibias0 0.81527f
C1360 AVDD a_41892_20598# 1.33357f
C1361 a_50902_12534# comparator_slice_0.comparator_body_0.outx 0.09413f
C1362 resistor_network_0.resistor_leg_0.pt a_39290_39234# 0.28809f
C1363 resistor_network_0.p1 resistor_network_0.resistor_leg_3.p1 8.66624f
C1364 resistor_network_0.p1 a_54772_43497# 0.05339f
C1365 threshold a_54186_35224# 0.0522f
C1366 a_38750_14562# a_39020_14562# 0.30437f
C1367 a_57082_4082# ibias0 0.81675f
C1368 a_54772_17297# vctrl 0.18752f
C1369 AVDD a_42972_42252# 1.49271f
C1370 a_41622_11544# AVDD 1.33532f
C1371 a_50318_10154# comparator_slice_0.comparator_body_0.outx 0.19162f
C1372 AVDD a_39020_20598# 1.33134f
C1373 a_56766_11458# ibias0 0.727f
C1374 resistor_network_0.resistor_leg_3.p1 a_38750_39234# 0.37132f
C1375 resistor_network_0.resistor_leg_0.pt a_39020_36216# 0.12716f
C1376 resistor_network_0.resistor_leg_2.p1 a_41352_36216# 0.02314f
C1377 resistor_network_0.p1 a_54186_40606# 0.24249f
C1378 threshold a_53873_32744# 0.25354f
C1379 AVDD ibias0 0.85291f
C1380 a_54186_14817# vctrl 0.25371f
C1381 a_51802_8964# comparator_slice_0.comparator_body_0.outx 0.19393f
C1382 a_41352_8526# AVDD 1.33134f
C1383 resistor_network_0.pb a_39560_11544# 0.04774f
C1384 a_56182_10268# ibias0 0.74374f
C1385 AVDD a_38750_17580# 1.34725f
C1386 resistor_network_0.resistor_leg_0.pt a_38750_33198# 0.14996f
C1387 resistor_network_0.p1 a_53873_38126# 0.05337f
C1388 comparator_slice_1.comparator_body_0.outx a_50318_44827# 0.10522f
C1389 resistor_network_0.resistor_leg_3.p1 a_38480_36216# 0.17395f
C1390 threshold a_53289_29834# 0.05769f
C1391 AVDD a_60176_37898# 0.83211f
C1392 a_60444_13955# a_60176_13955# 0.18937f
C1393 a_38480_11544# a_38750_11544# 0.30437f
C1394 a_53873_11915# vctrl 0.05182f
C1395 a_51218_6454# comparator_slice_0.comparator_body_0.outx 0.10658f
C1396 threshold set_b 1.32443f
C1397 AVDD a_38480_14562# 1.37061f
C1398 a_50318_22314# AVDD 0.21688f
C1399 resistor_network_0.resistor_leg_0.pt a_38480_30180# 0.37645f
C1400 resistor_network_0.p1 a_53289_35224# 0.25924f
C1401 ibias1 a_56182_47199# 0.81895f
C1402 threshold a_54772_28594# 0.18708f
C1403 AVDD resistor_network_0.resistor_leg_1.pt 16.4362f
C1404 a_53290_9435# vctrl 0.25569f
C1405 AVDD a_38210_11544# 1.50718f
C1406 a_50902_4074# comparator_slice_0.comparator_body_0.outx 0.21057f
C1407 a_51802_21124# AVDD 0.2148f
C1408 a_53873_36464# a_54186_36464# 0.11313f
C1409 resistor_network_0.p1 a_39830_36216# 0.13538f
C1410 a_39290_39234# a_39560_39234# 0.30437f
C1411 resistor_network_0.p1 a_54772_33984# 0.2254f
C1412 comparator_slice_1.comparator_body_0.outx a_50902_43637# 0.09413f
C1413 ibias1 a_57666_46009# 0.83215f
C1414 resistor_network_0.resistor_leg_1.pt a_42162_36216# 0.12716f
C1415 a_54772_7784# vctrl 0.27988f
C1416 a_38210_8526# a_38480_8526# 0.30437f
C1417 ibias1 a_56182_42203# 0.81667f
C1418 a_51218_18744# AVDD 0.24966f
C1419 a_53289_21447# comparator_slice_0.comparator_body_0.outx 0.18262f
C1420 AVDD a_40100_11544# 1.5824f
C1421 vctrl a_41622_20598# 0.17262f
C1422 comparator_slice_1.comparator_body_0.outx a_53290_47217# 0.2698f
C1423 a_53873_13155# a_54186_13155# 0.11313f
C1424 resistor_network_0.resistor_leg_3.p1 a_39830_30180# 0.04257f
C1425 resistor_network_0.p1 a_39560_33198# 0.13619f
C1426 resistor_network_0.p1 a_54186_31074# 0.05336f
C1427 resistor_network_0.resistor_leg_1.pt a_41892_33198# 0.06469f
C1428 ibias1 a_57082_43629# 0.7281f
C1429 comparator_slice_1.comparator_body_0.outx a_50318_41127# 0.19162f
C1430 a_61058_12138# AVDD 0.33544f
C1431 vctrl a_54772_23927# 0.2837f
C1432 a_54186_5304# vctrl 0.05196f
C1433 a_50902_16234# AVDD 0.2406f
C1434 AVDD a_41352_36216# 1.41839f
C1435 ibias1 a_57666_41013# 0.83215f
C1436 a_54772_20207# comparator_slice_0.comparator_body_0.outx 0.18066f
C1437 comparator_slice_1.comparator_body_0.outx a_54772_45977# 0.258f
C1438 AVDD a_39830_8526# 1.33134f
C1439 resistor_network_0.p1 a_53873_28594# 0.24254f
C1440 resistor_network_0.resistor_leg_0.p2 a_39830_17580# 0.13538f
C1441 a_41352_17580# vctrl 0.02314f
C1442 comparator_slice_1.comparator_body_0.outx a_51802_39937# 0.19148f
C1443 a_39020_36216# a_39290_36216# 0.30437f
C1444 resistor_network_0.p1 a_39290_30180# 0.12153f
C1445 resistor_network_0.resistor_leg_0.p2 a_38480_20598# 0.3271f
C1446 resistor_network_0.resistor_leg_1.pt a_41622_30180# 0.04774f
C1447 a_41622_36216# a_41892_36216# 0.30437f
C1448 resistor_network_0.resistor_leg_0.pt a_39020_20598# 0.12211f
C1449 ibias1 a_57082_38633# 0.7281f
C1450 AVDD a_42432_23616# 1.33134f
C1451 a_50318_13854# AVDD 0.24012f
C1452 AVDD a_41082_33198# 1.5824f
C1453 a_54186_17297# comparator_slice_0.comparator_body_0.outx 0.08298f
C1454 AVDD1V2 set_b 1.26064f
C1455 resistor_network_0.resistor_leg_0.p2 a_39560_14562# 0.13619f
C1456 comparator_slice_1.comparator_body_0.outx a_51218_37427# 0.09565f
C1457 AVDD a_50318_46017# 0.21543f
C1458 AVDD a_42972_33198# 1.50711f
C1459 resistor_network_0.resistor_leg_0.pt a_38750_17580# 0.04651f
C1460 AVDD1V2 comparator_slice_0.comparator_body_0.outx 0.0995f
C1461 comparator_slice_1.comparator_body_0.outx a_53873_40606# 0.08299f
C1462 a_51802_12534# AVDD 0.2401f
C1463 ibias1 a_56182_37207# 0.81806f
C1464 resistor_network_0.resistor_leg_0.p2 a_39290_11544# 0.12153f
C1465 a_38750_33198# a_39020_33198# 0.30437f
C1466 a_41352_33198# a_41622_33198# 0.30437f
C1467 comparator_slice_1.comparator_body_0.outx a_50902_35047# 0.19516f
C1468 AVDD a_39020_23616# 1.33134f
C1469 threshold resistor_network_0.pb 0.23173f
C1470 a_42702_23616# a_42972_23616# 0.30437f
C1471 AVDD a_51802_44827# 0.21755f
C1472 AVDD a_42702_30180# 1.34592f
C1473 a_51218_10154# AVDD 0.24107f
C1474 ibias1 a_57666_36017# 0.83215f
C1475 a_53289_11915# comparator_slice_0.comparator_body_0.outx 0.25863f
C1476 comparator_slice_1.comparator_body_0.outx a_53289_38126# 0.18271f
C1477 resistor_network_0.resistor_leg_0.pt a_38480_14562# 0.13568f
C1478 comparator_slice_1.comparator_body_0.outx a_50318_32537# 0.07811f
C1479 resistor_network_0.resistor_leg_0.pt resistor_network_0.resistor_leg_1.pt 0.18554f
C1480 AVDD a_39830_42252# 1.33134f
C1481 a_54772_10675# comparator_slice_0.comparator_body_0.outx 0.258f
C1482 ibias1 a_57082_34827# 0.81425f
C1483 comparator_slice_1.comparator_body_0.outx a_54772_36464# 0.18066f
C1484 AVDD a_42432_27162# 1.33134f
C1485 resistor_network_0.p1 resistor_network_0.resistor_leg_2.p1 8.66854f
C1486 a_50902_7644# AVDD 0.24955f
C1487 AVDD reset_b 0.03353f
C1488 vctrl a_39830_17580# 0.02314f
C1489 comparator_slice_1.comparator_body_0.outx a_51802_31347# 0.1038f
C1490 vctrl a_38480_20598# 0.02874f
C1491 a_38480_30180# a_38750_30180# 0.30437f
C1492 a_41082_30180# a_41352_30180# 0.30437f
C1493 AVDD ibias1 1.37266f
C1494 ibias1 a_56766_32211# 0.7281f
C1495 comparator_slice_1.comparator_body_0.outx a_54186_33984# 0.08298f
C1496 AVDD a_50318_42317# 0.23898f
C1497 a_50318_5264# AVDD 0.21543f
C1498 vctrl a_39560_14562# 0.16171f
C1499 comparator_slice_1.comparator_body_0.outx a_51218_28967# 0.20889f
C1500 a_54772_22687# trigger 0.22554f
C1501 a_39290_23616# a_39560_23616# 0.30437f
C1502 a_51802_4074# AVDD 0.21562f
C1503 AVDD a_51802_41127# 0.22421f
C1504 a_53873_5304# comparator_slice_0.comparator_body_0.outx 0.08299f
C1505 ibias1 a_56182_29831# 0.81417f
C1506 a_38210_42252# a_38480_42252# 0.30437f
C1507 a_53873_27354# a_54186_27354# 0.11313f
C1508 vctrl a_39290_11544# 0.05737f
C1509 a_38210_27162# a_38480_27162# 0.30437f
C1510 a_54186_20207# trigger 0.05336f
C1511 AVDD a_51218_38747# 0.24138f
C1512 ibias1 a_57666_28641# 0.81527f
C1513 a_53873_4064# a_54186_4064# 0.11313f
C1514 comparator_slice_1.comparator_body_0.outx a_53289_28594# 0.25863f
C1515 a_53873_17297# trigger 0.24254f
C1516 a_42702_14562# resistor_network_0.resistor_leg_1.p2 0.0179f
C1517 resistor_network_0.resistor_leg_1.p2 a_42702_20598# 0.3271f
C1518 a_42162_17580# a_42432_17580# 0.30437f
C1519 AVDD a_50902_36237# 0.2495f
C1520 comparator_slice_1.comparator_body_0.outx a_54772_27354# 0.25799f
C1521 resistor_network_0.p1 a_42432_39234# 0.12949f
C1522 a_42702_27162# a_42972_27162# 0.30437f
C1523 a_53290_14817# trigger 0.06849f
C1524 AVDD resistor_network_0.p1 24.6668f
C1525 a_50318_47207# comparator_slice_1.comparator_body_0.outx 0.0777f
C1526 a_42432_11544# resistor_network_0.resistor_leg_1.p2 0.34222f
C1527 AVDD a_50318_33857# 0.23336f
C1528 resistor_network_0.p1 a_42162_36216# 0.23663f
C1529 AVDD a_38750_39234# 1.33741f
C1530 a_54772_13155# trigger 0.05339f
C1531 AVDD a_51802_32537# 0.23146f
C1532 a_41892_14562# a_42162_14562# 0.30437f
C1533 a_41892_20598# a_42162_20598# 0.30437f
C1534 resistor_network_0.p1 a_41892_33198# 0.22002f
C1535 a_54186_10675# trigger 0.24249f
C1536 AVDD a_38480_36216# 1.36025f
C1537 AVDD a_51218_30157# 0.2488f
C1538 threshold a_53873_47217# 0.06056f
C1539 a_41082_17580# a_40100_17580# 0.07769f
C1540 reset_b AVSS 18.8114f
C1541 ibias0 AVSS 0.15619p
C1542 trigger AVSS 76.6049f
C1543 vctrl AVSS 89.9194f
C1544 set_b AVSS 49.83212f
C1545 ibias1 AVSS 0.15322p
C1546 threshold AVSS 82.42891f
C1547 AVDD1V2 AVSS 59.57172f
C1548 AVDD AVSS 0.2822p
C1549 a_57666_4082# AVSS 0.21587f
C1550 a_57082_4082# AVSS 0.24651f
C1551 a_56766_4082# AVSS 0.79978f
C1552 a_56182_4082# AVSS 0.23331f
C1553 a_57666_5272# AVSS 0.77855f
C1554 a_57082_5272# AVSS 0.79575f
C1555 a_56766_5272# AVSS 0.24881f
C1556 a_56182_5272# AVSS 0.78292f
C1557 a_57666_6462# AVSS 0.77505f
C1558 a_57082_6462# AVSS 0.80466f
C1559 a_56766_6462# AVSS 0.24107f
C1560 a_56182_6462# AVSS 0.23459f
C1561 a_57666_7652# AVSS 0.23775f
C1562 a_57082_7652# AVSS 0.23885f
C1563 a_56766_7652# AVSS 0.80806f
C1564 a_56182_7652# AVSS 0.79603f
C1565 a_57666_9078# AVSS 0.78908f
C1566 a_57082_9078# AVSS 0.8061f
C1567 a_56766_9078# AVSS 0.8004f
C1568 a_56182_9078# AVSS 0.24793f
C1569 a_57666_10268# AVSS 0.22237f
C1570 a_57082_10268# AVSS 0.23735f
C1571 a_56766_10268# AVSS 0.24881f
C1572 a_56182_10268# AVSS 0.78574f
C1573 a_62350_12138# AVSS 3.27182f
C1574 a_61058_12138# AVSS 0.69409f
C1575 a_60474_12138# AVSS 0.69397f
C1576 a_57666_11458# AVSS 0.77503f
C1577 a_57082_11458# AVSS 0.24625f
C1578 a_56766_11458# AVSS 0.79948f
C1579 a_56182_11458# AVSS 0.23526f
C1580 a_62904_13955# AVSS 0.34815f
C1581 a_62320_13955# AVSS 0.35868f
C1582 a_61028_13955# AVSS 1.04487f
C1583 a_60444_13955# AVSS 1.05039f
C1584 a_57666_12648# AVSS 0.23766f
C1585 a_57082_12648# AVSS 0.79787f
C1586 a_56766_12648# AVSS 0.24966f
C1587 a_56182_12648# AVSS 0.79695f
C1588 a_57666_14074# AVSS 0.78917f
C1589 a_57082_14074# AVSS 0.24708f
C1590 a_56766_14074# AVSS 0.8004f
C1591 a_56182_14074# AVSS 0.24679f
C1592 a_57666_15264# AVSS 0.22239f
C1593 a_57082_15264# AVSS 0.79575f
C1594 a_56766_15264# AVSS 0.24881f
C1595 a_56182_15264# AVSS 0.78635f
C1596 a_57666_16454# AVSS 0.21664f
C1597 a_57082_16454# AVSS 0.24625f
C1598 a_56766_16454# AVSS 0.24107f
C1599 a_56182_16454# AVSS 0.23457f
C1600 a_57666_17644# AVSS 0.79616f
C1601 a_57082_17644# AVSS 0.79726f
C1602 a_56766_17644# AVSS 0.80806f
C1603 a_56182_17644# AVSS 0.79699f
C1604 a_57666_19070# AVSS 0.78908f
C1605 a_57082_19070# AVSS 0.24707f
C1606 a_56766_19070# AVSS 0.8004f
C1607 a_56182_19070# AVSS 0.24673f
C1608 a_57666_20260# AVSS 0.22237f
C1609 a_57082_20260# AVSS 0.79638f
C1610 a_56766_20260# AVSS 0.24881f
C1611 a_56182_20260# AVSS 0.78515f
C1612 a_57666_21450# AVSS 0.21438f
C1613 a_57082_21450# AVSS 0.24625f
C1614 a_56766_21450# AVSS 0.24107f
C1615 a_56182_21450# AVSS 0.23231f
C1616 a_57666_22640# AVSS 0.78186f
C1617 a_57082_22640# AVSS 0.79668f
C1618 a_56766_22640# AVSS 0.80806f
C1619 a_56182_22640# AVSS 0.78731f
C1620 a_54772_4064# AVSS 0.39925f
C1621 a_54186_4064# AVSS 0.4671f
C1622 a_53873_4064# AVSS 0.35645f
C1623 a_53290_4064# AVSS 0.52486f
C1624 a_54772_5304# AVSS 0.47455f
C1625 a_54186_5304# AVSS 0.35108f
C1626 a_53873_5304# AVSS 0.46021f
C1627 a_53289_5304# AVSS 0.35714f
C1628 a_54772_6544# AVSS 0.35815f
C1629 a_54186_6544# AVSS 0.46007f
C1630 a_53873_6544# AVSS 0.3508f
C1631 a_53289_6544# AVSS 0.46952f
C1632 a_54772_7784# AVSS 0.46144f
C1633 a_54186_7784# AVSS 0.35048f
C1634 a_53873_7784# AVSS 0.48276f
C1635 a_53289_7784# AVSS 0.36291f
C1636 a_54772_9435# AVSS 0.3578f
C1637 a_54186_9435# AVSS 0.45977f
C1638 a_53873_9435# AVSS 0.35045f
C1639 a_53290_9435# AVSS 0.48322f
C1640 a_54772_10675# AVSS 0.46174f
C1641 a_54186_10675# AVSS 0.35082f
C1642 a_53873_10675# AVSS 0.46006f
C1643 a_53289_10675# AVSS 0.35204f
C1644 a_54772_11915# AVSS 0.35815f
C1645 a_54186_11915# AVSS 0.46007f
C1646 a_53873_11915# AVSS 0.3508f
C1647 a_53289_11915# AVSS 0.46952f
C1648 a_54772_13155# AVSS 0.46144f
C1649 a_54186_13155# AVSS 0.35048f
C1650 a_53873_13155# AVSS 0.48276f
C1651 a_53289_13155# AVSS 0.36304f
C1652 a_54772_14817# AVSS 0.3578f
C1653 a_54186_14817# AVSS 0.45977f
C1654 a_53873_14817# AVSS 0.35045f
C1655 a_53290_14817# AVSS 0.48322f
C1656 a_54772_16057# AVSS 0.46174f
C1657 a_54186_16057# AVSS 0.35082f
C1658 a_53873_16057# AVSS 0.46006f
C1659 a_53289_16057# AVSS 0.35204f
C1660 a_54772_17297# AVSS 0.35815f
C1661 a_54186_17297# AVSS 0.46007f
C1662 a_53873_17297# AVSS 0.3508f
C1663 a_53289_17297# AVSS 0.46952f
C1664 a_54772_18537# AVSS 0.46144f
C1665 a_54186_18537# AVSS 0.35048f
C1666 a_53873_18537# AVSS 0.48276f
C1667 a_53289_18537# AVSS 0.36314f
C1668 a_54772_20207# AVSS 0.3578f
C1669 a_54186_20207# AVSS 0.45977f
C1670 a_53873_20207# AVSS 0.35045f
C1671 a_53290_20207# AVSS 0.48322f
C1672 a_54772_21447# AVSS 0.46174f
C1673 a_54186_21447# AVSS 0.35082f
C1674 a_53873_21447# AVSS 0.46006f
C1675 a_53289_21447# AVSS 0.35204f
C1676 a_54772_22687# AVSS 0.35815f
C1677 a_54186_22687# AVSS 0.46007f
C1678 a_53873_22687# AVSS 0.3508f
C1679 a_53289_22687# AVSS 0.46952f
C1680 a_51802_4074# AVSS 1.51898f
C1681 a_51218_5264# AVSS 1.51247f
C1682 a_50902_5264# AVSS 1.51247f
C1683 a_50318_5264# AVSS 1.51247f
C1684 a_50902_6454# AVSS 1.51247f
C1685 a_51802_7644# AVSS 1.51247f
C1686 a_51218_7644# AVSS 1.51247f
C1687 a_50318_7644# AVSS 1.51247f
C1688 a_51802_8964# AVSS 1.51247f
C1689 a_51218_8964# AVSS 1.51247f
C1690 a_50902_8964# AVSS 1.51247f
C1691 a_50318_10154# AVSS 1.51247f
C1692 a_51218_11344# AVSS 1.51247f
C1693 a_51802_12534# AVSS 1.51247f
C1694 a_50902_12534# AVSS 1.51247f
C1695 a_50318_12534# AVSS 1.51247f
C1696 a_51218_13854# AVSS 1.51247f
C1697 a_51802_15044# AVSS 1.51247f
C1698 a_50902_15044# AVSS 1.51247f
C1699 a_50318_15044# AVSS 1.51247f
C1700 a_51802_16234# AVSS 1.51247f
C1701 a_50902_16234# AVSS 1.51247f
C1702 a_51218_17424# AVSS 1.51247f
C1703 a_50318_17424# AVSS 1.51247f
C1704 a_51802_19934# AVSS 1.51247f
C1705 a_51218_19934# AVSS 1.51247f
C1706 a_50902_19934# AVSS 1.51247f
C1707 a_50318_19934# AVSS 1.51247f
C1708 a_51802_21124# AVSS 1.51247f
C1709 a_50902_21124# AVSS 1.51247f
C1710 a_51218_22314# AVSS 1.51247f
C1711 a_50318_22314# AVSS 1.51247f
C1712 resistor_network_0.resistor_leg_1.p2 AVSS 1.39594f
C1713 comparator_slice_0.comparator_body_0.outx AVSS 60.37645f
C1714 a_54772_23927# AVSS 0.46144f
C1715 a_54186_23927# AVSS 0.35048f
C1716 a_53873_23927# AVSS 0.48276f
C1717 a_53289_23927# AVSS 0.37209f
C1718 resistor_network_0.pb AVSS 4.97228f
C1719 resistor_network_0.resistor_leg_0.p2 AVSS 1.39594f
C1720 a_57666_28641# AVSS 0.79622f
C1721 a_57082_28641# AVSS 0.23828f
C1722 a_56766_28641# AVSS 0.82242f
C1723 a_56182_28641# AVSS 0.22891f
C1724 a_57666_29831# AVSS 0.21438f
C1725 a_57082_29831# AVSS 0.81902f
C1726 a_56766_29831# AVSS 0.24107f
C1727 a_56182_29831# AVSS 0.80508f
C1728 a_57666_31021# AVSS 0.79514f
C1729 a_57082_31021# AVSS 0.23735f
C1730 a_56766_31021# AVSS 0.82222f
C1731 a_56182_31021# AVSS 0.22675f
C1732 a_57666_32211# AVSS 0.23067f
C1733 a_57082_32211# AVSS 0.82047f
C1734 a_56766_32211# AVSS 0.24137f
C1735 a_56182_32211# AVSS 0.8195f
C1736 a_57666_33637# AVSS 0.81052f
C1737 a_57082_33637# AVSS 0.81162f
C1738 a_56766_33637# AVSS 0.24966f
C1739 a_56182_33637# AVSS 0.81135f
C1740 a_57666_34827# AVSS 0.21664f
C1741 a_57082_34827# AVSS 0.24625f
C1742 a_56766_34827# AVSS 0.81384f
C1743 a_56182_34827# AVSS 0.23457f
C1744 a_62904_37326# AVSS 0.34815f
C1745 a_62320_37326# AVSS 0.35868f
C1746 a_61028_37326# AVSS 1.04505f
C1747 a_60444_37326# AVSS 1.05058f
C1748 a_57666_36017# AVSS 0.22239f
C1749 a_57082_36017# AVSS 0.23735f
C1750 a_56766_36017# AVSS 0.82158f
C1751 a_56182_36017# AVSS 0.22795f
C1752 a_57666_37207# AVSS 0.80353f
C1753 a_57082_37207# AVSS 0.82048f
C1754 a_56766_37207# AVSS 0.24137f
C1755 a_56182_37207# AVSS 0.81956f
C1756 a_62934_39143# AVSS 3.27192f
C1757 a_62350_39143# AVSS 0.3455f
C1758 a_61058_39143# AVSS 0.69428f
C1759 a_60474_39143# AVSS 0.69415f
C1760 a_57666_38633# AVSS 0.23766f
C1761 a_57082_38633# AVSS 0.23884f
C1762 a_56766_38633# AVSS 0.24966f
C1763 a_56182_38633# AVSS 0.23854f
C1764 a_57666_39823# AVSS 0.78939f
C1765 a_57082_39823# AVSS 0.81902f
C1766 a_56766_39823# AVSS 0.81448f
C1767 a_56182_39823# AVSS 0.80802f
C1768 a_57666_41013# AVSS 0.22237f
C1769 a_57082_41013# AVSS 0.23735f
C1770 a_56766_41013# AVSS 0.82158f
C1771 a_56182_41013# AVSS 0.22733f
C1772 a_57666_42203# AVSS 0.80344f
C1773 a_57082_42203# AVSS 0.82047f
C1774 a_56766_42203# AVSS 0.24137f
C1775 a_56182_42203# AVSS 0.82069f
C1776 a_57666_43629# AVSS 0.23775f
C1777 a_57082_43629# AVSS 0.23885f
C1778 a_56766_43629# AVSS 0.24966f
C1779 a_56182_43629# AVSS 0.23762f
C1780 a_57666_44819# AVSS 0.78941f
C1781 a_57082_44819# AVSS 0.81902f
C1782 a_56766_44819# AVSS 0.81448f
C1783 a_56182_44819# AVSS 0.80736f
C1784 a_57666_46009# AVSS 0.22014f
C1785 a_57082_46009# AVSS 0.81011f
C1786 a_56766_46009# AVSS 0.24881f
C1787 a_56182_46009# AVSS 0.79728f
C1788 a_57666_47199# AVSS 0.78864f
C1789 a_57082_47199# AVSS 0.24651f
C1790 a_56766_47199# AVSS 0.81414f
C1791 a_56182_47199# AVSS 0.23331f
C1792 a_54772_27354# AVSS 0.37001f
C1793 a_54186_27354# AVSS 0.11445f
C1794 a_53873_27354# AVSS 0.38525f
C1795 a_53289_27354# AVSS 0.15203f
C1796 a_54772_28594# AVSS 0.11617f
C1797 a_54186_28594# AVSS 0.36865f
C1798 a_53873_28594# AVSS 0.12646f
C1799 a_53289_28594# AVSS 0.37591f
C1800 a_54772_29834# AVSS 0.37031f
C1801 a_54186_29834# AVSS 0.12647f
C1802 a_53873_29834# AVSS 0.36863f
C1803 a_53289_29834# AVSS 0.11572f
C1804 a_54772_31074# AVSS 0.11583f
C1805 a_54186_31074# AVSS 0.36834f
C1806 a_53873_31074# AVSS 0.11702f
C1807 a_53290_31074# AVSS 0.38584f
C1808 a_54772_32744# AVSS 0.37001f
C1809 a_54186_32744# AVSS 0.11416f
C1810 a_53873_32744# AVSS 0.38525f
C1811 a_53289_32744# AVSS 0.13195f
C1812 a_54772_33984# AVSS 0.11617f
C1813 a_54186_33984# AVSS 0.36865f
C1814 a_53873_33984# AVSS 0.11958f
C1815 a_53289_33984# AVSS 0.37591f
C1816 a_54772_35224# AVSS 0.37031f
C1817 a_54186_35224# AVSS 0.1145f
C1818 a_53873_35224# AVSS 0.36863f
C1819 a_53289_35224# AVSS 0.12097f
C1820 a_54772_36464# AVSS 0.11583f
C1821 a_54186_36464# AVSS 0.36834f
C1822 a_53873_36464# AVSS 0.12112f
C1823 a_53290_36464# AVSS 0.38584f
C1824 a_54772_38126# AVSS 0.37001f
C1825 a_54186_38126# AVSS 0.11416f
C1826 a_53873_38126# AVSS 0.38525f
C1827 a_53289_38126# AVSS 0.12673f
C1828 a_54772_39366# AVSS 0.1516f
C1829 a_54186_39366# AVSS 0.36865f
C1830 a_53873_39366# AVSS 23.27794f
C1831 a_53289_39366# AVSS 0.37591f
C1832 a_54772_40606# AVSS 0.37031f
C1833 a_54186_40606# AVSS 0.1145f
C1834 a_53873_40606# AVSS 0.36863f
C1835 a_53289_40606# AVSS 0.11572f
C1836 a_54772_41846# AVSS 0.12261f
C1837 a_54186_41846# AVSS 0.36834f
C1838 a_53873_41846# AVSS 0.12279f
C1839 a_53290_41846# AVSS 0.38584f
C1840 a_54772_43497# AVSS 0.37001f
C1841 a_54186_43497# AVSS 0.11416f
C1842 a_53873_43497# AVSS 0.38525f
C1843 a_53289_43497# AVSS 0.12659f
C1844 a_54772_44737# AVSS 0.13367f
C1845 a_54186_44737# AVSS 0.36865f
C1846 a_53873_44737# AVSS 0.11449f
C1847 a_53289_44737# AVSS 0.37591f
C1848 a_54772_45977# AVSS 0.38312f
C1849 a_54186_45977# AVSS 0.11477f
C1850 a_53873_45977# AVSS 0.36879f
C1851 a_53289_45977# AVSS 0.12082f
C1852 a_54772_47217# AVSS 0.16061f
C1853 a_54186_47217# AVSS 0.37567f
C1854 a_53873_47217# AVSS 0.1212f
C1855 a_53290_47217# AVSS 0.42748f
C1856 a_51218_28967# AVSS 1.51262f
C1857 a_50902_28967# AVSS 1.51262f
C1858 a_51802_30157# AVSS 1.51262f
C1859 a_50318_30157# AVSS 1.51262f
C1860 a_51802_31347# AVSS 1.51262f
C1861 a_50902_31347# AVSS 1.51262f
C1862 a_51218_32537# AVSS 1.51262f
C1863 a_50318_32537# AVSS 1.51262f
C1864 a_51802_33857# AVSS 1.51262f
C1865 a_51218_35047# AVSS 1.51262f
C1866 a_50902_35047# AVSS 1.51262f
C1867 a_50318_35047# AVSS 1.51262f
C1868 a_50318_36237# AVSS 1.51262f
C1869 a_51802_37427# AVSS 1.51262f
C1870 a_51218_37427# AVSS 1.51262f
C1871 a_50902_37427# AVSS 1.51262f
C1872 a_50318_38747# AVSS 1.51262f
C1873 a_51802_39937# AVSS 1.51262f
C1874 a_51218_39937# AVSS 1.51262f
C1875 a_50902_39937# AVSS 1.51262f
C1876 a_50318_41127# AVSS 1.51262f
C1877 a_51802_42317# AVSS 1.51262f
C1878 a_51218_42317# AVSS 1.51262f
C1879 a_50902_42317# AVSS 1.51262f
C1880 a_51218_43637# AVSS 1.51262f
C1881 a_50318_43637# AVSS 1.51262f
C1882 resistor_network_0.resistor_leg_1.pt AVSS 7.15068f
C1883 resistor_network_0.resistor_leg_2.p1 AVSS 1.16553f
C1884 resistor_network_0.resistor_leg_3.p1 AVSS 1.16553f
C1885 resistor_network_0.resistor_leg_0.pt AVSS 7.87225f
C1886 resistor_network_0.p1 AVSS 0.02087f
C1887 a_51802_44827# AVSS 1.51262f
C1888 a_50902_44827# AVSS 1.51262f
C1889 a_50902_46017# AVSS 1.51262f
C1890 comparator_slice_1.comparator_body_0.outx AVSS 60.49055f
C1891 a_51802_47207# AVSS 1.51912f
C1892 a_51218_47207# AVSS 1.51262f
C1893 a_50318_47207# AVSS 1.51262f
C1894 comparator_slice_1.comparator_body_0.m3_m4_diff_0.m3_m4_array_2/p1_2$1_13.D AVSS 3.51186f
C1895 comparator_slice_1.comparator_body_0.m3_m4_diff_0.n1.n0 AVSS 6.78137f
C1896 comparator_slice_1.comparator_body_0.m3_m4_diff_0.m3_m4_array_2/p1_2$1_7.D AVSS 1.38685f
C1897 comparator_slice_1.comparator_body_0.m3_m4_diff_0.m3_m4_array_2/p1_2$1_14.D AVSS 2.2168f
C1898 comparator_slice_1.comparator_body_0.m3_m4_diff_0.n1.n4 AVSS 0.84756f
C1899 comparator_slice_1.comparator_body_0.m3_m4_diff_0.m3_m4_array_2/p1_2$1_10.D AVSS 2.21573f
C1900 comparator_slice_1.comparator_body_0.m3_m4_diff_0.m3_m4_array_3/p1_2$1_7.D AVSS 1.38685f
C1901 comparator_slice_1.comparator_body_0.m3_m4_diff_0.m3_m4_array_3/p1_2$1_10.D AVSS 2.21573f
C1902 comparator_slice_1.comparator_body_0.m3_m4_diff_0.m3_m4_array_1/p1_2$1_7.D AVSS 1.38685f
C1903 comparator_slice_1.comparator_body_0.m3_m4_diff_0.m3_m4_array_1/p1_2$1_10.D AVSS 2.21573f
C1904 comparator_slice_1.comparator_body_0.m3_m4_diff_0.n1.n5 AVSS 0.84756f
C1905 comparator_slice_1.comparator_body_0.m3_m4_diff_0.m3_m4_array_0/p1_2$1_10.D AVSS 1.39481f
C1906 comparator_slice_1.comparator_body_0.m3_m4_diff_0.m3_m4_array_0/p1_2$1_7.D AVSS 2.20776f
C1907 comparator_slice_1.comparator_body_0.m3_m4_diff_0.n1.n6 AVSS 0.56667f
C1908 comparator_slice_1.comparator_body_0.m3_m4_diff_0.m3_m4_array_1/p1_2$1_14.D AVSS 2.2168f
C1909 comparator_slice_1.comparator_body_0.m3_m4_diff_0.m3_m4_array_3/p1_2$1_14.D AVSS 2.2168f
C1910 comparator_slice_1.comparator_body_0.m3_m4_diff_0.n1.n7 AVSS 1.63762f
C1911 comparator_slice_1.comparator_body_0.m3_m4_diff_0.m3_m4_array_3/p1_2$1_4.D AVSS 2.22132f
C1912 comparator_slice_1.comparator_body_0.m3_m4_diff_0.m3_m4_array_0/p1_2$1_4.D AVSS 2.22136f
C1913 comparator_slice_1.comparator_body_0.m3_m4_diff_0.m3_m4_array_1/p1_2$1_9.D AVSS 1.27157f
C1914 comparator_slice_1.comparator_body_0.m3_m4_diff_0.m3_m4_array_1/p1_2$1_4.D AVSS 3.02211f
C1915 comparator_slice_1.comparator_body_0.m3_m4_diff_0.n1.n9 AVSS 0.87967f
C1916 comparator_slice_1.comparator_body_0.m3_m4_diff_0.m3_m4_array_2/p1_2$1_4.D AVSS 1.44368f
C1917 comparator_slice_1.comparator_body_0.m3_m4_diff_0.m3_m4_array_3/p1_2$1_1.D AVSS 2.20042f
C1918 comparator_slice_1.comparator_body_0.m3_m4_diff_0.n1.n11 AVSS 0.84756f
C1919 comparator_slice_1.comparator_body_0.m3_m4_diff_0.n1.n12 AVSS 0.9108f
C1920 comparator_slice_1.comparator_body_0.m3_m4_diff_0.n1.n13 AVSS 0.84306f
C1921 comparator_slice_1.comparator_body_0.m3_m4_diff_0.n1.n15 AVSS 0.59935f
C1922 comparator_slice_1.comparator_body_0.m3_m4_diff_0.n1.n18 AVSS 0.56667f
C1923 comparator_slice_1.comparator_body_0.m3_m4_diff_0.n1.n19 AVSS 0.9108f
C1924 comparator_slice_1.comparator_body_0.m3_m4_diff_0.n1.n20 AVSS 2.25259f
C1925 comparator_slice_1.comparator_body_0.m3_m4_diff_0.n1.n24 AVSS 0.04677f
C1926 comparator_slice_1.comparator_body_0.m3_m4_diff_0.n1.n25 AVSS 2.47886f
C1927 comparator_slice_1.comparator_body_0.m3_m4_diff_0.m3_m4_array_0/p1_2$1_1.D AVSS 2.20042f
C1928 comparator_slice_1.comparator_body_0.m3_m4_diff_0.m3_m4_array_1/p1_2$1_1.D AVSS 2.20042f
C1929 comparator_slice_1.comparator_body_0.m3_m4_diff_0.m3_m4_array_2/p1_2$1_1.D AVSS 2.13814f
C1930 comparator_slice_1.comparator_body_0.m3_m4_diff_0.m3_m4_array_1/p1_2$1_13.D AVSS 1.6567f
C1931 comparator_slice_1.comparator_body_0.m3_m4_diff_0.n1.n30 AVSS 4.31045f
C1932 comparator_slice_1.comparator_body_0.m3_m4_diff_0.m3_m4_array_0/p1_2$1_14.D AVSS 1.38033f
C1933 comparator_slice_1.comparator_body_0.m3_m4_diff_0.n1.n31 AVSS 1.4229f
C1934 comparator_slice_1.comparator_body_0.m3_m4_diff_0.m3_m4_array_2/p1_2$1_9.D AVSS 1.79212f
C1935 comparator_slice_1.comparator_body_0.m3_m4_diff_0.n1.n33 AVSS 2.18616f
C1936 comparator_slice_1.comparator_body_0.m3_m4_diff_0.n1.n34 AVSS 1.48847f
C1937 comparator_slice_1.comparator_body_0.m3_m4_diff_0.n1.n35 AVSS 1.32677f
C1938 comparator_slice_1.comparator_body_0.m1_m2_diff_0.n1 AVSS 4.92833f
C1939 comparator_slice_1.comparator_body_0.m3_m4_diff_0.n1.n36 AVSS 5.27763f
C1940 comparator_slice_1.comparator_body_0.m3_m4_diff_0.n1.n37 AVSS 2.69479f
C1941 comparator_slice_1.comparator_body_0.m3_m4_diff_0.n1.n38 AVSS 2.69479f
C1942 comparator_slice_1.comparator_body_0.m3_m4_diff_0.n1.n39 AVSS 2.69479f
C1943 comparator_slice_1.comparator_body_0.m3_m4_diff_0.n1.n40 AVSS 2.69479f
C1944 comparator_slice_1.comparator_body_0.m3_m4_diff_0.n1.n41 AVSS 2.42031f
C1945 comparator_slice_1.comparator_body_0.m3_m4_diff_0.m3_m4_array_3/p1_2$1_13.D AVSS 1.34022f
C1946 comparator_slice_1.comparator_body_0.m3_m4_diff_0.n1.n42 AVSS 1.66819f
C1947 comparator_slice_1.comparator_body_0.m3_m4_diff_0.n1.n44 AVSS 1.98883f
C1948 comparator_slice_1.comparator_body_0.m3_m4_diff_0.n1.n45 AVSS 1.95578f
C1949 comparator_slice_1.comparator_body_0.m3_m4_diff_0.m3_m4_array_3/p1_2$1_0.D AVSS 1.62833f
C1950 comparator_slice_1.comparator_body_0.m3_m4_diff_0.m3_m4_array_0/p1_2$1_0.D AVSS 1.35354f
C1951 comparator_slice_1.comparator_body_0.m3_m4_diff_0.m3_m4_array_1/p1_2$1_0.D AVSS 1.58803f
C1952 comparator_slice_1.comparator_body_0.m3_m4_diff_0.m3_m4_array_2/p1_2$1_0.D AVSS 1.58803f
C1953 comparator_slice_1.comparator_body_0.m3_m4_diff_0.m3_m4_array_3/p1_2$1_9.D AVSS 1.36151f
C1954 comparator_slice_1.comparator_body_0.m3_m4_diff_0.m3_m4_array_0/p1_2$1_9.D AVSS 1.27952f
C1955 comparator_slice_1.comparator_body_0.m3_m4_diff_0.n1.n46 AVSS 1.1472f
C1956 comparator_slice_1.comparator_body_0.m3_m4_diff_0.n1.n47 AVSS 0.74423f
C1957 comparator_slice_1.comparator_body_0.m3_m4_diff_0.n1.n48 AVSS 1.97554f
C1958 comparator_slice_1.comparator_body_0.m3_m4_diff_0.n1.n49 AVSS 3.32456f
C1959 comparator_slice_1.comparator_body_0.m3_m4_diff_0.n1.n50 AVSS 2.56208f
C1960 comparator_slice_1.comparator_body_0.m3_m4_diff_0.n1.n51 AVSS 1.97554f
C1961 comparator_slice_1.comparator_body_0.m3_m4_diff_0.n1.n52 AVSS 1.97554f
C1962 comparator_slice_1.comparator_body_0.m3_m4_diff_0.n1.n53 AVSS 1.23019f
C1963 comparator_slice_1.comparator_body_0.m3_m4_diff_0.m3_m4_array_0/p1_2$1_13.D AVSS 1.6567f
C1964 comparator_slice_1.comparator_body_0.m3_m4_diff_0.n1.t3 AVSS 0.21956f
C1965 comparator_slice_1.comparator_body_0.m3_m4_diff_0.n1.t35 AVSS 0.21956f
C1966 comparator_slice_1.comparator_body_0.m3_m4_diff_0.n1.t17 AVSS 0.21956f
C1967 comparator_slice_1.comparator_body_0.m3_m4_diff_0.n1.t55 AVSS 1.73217f
C1968 comparator_slice_1.comparator_body_0.m3_m4_diff_0.n1.t9 AVSS 1.73217f
C1969 comparator_slice_1.comparator_body_0.m3_m4_diff_0.n1.t33 AVSS 0.21956f
C1970 comparator_slice_1.comparator_body_0.m3_m4_diff_0.n1.t7 AVSS 0.21956f
C1971 comparator_slice_1.comparator_body_0.m3_m4_diff_0.n1.t11 AVSS 0.21956f
C1972 comparator_slice_1.comparator_body_0.m3_m4_diff_0.n1.t45 AVSS 1.73217f
C1973 comparator_slice_1.comparator_body_0.m3_m4_diff_0.n1.t31 AVSS 0.21956f
C1974 comparator_slice_1.comparator_body_0.m3_m4_diff_0.n1.t5 AVSS 0.21956f
C1975 comparator_slice_1.comparator_body_0.m3_m4_diff_0.n1.t53 AVSS 0.21956f
C1976 comparator_slice_1.comparator_body_0.m3_m4_diff_0.n1.t37 AVSS 0.21956f
C1977 comparator_slice_1.comparator_body_0.m3_m4_diff_0.n1.t13 AVSS 0.21956f
C1978 comparator_slice_1.comparator_body_0.m3_m4_diff_0.n1.t25 AVSS 0.21956f
C1979 comparator_slice_1.comparator_body_0.m3_m4_diff_0.n1.n54 AVSS 1.61634f
C1980 comparator_slice_1.comparator_body_0.m1_m2_diff_0.m1_m2_array_1/n1_2_1.D AVSS 0.35912f
C1981 comparator_slice_1.comparator_body_0.m1_m2_diff_0.m1_m2_array_1/n1_2_14.D AVSS 0.75816f
C1982 comparator_slice_1.comparator_body_0.m1_m2_diff_0.m1_m2_array_1/n1_2_2.D AVSS 0.32371f
C1983 comparator_slice_1.comparator_body_0.m1_m2_diff_0.m1_m2_array_3/n1_2_1.D AVSS 0.35912f
C1984 comparator_slice_1.comparator_body_0.m1_m2_diff_0.m1_m2_array_3/n1_2_14.D AVSS 0.75816f
C1985 comparator_slice_1.comparator_body_0.m1_m2_diff_0.m1_m2_array_3/n1_2_2.D AVSS 0.32371f
C1986 comparator_slice_1.comparator_body_0.m1_m2_diff_0.m1_m2_array_3/n1_2_13.D AVSS 0.32371f
C1987 comparator_slice_1.comparator_body_0.m1_m2_diff_0.m1_m2_array_2/n1_2_1.D AVSS 0.35912f
C1988 comparator_slice_1.comparator_body_0.m1_m2_diff_0.m1_m2_array_2/n1_2_14.D AVSS 0.75816f
C1989 comparator_slice_1.comparator_body_0.m1_m2_diff_0.m1_m2_array_2/n1_2_2.D AVSS 0.32371f
C1990 comparator_slice_1.comparator_body_0.m1_m2_diff_0.m1_m2_array_2/n1_2_13.D AVSS 0.32371f
C1991 comparator_slice_1.comparator_body_0.m1_m2_diff_0.m1_m2_array_0/n1_2_1.D AVSS 0.35912f
C1992 comparator_slice_1.comparator_body_0.m1_m2_diff_0.m1_m2_array_0/n1_2_14.D AVSS 0.75816f
C1993 comparator_slice_1.comparator_body_0.m1_m2_diff_0.m1_m2_array_0/n1_2_2.D AVSS 0.32371f
C1994 comparator_slice_1.comparator_body_0.m1_m2_diff_0.m1_m2_array_0/n1_2_13.D AVSS 0.32371f
C1995 comparator_slice_1.comparator_body_0.m1_m2_diff_0.m1_m2_array_1/n1_2_13.D AVSS 0.31062f
C1996 comparator_slice_1.comparator_body_0.m1_m2_diff_0.m1_m2_array_1/n1_2_10.D AVSS 0.32423f
C1997 comparator_slice_1.comparator_body_0.m1_m2_diff_0.m1_m2_array_1/n1_2_7.D AVSS 0.35966f
C1998 comparator_slice_1.comparator_body_0.m1_m2_diff_0.m1_m2_array_1/n1_2_4.D AVSS 0.35966f
C1999 comparator_slice_1.comparator_body_0.m1_m2_diff_0.m1_m2_array_3/n1_2_10.D AVSS 0.32423f
C2000 comparator_slice_1.comparator_body_0.m1_m2_diff_0.m1_m2_array_3/n1_2_11.D AVSS 0.87322f
C2001 comparator_slice_1.comparator_body_0.m1_m2_diff_0.m1_m2_array_3/n1_2_7.D AVSS 0.35966f
C2002 comparator_slice_1.comparator_body_0.m1_m2_diff_0.m1_m2_array_3/n1_2_4.D AVSS 0.35966f
C2003 comparator_slice_1.comparator_body_0.m1_m2_diff_0.m1_m2_array_2/n1_2_10.D AVSS 0.32423f
C2004 comparator_slice_1.comparator_body_0.m1_m2_diff_0.m1_m2_array_2/n1_2_11.D AVSS 0.33793f
C2005 comparator_slice_1.comparator_body_0.m1_m2_diff_0.m1_m2_array_2/n1_2_7.D AVSS 0.35966f
C2006 comparator_slice_1.comparator_body_0.m1_m2_diff_0.m1_m2_array_2/n1_2_4.D AVSS 0.35966f
C2007 comparator_slice_1.comparator_body_0.m1_m2_diff_0.m1_m2_array_0/n1_2_10.D AVSS 0.32423f
C2008 comparator_slice_1.comparator_body_0.m1_m2_diff_0.m1_m2_array_0/n1_2_11.D AVSS 0.41933f
C2009 comparator_slice_1.comparator_body_0.m1_m2_diff_0.m1_m2_array_0/n1_2_7.D AVSS 0.35966f
C2010 comparator_slice_1.comparator_body_0.m1_m2_diff_0.m1_m2_array_0/n1_2_4.D AVSS 0.35966f
C2011 comparator_slice_1.comparator_body_0.m1_m2_diff_0.m1_m2_array_1/n1_2_11.D AVSS 0.40898f
C2012 comparator_slice_1.comparator_body_0.m3_m4_diff_0.n1.t1 AVSS 0.21952f
C2013 comparator_slice_1.comparator_body_0.m3_m4_diff_0.n1.t27 AVSS 1.73124f
C2014 comparator_slice_1.comparator_body_0.m3_m4_diff_0.n1.t51 AVSS 0.21862f
C2015 comparator_slice_1.comparator_body_0.m3_m4_diff_0.n1.t47 AVSS 0.21862f
C2016 comparator_slice_1.comparator_body_0.m3_m4_diff_0.n1.t57 AVSS 0.21862f
C2017 comparator_slice_1.comparator_body_0.m3_m4_diff_0.n1.t23 AVSS 1.73124f
C2018 comparator_slice_1.comparator_body_0.m3_m4_diff_0.n1.t39 AVSS 0.21862f
C2019 comparator_slice_1.comparator_body_0.m3_m4_diff_0.n1.t63 AVSS 0.21862f
C2020 comparator_slice_1.comparator_body_0.m3_m4_diff_0.n1.t15 AVSS 1.73124f
C2021 comparator_slice_1.comparator_body_0.m3_m4_diff_0.n1.t19 AVSS 0.21862f
C2022 comparator_slice_1.comparator_body_0.m3_m4_diff_0.n1.t79 AVSS 0.22137f
C2023 comparator_slice_1.comparator_body_0.m3_m4_diff_0.n1.t91 AVSS 0.22137f
C2024 comparator_slice_1.comparator_body_0.m3_m4_diff_0.n1.t83 AVSS 0.22064f
C2025 comparator_slice_1.comparator_body_0.m3_m4_diff_0.n1.t84 AVSS 0.22137f
C2026 comparator_slice_1.comparator_body_0.m3_m4_diff_0.n1.t76 AVSS 0.22064f
C2027 comparator_slice_1.comparator_body_0.m3_m4_diff_0.n1.t77 AVSS 0.22137f
C2028 comparator_slice_1.comparator_body_0.m3_m4_diff_0.n1.t94 AVSS 0.22064f
C2029 comparator_slice_1.comparator_body_0.m3_m4_diff_0.n1.t65 AVSS 0.22602f
C2030 comparator_slice_1.comparator_body_0.m3_m4_diff_0.n1.t81 AVSS 0.22137f
C2031 comparator_slice_1.comparator_body_0.m3_m4_diff_0.n1.t73 AVSS 0.22574f
C2032 comparator_slice_1.comparator_body_0.m3_m4_diff_0.n1.t71 AVSS 0.22137f
C2033 comparator_slice_1.comparator_body_0.m3_m4_diff_0.n1.t68 AVSS 0.22137f
C2034 comparator_slice_1.comparator_body_0.m3_m4_diff_0.n1.t61 AVSS 0.21862f
C2035 comparator_slice_1.comparator_body_0.m3_m4_diff_0.n1.t21 AVSS 1.73124f
C2036 comparator_slice_1.comparator_body_0.m3_m4_diff_0.n1.t49 AVSS 0.21862f
C2037 comparator_slice_1.comparator_body_0.m3_m4_diff_0.n1.t43 AVSS 0.21862f
C2038 comparator_slice_1.comparator_body_0.m3_m4_diff_0.n1.t72 AVSS 0.22137f
C2039 comparator_slice_1.comparator_body_0.m3_m4_diff_0.n1.t89 AVSS 0.22137f
C2040 comparator_slice_1.comparator_body_0.m3_m4_diff_0.n1.t82 AVSS 0.2242f
C2041 comparator_slice_1.comparator_body_0.m3_m4_diff_0.n1.t86 AVSS 0.22137f
C2042 comparator_slice_1.comparator_body_0.m3_m4_diff_0.n1.t88 AVSS 0.2368f
C2043 comparator_slice_1.comparator_body_0.m3_m4_diff_0.n1.t67 AVSS 0.22137f
C2044 comparator_slice_1.comparator_body_0.m3_m4_diff_0.n1.t85 AVSS 0.23814f
C2045 comparator_slice_1.comparator_body_0.m3_m4_diff_0.n1.n55 AVSS 1.71076f
C2046 comparator_slice_1.comparator_body_0.m3_m4_diff_0.n1.t87 AVSS 0.22171f
C2047 comparator_slice_1.comparator_body_0.m3_m4_diff_0.n1.t93 AVSS 0.22137f
C2048 comparator_slice_1.comparator_body_0.m3_m4_diff_0.n1.t66 AVSS 0.22064f
C2049 comparator_slice_1.comparator_body_0.m3_m4_diff_0.n1.t90 AVSS 0.22137f
C2050 comparator_slice_1.comparator_body_0.m3_m4_diff_0.n1.t70 AVSS 0.22137f
C2051 comparator_slice_1.comparator_body_0.m3_m4_diff_0.n1.t78 AVSS 0.22137f
C2052 comparator_slice_1.comparator_body_0.m3_m4_diff_0.n1.t59 AVSS 0.21862f
C2053 comparator_slice_1.comparator_body_0.m3_m4_diff_0.n1.t41 AVSS 0.21862f
C2054 comparator_slice_1.comparator_body_0.m3_m4_diff_0.n1.t29 AVSS 0.21862f
C2055 comparator_slice_1.comparator_body_0.m3_m4_diff_0.n1.t64 AVSS 0.22398f
C2056 comparator_slice_1.comparator_body_0.m3_m4_diff_0.n1.n56 AVSS 3.48782f
C2057 comparator_slice_1.comparator_body_0.m3_m4_diff_0.n1.n57 AVSS 0.04677f
C2058 comparator_slice_1.comparator_body_0.m3_m4_diff_0.n1.t92 AVSS 0.22429f
C2059 comparator_slice_1.comparator_body_0.m3_m4_diff_0.n1.t80 AVSS 0.25608f
C2060 comparator_slice_1.comparator_body_0.m3_m4_diff_0.n1.n58 AVSS 1.65924f
C2061 comparator_slice_1.comparator_body_0.m3_m4_diff_0.n1.t74 AVSS 0.22064f
C2062 comparator_slice_1.comparator_body_0.m3_m4_diff_0.n1.n59 AVSS 1.4456f
C2063 comparator_slice_1.comparator_body_0.m3_m4_diff_0.n1.t95 AVSS 0.22286f
C2064 comparator_slice_1.comparator_body_0.m3_m4_diff_0.n1.t69 AVSS 0.22064f
C2065 comparator_slice_1.comparator_body_0.m3_m4_diff_0.n1.t75 AVSS 0.22064f
C2066 comparator_slice_1.comparator_body_0.m3_m4_diff_0.n1.n60 AVSS 2.01624f
C2067 comparator_slice_1.comparator_body_0.outx.n0 AVSS 1.63553f
C2068 comparator_slice_1.comparator_body_0.outx.n1 AVSS 11.119f
C2069 comparator_slice_1.comparator_body_0.outx.n2 AVSS 0.47971f
C2070 comparator_slice_1.comparator_body_0.outx.n3 AVSS 1.50734f
C2071 comparator_slice_1.comparator_body_0.outx.n4 AVSS 7.02938f
C2072 comparator_slice_1.comparator_body_0.outx.n5 AVSS 0.52577f
C2073 comparator_slice_1.comparator_body_0.outx.n6 AVSS 1.19523f
C2074 comparator_slice_1.comparator_body_0.outx.n7 AVSS 3.38282f
C2075 comparator_slice_1.comparator_body_0.outx.n8 AVSS 0.98274f
C2076 comparator_slice_1.comparator_body_0.outx.n9 AVSS 6.44286f
C2077 comparator_slice_1.comparator_body_0.outx.n11 AVSS 3.36944f
C2078 comparator_slice_1.comparator_body_0.outx.n13 AVSS 3.36944f
C2079 comparator_slice_1.comparator_body_0.outx.n14 AVSS 1.11878f
C2080 comparator_slice_1.comparator_body_0.outx.n15 AVSS 2.42788f
C2081 comparator_slice_1.comparator_body_0.outx.n16 AVSS 6.75159f
C2082 comparator_slice_1.comparator_body_0.outx.n17 AVSS 0.38548f
C2083 comparator_slice_1.comparator_body_0.outx.n18 AVSS 0.98574f
C2084 comparator_slice_1.comparator_body_0.outx.n19 AVSS 2.14268f
C2085 comparator_slice_1.comparator_body_0.outx.n20 AVSS 0.65134f
C2086 comparator_slice_1.comparator_body_0.outx.n21 AVSS 2.65039f
C2087 comparator_slice_1.comparator_body_0.outx.n23 AVSS 2.65039f
C2088 comparator_slice_1.comparator_body_0.outx.n26 AVSS 2.60379f
C2089 comparator_slice_1.comparator_body_0.outx.n27 AVSS 0.99296f
C2090 comparator_slice_1.comparator_body_0.outx.n28 AVSS 1.72858f
C2091 comparator_slice_1.comparator_body_0.outx.n30 AVSS 1.55932f
C2092 comparator_slice_1.comparator_body_0.outx.n31 AVSS 0.97433f
C2093 comparator_slice_1.comparator_body_0.outx.n32 AVSS 0.58292f
C2094 comparator_slice_1.comparator_body_0.outx.n33 AVSS 0.99157f
C2095 comparator_slice_1.comparator_body_0.outx.n34 AVSS 1.77349f
C2096 comparator_slice_1.comparator_body_0.outx.n35 AVSS 1.25393f
C2097 comparator_slice_1.comparator_body_0.outx.n36 AVSS 1.97843f
C2098 comparator_slice_1.comparator_body_0.outx.n37 AVSS 1.23932f
C2099 comparator_slice_1.comparator_body_0.outx.n38 AVSS 1.23932f
C2100 comparator_slice_1.comparator_body_0.outx.n39 AVSS 0.73716f
C2101 comparator_slice_1.comparator_body_0.outx.n40 AVSS 1.21893f
C2102 comparator_slice_1.comparator_body_0.outx.n41 AVSS 1.07984f
C2103 comparator_slice_1.comparator_body_0.outx.n42 AVSS 1.07984f
C2104 comparator_slice_1.comparator_body_0.outx.n43 AVSS 1.68257f
C2105 comparator_slice_1.comparator_body_0.outx.n44 AVSS 1.78858f
C2106 comparator_slice_1.comparator_body_0.outx.n45 AVSS 1.68257f
C2107 comparator_slice_1.comparator_body_0.outx.n46 AVSS 0.80477f
C2108 comparator_slice_1.comparator_body_0.outx.n47 AVSS 9.25574f
C2109 comparator_slice_1.comparator_body_0.outx.n48 AVSS 0.73716f
C2110 comparator_slice_1.comparator_body_0.outx.n49 AVSS 1.06756f
C2111 comparator_slice_1.comparator_body_0.outx.n50 AVSS 1.15316f
C2112 comparator_slice_1.comparator_body_0.outx.n51 AVSS 1.24574f
C2113 comparator_slice_1.comparator_body_0.outx.n52 AVSS 1.94392f
C2114 comparator_slice_1.comparator_body_0.outx.n53 AVSS 4.16173f
C2115 comparator_slice_1.comparator_body_0.outx.t0 AVSS 0.17212f
C2116 comparator_slice_1.comparator_body_0.outx.t17 AVSS 1.68404f
C2117 comparator_slice_1.comparator_body_0.outx.t22 AVSS 0.17215f
C2118 comparator_slice_1.comparator_body_0.outx.t48 AVSS 0.44215f
C2119 comparator_slice_1.comparator_body_0.outx.t37 AVSS 0.17165f
C2120 comparator_slice_1.comparator_body_0.outx.n54 AVSS 1.36857f
C2121 comparator_slice_1.comparator_body_0.outx.t38 AVSS 0.17109f
C2122 comparator_slice_1.comparator_body_0.outx.t9 AVSS 0.17142f
C2123 comparator_slice_1.comparator_body_0.outx.t1 AVSS 0.17142f
C2124 comparator_slice_1.comparator_body_0.outx.t61 AVSS 0.17215f
C2125 comparator_slice_1.comparator_body_0.outx.t8 AVSS 1.68404f
C2126 comparator_slice_1.comparator_body_0.outx.t36 AVSS 0.44215f
C2127 comparator_slice_1.comparator_body_0.outx.t41 AVSS 0.43184f
C2128 comparator_slice_1.comparator_body_0.outx.n55 AVSS 1.36857f
C2129 comparator_slice_1.comparator_body_0.outx.t51 AVSS 0.17109f
C2130 comparator_slice_1.comparator_body_0.outx.t42 AVSS 0.42523f
C2131 comparator_slice_1.comparator_body_0.outx.t34 AVSS 0.42579f
C2132 comparator_slice_1.comparator_body_0.outx.n56 AVSS 1.38044f
C2133 comparator_slice_1.comparator_body_0.outx.t49 AVSS 0.42523f
C2134 comparator_slice_1.comparator_body_0.outx.t55 AVSS 0.17165f
C2135 comparator_slice_1.comparator_body_0.outx.t46 AVSS 0.44236f
C2136 comparator_slice_1.comparator_body_0.outx.t2 AVSS 1.68404f
C2137 comparator_slice_1.comparator_body_0.outx.t5 AVSS 0.17142f
C2138 comparator_slice_1.comparator_body_0.outx.n57 AVSS 1.67711f
C2139 comparator_slice_1.comparator_body_0.outx.t23 AVSS 0.17215f
C2140 comparator_slice_1.comparator_body_0.outx.t24 AVSS 0.17142f
C2141 comparator_slice_1.comparator_body_0.outx.t19 AVSS 0.17215f
C2142 comparator_slice_1.comparator_body_0.outx.t11 AVSS 0.17215f
C2143 comparator_slice_1.comparator_body_0.outx.t63 AVSS 1.68476f
C2144 comparator_slice_1.comparator_body_0.outx.t25 AVSS 0.17142f
C2145 comparator_slice_1.comparator_body_0.outx.t27 AVSS 0.17215f
C2146 comparator_slice_1.comparator_body_0.outx.t20 AVSS 0.17142f
C2147 comparator_slice_1.comparator_body_0.outx.t50 AVSS 0.44236f
C2148 comparator_slice_1.comparator_body_0.outx.t29 AVSS 0.42523f
C2149 comparator_slice_1.comparator_body_0.outx.t40 AVSS 0.17165f
C2150 comparator_slice_1.comparator_body_0.outx.n58 AVSS 1.38044f
C2151 comparator_slice_1.comparator_body_0.outx.t57 AVSS 0.42523f
C2152 comparator_slice_1.comparator_body_0.outx.t56 AVSS 0.17165f
C2153 comparator_slice_1.comparator_body_0.outx.t62 AVSS 0.17215f
C2154 comparator_slice_1.comparator_body_0.outx.t28 AVSS 0.17215f
C2155 comparator_slice_1.comparator_body_0.outx.t13 AVSS 0.17142f
C2156 comparator_slice_1.comparator_body_0.outx.t33 AVSS 0.44215f
C2157 comparator_slice_1.comparator_body_0.outx.t59 AVSS 0.17165f
C2158 comparator_slice_1.comparator_body_0.outx.n59 AVSS 1.36857f
C2159 comparator_slice_1.comparator_body_0.outx.t60 AVSS 0.42523f
C2160 comparator_slice_1.comparator_body_0.outx.t54 AVSS 0.17165f
C2161 comparator_slice_1.comparator_body_0.outx.t47 AVSS 0.42523f
C2162 comparator_slice_1.comparator_body_0.outx.t58 AVSS 0.17165f
C2163 comparator_slice_1.comparator_body_0.outx.n60 AVSS 1.38044f
C2164 comparator_slice_1.comparator_body_0.outx.t52 AVSS 0.42523f
C2165 comparator_slice_1.comparator_body_0.outx.t44 AVSS 0.17165f
C2166 comparator_slice_1.comparator_body_0.outx.t12 AVSS 0.17215f
C2167 comparator_slice_1.comparator_body_0.outx.t6 AVSS 0.17215f
C2168 comparator_slice_1.comparator_body_0.outx.t4 AVSS 0.17215f
C2169 comparator_slice_1.comparator_body_0.outx.t3 AVSS 0.17142f
C2170 comparator_slice_1.comparator_body_0.outx.t21 AVSS 0.17215f
C2171 comparator_slice_1.comparator_body_0.outx.t7 AVSS 0.17142f
C2172 comparator_slice_1.comparator_body_0.outx.t14 AVSS 1.68404f
C2173 comparator_slice_1.comparator_body_0.outx.t18 AVSS 0.17142f
C2174 comparator_slice_1.comparator_body_0.outx.t10 AVSS 0.17215f
C2175 comparator_slice_1.comparator_body_0.outx.t26 AVSS 0.17215f
C2176 comparator_slice_1.comparator_body_0.outx.n61 AVSS 1.28141f
C2177 comparator_slice_1.comparator_body_0.outx.t32 AVSS 0.44215f
C2178 comparator_slice_1.comparator_body_0.outx.t31 AVSS 0.17165f
C2179 comparator_slice_1.comparator_body_0.outx.n62 AVSS 1.36857f
C2180 comparator_slice_1.comparator_body_0.outx.t35 AVSS 0.17109f
C2181 comparator_slice_1.comparator_body_0.outx.t45 AVSS 0.42523f
C2182 comparator_slice_1.comparator_body_0.outx.t39 AVSS 0.17165f
C2183 comparator_slice_1.comparator_body_0.outx.n63 AVSS 1.38044f
C2184 comparator_slice_1.comparator_body_0.outx.t43 AVSS 0.17109f
C2185 comparator_slice_1.comparator_body_0.outx.t53 AVSS 0.42579f
C2186 comparator_slice_1.comparator_body_0.outx.t30 AVSS 0.17165f
C2187 comparator_slice_1.comparator_body_0.outx.t15 AVSS 0.17142f
C2188 comparator_slice_1.comparator_body_0.outx.t16 AVSS 0.17142f
C2189 comparator_slice_1.comparator_body_0.m1_m2_diff_0.m1_m2_array_3/n1_2_15.S AVSS 0.26042f
C2190 comparator_slice_1.comparator_body_0.mref_m5_diff_0.tail.n0 AVSS 0.57549f
C2191 comparator_slice_1.comparator_body_0.mref_m5_diff_0.tail.n1 AVSS 55.2083f
C2192 comparator_slice_1.comparator_body_0.mref_m5_diff_0.tail.n2 AVSS 0.57148f
C2193 comparator_slice_1.comparator_body_0.mref_m5_diff_0.tail.n3 AVSS 0.84701f
C2194 comparator_slice_1.comparator_body_0.mref_m5_diff_0.tail.n4 AVSS 0.29402f
C2195 comparator_slice_1.comparator_body_0.mref_m5_diff_0.tail.n5 AVSS 0.57151f
C2196 comparator_slice_1.comparator_body_0.mref_m5_diff_0.tail.n6 AVSS 0.65084f
C2197 comparator_slice_1.comparator_body_0.mref_m5_diff_0.tail.n7 AVSS 0.57549f
C2198 comparator_slice_1.comparator_body_0.mref_m5_diff_0.tail.n8 AVSS 0.57549f
C2199 comparator_slice_1.comparator_body_0.mref_m5_diff_0.tail.n9 AVSS 0.58637f
C2200 comparator_slice_1.comparator_body_0.m1_m2_diff_0.m1_m2_array_0/n1_2_8.S AVSS 0.25099f
C2201 comparator_slice_1.comparator_body_0.mref_m5_diff_0.tail.n10 AVSS 0.18256f
C2202 comparator_slice_1.comparator_body_0.mref_m5_diff_0.tail.n11 AVSS 0.23033f
C2203 comparator_slice_1.comparator_body_0.m1_m2_diff_0.m1_m2_array_0/n1_2_15.S AVSS 0.26013f
C2204 comparator_slice_1.comparator_body_0.m1_m2_diff_0.m1_m2_array_2/n1_2_15.S AVSS 0.26038f
C2205 comparator_slice_1.comparator_body_0.mref_m5_diff_0.tail.n12 AVSS 0.35171f
C2206 comparator_slice_1.comparator_body_0.mref_m5_diff_0.tail.n13 AVSS 0.86164f
C2207 comparator_slice_1.comparator_body_0.mref_m5_diff_0.tail.n14 AVSS 0.35843f
C2208 comparator_slice_1.comparator_body_0.m1_m2_diff_0.m1_m2_array_0/n1_2_4.S AVSS 0.22982f
C2209 comparator_slice_1.comparator_body_0.mref_m5_diff_0.tail.n15 AVSS 0.36518f
C2210 comparator_slice_1.comparator_body_0.mref_m5_diff_0.tail.n16 AVSS 0.57825f
C2211 comparator_slice_1.comparator_body_0.mref_m5_diff_0.tail.n17 AVSS 1.35465f
C2212 comparator_slice_1.comparator_body_0.mref_m5_diff_0.tail.n18 AVSS 0.38286f
C2213 comparator_slice_1.comparator_body_0.mref_m5_diff_0.tail.n19 AVSS 0.45597f
C2214 comparator_slice_1.comparator_body_0.mref_m5_diff_0.tail.n20 AVSS 0.46433f
C2215 comparator_slice_1.comparator_body_0.mref_m5_diff_0.tail.n21 AVSS 0.78183f
C2216 comparator_slice_1.comparator_body_0.mref_m5_diff_0.tail.n22 AVSS 0.61124f
C2217 comparator_slice_1.comparator_body_0.mref_m5_diff_0.tail.n23 AVSS 0.54437f
C2218 comparator_slice_1.comparator_body_0.mref_m5_diff_0.tail.n24 AVSS 0.54043f
C2219 comparator_slice_1.comparator_body_0.mref_m5_diff_0.tail.n25 AVSS 0.19941f
C2220 comparator_slice_1.comparator_body_0.mref_m5_diff_0.tail.n26 AVSS 0.70431f
C2221 comparator_slice_1.comparator_body_0.mref_m5_diff_0.tail.n27 AVSS 0.54437f
C2222 comparator_slice_1.comparator_body_0.mref_m5_diff_0.tail.n28 AVSS 0.54043f
C2223 comparator_slice_1.comparator_body_0.mref_m5_diff_0.tail.n29 AVSS 0.19941f
C2224 comparator_slice_1.comparator_body_0.mref_m5_diff_0.tail.n30 AVSS 0.70431f
C2225 comparator_slice_1.comparator_body_0.mref_m5_diff_0.tail.n31 AVSS 0.54437f
C2226 comparator_slice_1.comparator_body_0.mref_m5_diff_0.tail.n32 AVSS 0.54043f
C2227 comparator_slice_1.comparator_body_0.mref_m5_diff_0.tail.n33 AVSS 0.19941f
C2228 comparator_slice_1.comparator_body_0.mref_m5_diff_0.tail.n34 AVSS 0.70431f
C2229 comparator_slice_1.comparator_body_0.mref_m5_diff_0.tail.n35 AVSS 0.19941f
C2230 comparator_slice_1.comparator_body_0.mref_m5_diff_0.tail.n36 AVSS 0.70431f
C2231 comparator_slice_1.comparator_body_0.mref_m5_diff_0.mref_m5_array_0/n1_2$1_3.D AVSS 0.18393f
C2232 comparator_slice_1.comparator_body_0.mref_m5_diff_0.mref_m5_array_0/n1_2$1_11.D AVSS 0.23835f
C2233 comparator_slice_1.comparator_body_0.mref_m5_diff_0.mref_m5_array_0/n1_2$1_2.D AVSS 0.18392f
C2234 comparator_slice_1.comparator_body_0.mref_m5_diff_0.mref_m5_array_0/n1_2$1_8.D AVSS 0.18392f
C2235 comparator_slice_1.comparator_body_0.mref_m5_diff_0.mref_m5_array_1/n1_2$1_11.D AVSS 0.23835f
C2236 comparator_slice_1.comparator_body_0.mref_m5_diff_0.mref_m5_array_1/n1_2$1_2.D AVSS 0.18392f
C2237 comparator_slice_1.comparator_body_0.mref_m5_diff_0.mref_m5_array_3/n1_2$1_11.D AVSS 0.23835f
C2238 comparator_slice_1.comparator_body_0.mref_m5_diff_0.mref_m5_array_3/n1_2$1_2.D AVSS 0.18392f
C2239 comparator_slice_1.comparator_body_0.mref_m5_diff_0.mref_m5_array_2/n1_2$1_11.D AVSS 0.23835f
C2240 comparator_slice_1.comparator_body_0.mref_m5_diff_0.mref_m5_array_2/n1_2$1_2.D AVSS 0.18392f
C2241 comparator_slice_1.comparator_body_0.mref_m5_diff_0.mref_m5_array_2/n1_2$1_8.D AVSS 0.18392f
C2242 comparator_slice_1.comparator_body_0.mref_m5_diff_0.mref_m5_array_2/n1_2$1_3.D AVSS 0.18393f
C2243 comparator_slice_1.comparator_body_0.mref_m5_diff_0.mref_m5_array_3/n1_2$1_8.D AVSS 0.18392f
C2244 comparator_slice_1.comparator_body_0.mref_m5_diff_0.mref_m5_array_3/n1_2$1_3.D AVSS 0.18393f
C2245 comparator_slice_1.comparator_body_0.mref_m5_diff_0.mref_m5_array_1/n1_2$1_8.D AVSS 0.18392f
C2246 comparator_slice_1.comparator_body_0.mref_m5_diff_0.mref_m5_array_1/n1_2$1_3.D AVSS 0.18393f
C2247 comparator_slice_1.comparator_body_0.m1_m2_diff_0.m1_m2_array_1/n1_2_15.S AVSS 0.21971f
C2248 comparator_slice_1.comparator_body_0.m1_m2_diff_0.m1_m2_array_1/n1_2_10.S AVSS 0.21969f
C2249 comparator_slice_1.comparator_body_0.m1_m2_diff_0.m1_m2_array_1/n1_2_0.S AVSS 0.21969f
C2250 comparator_slice_1.comparator_body_0.m1_m2_diff_0.m1_m2_array_1/n1_2_11.S AVSS 0.21969f
C2251 comparator_slice_1.comparator_body_0.m1_m2_diff_0.m1_m2_array_1/n1_2_3.S AVSS 0.23043f
C2252 comparator_slice_1.comparator_body_0.m1_m2_diff_0.m1_m2_array_1/n1_2_4.S AVSS 0.22982f
C2253 comparator_slice_1.comparator_body_0.m1_m2_diff_0.m1_m2_array_1/n1_2_12.S AVSS 0.21969f
C2254 comparator_slice_1.comparator_body_0.m1_m2_diff_0.m1_m2_array_0/n1_2_10.S AVSS 0.21969f
C2255 comparator_slice_1.comparator_body_0.m1_m2_diff_0.m1_m2_array_0/n1_2_0.S AVSS 0.24647f
C2256 comparator_slice_1.comparator_body_0.m1_m2_diff_0.m1_m2_array_0/n1_2_11.S AVSS 0.24468f
C2257 comparator_slice_1.comparator_body_0.m1_m2_diff_0.m1_m2_array_0/n1_2_3.S AVSS 0.23043f
C2258 comparator_slice_1.comparator_body_0.m1_m2_diff_0.m1_m2_array_0/n1_2_7.S AVSS 0.23354f
C2259 comparator_slice_1.comparator_body_0.m1_m2_diff_0.m1_m2_array_2/n1_2_12.S AVSS 0.21969f
C2260 comparator_slice_1.comparator_body_0.m1_m2_diff_0.m1_m2_array_2/n1_2_4.S AVSS 0.26515f
C2261 comparator_slice_1.comparator_body_0.m1_m2_diff_0.m1_m2_array_2/n1_2_3.S AVSS 0.23043f
C2262 comparator_slice_1.comparator_body_0.m1_m2_diff_0.m1_m2_array_2/n1_2_7.S AVSS 0.23354f
C2263 comparator_slice_1.comparator_body_0.m1_m2_diff_0.m1_m2_array_3/n1_2_12.S AVSS 0.21969f
C2264 comparator_slice_1.comparator_body_0.m1_m2_diff_0.m1_m2_array_3/n1_2_4.S AVSS 0.23136f
C2265 comparator_slice_1.comparator_body_0.m1_m2_diff_0.m1_m2_array_3/n1_2_3.S AVSS 0.23043f
C2266 comparator_slice_1.comparator_body_0.m1_m2_diff_0.m1_m2_array_3/n1_2_7.S AVSS 0.23173f
C2267 comparator_slice_1.comparator_body_0.m1_m2_diff_0.m1_m2_array_0/n1_2_12.S AVSS 0.29613f
C2268 comparator_slice_1.comparator_body_0.m1_m2_diff_0.m1_m2_array_2/n1_2_10.S AVSS 0.21969f
C2269 comparator_slice_1.comparator_body_0.m1_m2_diff_0.m1_m2_array_2/n1_2_0.S AVSS 0.21969f
C2270 comparator_slice_1.comparator_body_0.m1_m2_diff_0.m1_m2_array_2/n1_2_11.S AVSS 0.24466f
C2271 comparator_slice_1.comparator_body_0.m1_m2_diff_0.m1_m2_array_3/n1_2_10.S AVSS 0.24577f
C2272 comparator_slice_1.comparator_body_0.m1_m2_diff_0.m1_m2_array_3/n1_2_0.S AVSS 0.21969f
C2273 comparator_slice_1.comparator_body_0.m1_m2_diff_0.m1_m2_array_3/n1_2_11.S AVSS 0.24466f
C2274 comparator_slice_1.comparator_body_0.m1_m2_diff_0.m1_m2_array_1/n1_2_7.S AVSS 0.23354f
C2275 comparator_slice_1.comparator_body_0.mref_m5_diff_0.mref_m5_array_1/n1_2$1_15.D AVSS 0.23886f
C2276 comparator_slice_1.comparator_body_0.mref_m5_diff_0.mref_m5_array_0/n1_2$1_15.D AVSS 0.23886f
C2277 comparator_slice_1.comparator_body_0.mref_m5_diff_0.mref_m5_array_0/n1_2$1_6.D AVSS 0.18431f
C2278 comparator_slice_1.comparator_body_0.mref_m5_diff_0.mref_m5_array_0/n1_2$1_12.D AVSS 0.1843f
C2279 comparator_slice_1.comparator_body_0.mref_m5_diff_0.mref_m5_array_0/n1_2$1_5.D AVSS 0.1843f
C2280 comparator_slice_1.comparator_body_0.mref_m5_diff_0.mref_m5_array_1/n1_2$1_12.D AVSS 0.1843f
C2281 comparator_slice_1.comparator_body_0.mref_m5_diff_0.mref_m5_array_1/n1_2$1_6.D AVSS 0.18431f
C2282 comparator_slice_1.comparator_body_0.mref_m5_diff_0.mref_m5_array_3/n1_2$1_15.D AVSS 0.23886f
C2283 comparator_slice_1.comparator_body_0.mref_m5_diff_0.mref_m5_array_2/n1_2$1_15.D AVSS 0.23886f
C2284 comparator_slice_1.comparator_body_0.mref_m5_diff_0.mref_m5_array_2/n1_2$1_5.D AVSS 0.1843f
C2285 comparator_slice_1.comparator_body_0.mref_m5_diff_0.mref_m5_array_2/n1_2$1_6.D AVSS 0.18431f
C2286 comparator_slice_1.comparator_body_0.mref_m5_diff_0.mref_m5_array_2/n1_2$1_12.D AVSS 0.1843f
C2287 comparator_slice_1.comparator_body_0.mref_m5_diff_0.mref_m5_array_3/n1_2$1_5.D AVSS 0.1843f
C2288 comparator_slice_1.comparator_body_0.mref_m5_diff_0.mref_m5_array_3/n1_2$1_6.D AVSS 0.18431f
C2289 comparator_slice_1.comparator_body_0.mref_m5_diff_0.mref_m5_array_3/n1_2$1_12.D AVSS 0.1843f
C2290 comparator_slice_1.comparator_body_0.mref_m5_diff_0.mref_m5_array_1/n1_2$1_5.D AVSS 0.1843f
C2291 comparator_slice_1.comparator_body_0.mref_m5_diff_0.tail.n37 AVSS 0.65444f
C2292 comparator_slice_1.comparator_body_0.mref_m5_diff_0.tail.t0 AVSS 0.13146f
C2293 comparator_slice_1.comparator_body_0.m1_m2_diff_0.m1_m2_array_1/n1_2_13.S AVSS 0.21986f
C2294 comparator_slice_1.comparator_body_0.m1_m2_diff_0.m1_m2_array_1/n1_2_6.S AVSS 0.21977f
C2295 comparator_slice_1.comparator_body_0.m1_m2_diff_0.m1_m2_array_1/n1_2_1.S AVSS 0.21977f
C2296 comparator_slice_1.comparator_body_0.m1_m2_diff_0.m1_m2_array_1/n1_2_9.S AVSS 0.21977f
C2297 comparator_slice_1.comparator_body_0.m1_m2_diff_0.m1_m2_array_1/n1_2_14.S AVSS 0.22789f
C2298 comparator_slice_1.comparator_body_0.m1_m2_diff_0.m1_m2_array_0/n1_2_6.S AVSS 0.21977f
C2299 comparator_slice_1.comparator_body_0.m1_m2_diff_0.m1_m2_array_0/n1_2_1.S AVSS 0.21977f
C2300 comparator_slice_1.comparator_body_0.m1_m2_diff_0.m1_m2_array_0/n1_2_9.S AVSS 0.21977f
C2301 comparator_slice_1.comparator_body_0.m1_m2_diff_0.m1_m2_array_0/n1_2_14.S AVSS 0.21977f
C2302 comparator_slice_1.comparator_body_0.m1_m2_diff_0.m1_m2_array_3/n1_2_8.S AVSS 0.25099f
C2303 comparator_slice_1.comparator_body_0.m1_m2_diff_0.m1_m2_array_3/n1_2_2.S AVSS 0.24161f
C2304 comparator_slice_1.comparator_body_0.m1_m2_diff_0.m1_m2_array_3/n1_2_5.S AVSS 0.21977f
C2305 comparator_slice_1.comparator_body_0.m1_m2_diff_0.m1_m2_array_3/n1_2_13.S AVSS 0.21977f
C2306 comparator_slice_1.comparator_body_0.m1_m2_diff_0.m1_m2_array_2/n1_2_8.S AVSS 0.25337f
C2307 comparator_slice_1.comparator_body_0.m1_m2_diff_0.m1_m2_array_2/n1_2_2.S AVSS 0.21977f
C2308 comparator_slice_1.comparator_body_0.m1_m2_diff_0.m1_m2_array_2/n1_2_5.S AVSS 0.21977f
C2309 comparator_slice_1.comparator_body_0.m1_m2_diff_0.m1_m2_array_2/n1_2_13.S AVSS 0.24072f
C2310 comparator_slice_1.comparator_body_0.m1_m2_diff_0.m1_m2_array_0/n1_2_2.S AVSS 0.21977f
C2311 comparator_slice_1.comparator_body_0.m1_m2_diff_0.m1_m2_array_0/n1_2_5.S AVSS 0.21977f
C2312 comparator_slice_1.comparator_body_0.m1_m2_diff_0.m1_m2_array_0/n1_2_13.S AVSS 0.23479f
C2313 comparator_slice_1.comparator_body_0.m1_m2_diff_0.m1_m2_array_2/n1_2_6.S AVSS 0.21977f
C2314 comparator_slice_1.comparator_body_0.m1_m2_diff_0.m1_m2_array_2/n1_2_1.S AVSS 0.21977f
C2315 comparator_slice_1.comparator_body_0.m1_m2_diff_0.m1_m2_array_2/n1_2_9.S AVSS 0.21977f
C2316 comparator_slice_1.comparator_body_0.m1_m2_diff_0.m1_m2_array_2/n1_2_14.S AVSS 0.21977f
C2317 comparator_slice_1.comparator_body_0.m1_m2_diff_0.m1_m2_array_3/n1_2_6.S AVSS 0.21977f
C2318 comparator_slice_1.comparator_body_0.m1_m2_diff_0.m1_m2_array_3/n1_2_1.S AVSS 0.21977f
C2319 comparator_slice_1.comparator_body_0.m1_m2_diff_0.m1_m2_array_3/n1_2_9.S AVSS 0.21977f
C2320 comparator_slice_1.comparator_body_0.m1_m2_diff_0.m1_m2_array_3/n1_2_14.S AVSS 0.21977f
C2321 comparator_slice_1.comparator_body_0.m1_m2_diff_0.m1_m2_array_1/n1_2_8.S AVSS 0.21977f
C2322 comparator_slice_1.comparator_body_0.m1_m2_diff_0.m1_m2_array_1/n1_2_2.S AVSS 0.21977f
C2323 comparator_slice_1.comparator_body_0.m1_m2_diff_0.m1_m2_array_1/n1_2_5.S AVSS 0.21977f
C2324 comparator_slice_1.comparator_body_0.mref_m5_diff_0.tail.t47 AVSS 0.38506f
C2325 comparator_slice_1.comparator_body_0.mref_m5_diff_0.tail.t88 AVSS 0.13107f
C2326 comparator_slice_1.comparator_body_0.mref_m5_diff_0.tail.n38 AVSS 0.40414f
C2327 comparator_slice_1.comparator_body_0.mref_m5_diff_0.tail.t29 AVSS 0.13092f
C2328 comparator_slice_1.comparator_body_0.mref_m5_diff_0.tail.t61 AVSS 0.38506f
C2329 comparator_slice_1.comparator_body_0.mref_m5_diff_0.tail.t65 AVSS 0.13064f
C2330 comparator_slice_1.comparator_body_0.mref_m5_diff_0.tail.n39 AVSS 0.41896f
C2331 comparator_slice_1.comparator_body_0.mref_m5_diff_0.tail.t26 AVSS 0.13092f
C2332 comparator_slice_1.comparator_body_0.mref_m5_diff_0.tail.t36 AVSS 0.13148f
C2333 comparator_slice_1.comparator_body_0.mref_m5_diff_0.tail.t2 AVSS 0.13148f
C2334 comparator_slice_1.comparator_body_0.mref_m5_diff_0.tail.t63 AVSS 0.13148f
C2335 comparator_slice_1.comparator_body_0.mref_m5_diff_0.tail.t23 AVSS 0.13148f
C2336 comparator_slice_1.comparator_body_0.mref_m5_diff_0.tail.t6 AVSS 0.13092f
C2337 comparator_slice_1.comparator_body_0.mref_m5_diff_0.tail.n40 AVSS 0.37971f
C2338 comparator_slice_1.comparator_body_0.mref_m5_diff_0.tail.n41 AVSS 0.33593f
C2339 comparator_slice_1.comparator_body_0.mref_m5_diff_0.tail.t62 AVSS 0.39111f
C2340 comparator_slice_1.comparator_body_0.mref_m5_diff_0.tail.n42 AVSS 0.26245f
C2341 comparator_slice_1.comparator_body_0.mref_m5_diff_0.tail.n43 AVSS 0.33593f
C2342 comparator_slice_1.comparator_body_0.mref_m5_diff_0.tail.t14 AVSS 0.13092f
C2343 comparator_slice_1.comparator_body_0.mref_m5_diff_0.tail.n44 AVSS 0.2615f
C2344 comparator_slice_1.comparator_body_0.mref_m5_diff_0.tail.n45 AVSS 0.33593f
C2345 comparator_slice_1.comparator_body_0.mref_m5_diff_0.tail.t57 AVSS 0.40163f
C2346 comparator_slice_1.comparator_body_0.mref_m5_diff_0.tail.t56 AVSS 0.13092f
C2347 comparator_slice_1.comparator_body_0.mref_m5_diff_0.tail.t18 AVSS 0.13657f
C2348 comparator_slice_1.comparator_body_0.mref_m5_diff_0.tail.t22 AVSS 0.13092f
C2349 comparator_slice_1.comparator_body_0.mref_m5_diff_0.tail.t38 AVSS 0.38562f
C2350 comparator_slice_1.comparator_body_0.mref_m5_diff_0.tail.t42 AVSS 0.38506f
C2351 comparator_slice_1.comparator_body_0.mref_m5_diff_0.tail.t24 AVSS 23.27878f
C2352 comparator_slice_1.comparator_body_0.mref_m5_diff_0.tail.t3 AVSS 0.13092f
C2353 comparator_slice_1.comparator_body_0.mref_m5_diff_0.tail.t35 AVSS 0.13148f
C2354 comparator_slice_1.comparator_body_0.mref_m5_diff_0.tail.t33 AVSS 0.40163f
C2355 comparator_slice_1.comparator_body_0.mref_m5_diff_0.tail.t8 AVSS 0.13092f
C2356 comparator_slice_1.comparator_body_0.mref_m5_diff_0.tail.t34 AVSS 0.39111f
C2357 comparator_slice_1.comparator_body_0.mref_m5_diff_0.tail.t25 AVSS 0.13092f
C2358 comparator_slice_1.comparator_body_0.mref_m5_diff_0.tail.n46 AVSS 0.49075f
C2359 comparator_slice_1.comparator_body_0.mref_m5_diff_0.tail.t1 AVSS 0.13309f
C2360 comparator_slice_1.comparator_body_0.mref_m5_diff_0.tail.t59 AVSS 0.38506f
C2361 comparator_slice_1.comparator_body_0.mref_m5_diff_0.tail.t41 AVSS 0.38562f
C2362 comparator_slice_1.comparator_body_0.mref_m5_diff_0.tail.t17 AVSS 0.13092f
C2363 comparator_slice_1.comparator_body_0.mref_m5_diff_0.tail.t9 AVSS 0.13148f
C2364 comparator_slice_1.comparator_body_0.mref_m5_diff_0.tail.t43 AVSS 0.38506f
C2365 comparator_slice_1.comparator_body_0.mref_m5_diff_0.tail.t51 AVSS 0.13148f
C2366 comparator_slice_1.comparator_body_0.mref_m5_diff_0.tail.t53 AVSS 0.13092f
C2367 comparator_slice_1.comparator_body_0.mref_m5_diff_0.tail.t4 AVSS 0.13617f
C2368 comparator_slice_1.comparator_body_0.mref_m5_diff_0.tail.t40 AVSS 0.39111f
C2369 comparator_slice_1.comparator_body_0.mref_m5_diff_0.tail.n47 AVSS 0.38827f
C2370 comparator_slice_1.comparator_body_0.mref_m5_diff_0.tail.n48 AVSS 0.33593f
C2371 comparator_slice_1.comparator_body_0.mref_m5_diff_0.tail.t31 AVSS 0.13456f
C2372 comparator_slice_1.comparator_body_0.mref_m5_diff_0.tail.n49 AVSS 0.37971f
C2373 comparator_slice_1.comparator_body_0.mref_m5_diff_0.tail.t7 AVSS 0.13092f
C2374 comparator_slice_1.comparator_body_0.mref_m5_diff_0.tail.t19 AVSS 0.13436f
C2375 comparator_slice_1.comparator_body_0.mref_m5_diff_0.tail.t58 AVSS 0.38506f
C2376 comparator_slice_1.comparator_body_0.mref_m5_diff_0.tail.t54 AVSS 0.38562f
C2377 comparator_slice_1.comparator_body_0.mref_m5_diff_0.tail.t20 AVSS 0.14289f
C2378 comparator_slice_1.comparator_body_0.mref_m5_diff_0.tail.t12 AVSS 0.14345f
C2379 comparator_slice_1.comparator_body_0.mref_m5_diff_0.tail.t37 AVSS 0.13092f
C2380 comparator_slice_1.comparator_body_0.mref_m5_diff_0.tail.t39 AVSS 0.13148f
C2381 comparator_slice_1.comparator_body_0.mref_m5_diff_0.tail.t49 AVSS 0.13092f
C2382 comparator_slice_1.comparator_body_0.mref_m5_diff_0.tail.t15 AVSS 0.13092f
C2383 comparator_slice_1.comparator_body_0.mref_m5_diff_0.tail.t44 AVSS 0.13092f
C2384 comparator_slice_1.comparator_body_0.mref_m5_diff_0.tail.n50 AVSS 0.42701f
C2385 comparator_slice_1.comparator_body_0.mref_m5_diff_0.tail.t27 AVSS 0.14718f
C2386 comparator_slice_1.comparator_body_0.mref_m5_diff_0.tail.t13 AVSS 0.13121f
C2387 comparator_slice_1.comparator_body_0.mref_m5_diff_0.tail.t94 AVSS 0.13064f
C2388 comparator_slice_1.comparator_body_0.mref_m5_diff_0.tail.n51 AVSS 0.41656f
C2389 comparator_slice_1.comparator_body_0.m1_m2_diff_0.tail AVSS 0.54538f
C2390 comparator_slice_1.comparator_body_0.mref_m5_diff_0.tail.t5 AVSS 0.13148f
C2391 comparator_slice_1.comparator_body_0.mref_m5_diff_0.tail.t73 AVSS 0.13107f
C2392 comparator_slice_1.comparator_body_0.mref_m5_diff_0.tail.n52 AVSS 0.31466f
C2393 comparator_slice_1.comparator_body_0.mref_m5_diff_0.tail.n53 AVSS 0.57424f
C2394 comparator_slice_1.comparator_body_0.mref_m5_diff_0.tail.t87 AVSS 0.13107f
C2395 comparator_slice_1.comparator_body_0.mref_m5_diff_0.tail.n54 AVSS 0.55798f
C2396 comparator_slice_1.comparator_body_0.mref_m5_diff_0.tail.n55 AVSS 0.75574f
C2397 comparator_slice_1.comparator_body_0.mref_m5_diff_0.tail.t85 AVSS 0.13064f
C2398 comparator_slice_1.comparator_body_0.mref_m5_diff_0.tail.n56 AVSS 0.54043f
C2399 comparator_slice_1.comparator_body_0.mref_m5_diff_0.tail.t72 AVSS 0.13064f
C2400 comparator_slice_1.comparator_body_0.mref_m5_diff_0.tail.n57 AVSS 0.19943f
C2401 comparator_slice_1.comparator_body_0.mref_m5_diff_0.tail.n58 AVSS 0.61876f
C2402 comparator_slice_1.comparator_body_0.mref_m5_diff_0.tail.t78 AVSS 0.13064f
C2403 comparator_slice_1.comparator_body_0.mref_m5_diff_0.tail.n59 AVSS 0.68128f
C2404 comparator_slice_1.comparator_body_0.mref_m5_diff_0.tail.t84 AVSS 0.13107f
C2405 comparator_slice_1.comparator_body_0.mref_m5_diff_0.tail.n60 AVSS 0.19862f
C2406 comparator_slice_1.comparator_body_0.mref_m5_diff_0.tail.n61 AVSS 0.31101f
C2407 comparator_slice_1.comparator_body_0.mref_m5_diff_0.tail.n62 AVSS 0.61844f
C2408 comparator_slice_1.comparator_body_0.mref_m5_diff_0.tail.t69 AVSS 0.70341f
C2409 comparator_slice_1.comparator_body_0.mref_m5_diff_0.tail.n63 AVSS 0.19943f
C2410 comparator_slice_1.comparator_body_0.mref_m5_diff_0.tail.t67 AVSS 0.13064f
C2411 comparator_slice_1.comparator_body_0.mref_m5_diff_0.tail.t95 AVSS 0.13107f
C2412 comparator_slice_1.comparator_body_0.mref_m5_diff_0.tail.n64 AVSS 0.61844f
C2413 comparator_slice_1.comparator_body_0.mref_m5_diff_0.tail.n65 AVSS 0.84443f
C2414 comparator_slice_1.comparator_body_0.mref_m5_diff_0.tail.n66 AVSS 0.31466f
C2415 comparator_slice_1.comparator_body_0.mref_m5_diff_0.tail.t70 AVSS 0.13064f
C2416 comparator_slice_1.comparator_body_0.mref_m5_diff_0.tail.t76 AVSS 0.13107f
C2417 comparator_slice_1.comparator_body_0.mref_m5_diff_0.tail.t89 AVSS 0.13107f
C2418 comparator_slice_1.comparator_body_0.mref_m5_diff_0.tail.n67 AVSS 0.1986f
C2419 comparator_slice_1.comparator_body_0.mref_m5_diff_0.tail.n68 AVSS 0.43896f
C2420 comparator_slice_1.comparator_body_0.mref_m5_diff_0.tail.t80 AVSS 0.13064f
C2421 comparator_slice_1.comparator_body_0.mref_m5_diff_0.tail.n69 AVSS 0.19943f
C2422 comparator_slice_1.comparator_body_0.mref_m5_diff_0.tail.t74 AVSS 0.70341f
C2423 comparator_slice_1.comparator_body_0.mref_m5_diff_0.tail.t91 AVSS 0.70384f
C2424 comparator_slice_1.comparator_body_0.mref_m5_diff_0.tail.n70 AVSS 0.73491f
C2425 comparator_slice_1.comparator_body_0.mref_m5_diff_0.tail.n71 AVSS 0.76957f
C2426 comparator_slice_1.comparator_body_0.mref_m5_diff_0.tail.t86 AVSS 0.70384f
C2427 comparator_slice_1.comparator_body_0.mref_m5_diff_0.tail.n72 AVSS 0.1986f
C2428 comparator_slice_1.comparator_body_0.mref_m5_diff_0.tail.n73 AVSS 0.62185f
C2429 comparator_slice_1.comparator_body_0.mref_m5_diff_0.tail.n74 AVSS 0.51902f
C2430 comparator_slice_1.comparator_body_0.mref_m5_diff_0.tail.n75 AVSS 0.31466f
C2431 comparator_slice_1.comparator_body_0.mref_m5_diff_0.tail.t82 AVSS 0.70405f
C2432 comparator_slice_1.comparator_body_0.mref_m5_diff_0.tail.t81 AVSS 0.13107f
C2433 comparator_slice_1.comparator_body_0.mref_m5_diff_0.tail.n76 AVSS 0.19862f
C2434 comparator_slice_1.comparator_body_0.mref_m5_diff_0.tail.n77 AVSS 0.31101f
C2435 comparator_slice_1.comparator_body_0.mref_m5_diff_0.tail.n78 AVSS 0.68128f
C2436 comparator_slice_1.comparator_body_0.mref_m5_diff_0.tail.n79 AVSS 0.49972f
C2437 comparator_slice_1.comparator_body_0.mref_m5_diff_0.tail.t77 AVSS 0.13107f
C2438 comparator_slice_1.comparator_body_0.mref_m5_diff_0.tail.t68 AVSS 0.13064f
C2439 comparator_slice_1.comparator_body_0.mref_m5_diff_0.tail.n80 AVSS 0.68128f
C2440 comparator_slice_1.comparator_body_0.mref_m5_diff_0.tail.n81 AVSS 0.57763f
C2441 comparator_slice_1.comparator_body_0.mref_m5_diff_0.tail.n82 AVSS 0.49972f
C2442 comparator_slice_1.comparator_body_0.mref_m5_diff_0.tail.t64 AVSS 0.13064f
C2443 comparator_slice_1.comparator_body_0.mref_m5_diff_0.tail.n83 AVSS 0.19943f
C2444 comparator_slice_1.comparator_body_0.mref_m5_diff_0.tail.t83 AVSS 0.13064f
C2445 comparator_slice_1.comparator_body_0.mref_m5_diff_0.tail.t90 AVSS 0.13107f
C2446 comparator_slice_1.comparator_body_0.mref_m5_diff_0.tail.n84 AVSS 0.19862f
C2447 comparator_slice_1.comparator_body_0.mref_m5_diff_0.tail.n85 AVSS 0.31101f
C2448 comparator_slice_1.comparator_body_0.mref_m5_diff_0.tail.n86 AVSS 0.61844f
C2449 comparator_slice_1.comparator_body_0.mref_m5_diff_0.tail.n87 AVSS 0.57763f
C2450 comparator_slice_1.comparator_body_0.mref_m5_diff_0.tail.n88 AVSS 0.84443f
C2451 comparator_slice_1.comparator_body_0.mref_m5_diff_0.tail.n89 AVSS 0.57424f
C2452 comparator_slice_1.comparator_body_0.mref_m5_diff_0.tail.n90 AVSS 0.50295f
C2453 comparator_slice_1.comparator_body_0.mref_m5_diff_0.tail.n91 AVSS 0.51518f
C2454 comparator_slice_1.comparator_body_0.mref_m5_diff_0.tail.n92 AVSS 0.40798f
C2455 comparator_slice_1.comparator_body_0.mref_m5_diff_0.tail.t28 AVSS 0.13462f
C2456 comparator_slice_1.comparator_body_0.mref_m5_diff_0.tail.t46 AVSS 0.38562f
C2457 comparator_slice_1.comparator_body_0.mref_m5_diff_0.tail.t16 AVSS 0.13148f
C2458 comparator_slice_1.comparator_body_0.mref_m5_diff_0.tail.t48 AVSS 0.13148f
C2459 comparator_slice_1.comparator_body_0.mref_m5_diff_0.tail.n93 AVSS 0.41743f
C2460 comparator_slice_1.comparator_body_0.mref_m5_diff_0.tail.n94 AVSS 0.44049f
C2461 comparator_slice_1.comparator_body_0.mref_m5_diff_0.tail.n95 AVSS 0.57424f
C2462 comparator_slice_1.comparator_body_0.mref_m5_diff_0.tail.t71 AVSS 0.13107f
C2463 comparator_slice_1.comparator_body_0.mref_m5_diff_0.tail.n96 AVSS 0.1986f
C2464 comparator_slice_1.comparator_body_0.mref_m5_diff_0.tail.n97 AVSS 0.50295f
C2465 comparator_slice_1.comparator_body_0.mref_m5_diff_0.tail.n98 AVSS 0.51667f
C2466 comparator_slice_1.comparator_body_0.mref_m5_diff_0.tail.t92 AVSS 0.70341f
C2467 comparator_slice_1.comparator_body_0.mref_m5_diff_0.tail.t10 AVSS 0.13148f
C2468 comparator_slice_1.comparator_body_0.mref_m5_diff_0.tail.t79 AVSS 0.13107f
C2469 comparator_slice_1.comparator_body_0.mref_m5_diff_0.tail.n99 AVSS 0.40649f
C2470 comparator_slice_1.comparator_body_0.mref_m5_diff_0.tail.t60 AVSS 0.13148f
C2471 comparator_slice_1.comparator_body_0.mref_m5_diff_0.tail.t32 AVSS 0.13148f
C2472 comparator_slice_1.comparator_body_0.mref_m5_diff_0.tail.t30 AVSS 0.13148f
C2473 comparator_slice_1.comparator_body_0.mref_m5_diff_0.tail.n100 AVSS 0.37374f
C2474 comparator_slice_1.comparator_body_0.mref_m5_diff_0.tail.n101 AVSS 0.42514f
C2475 comparator_slice_1.comparator_body_0.mref_m5_diff_0.tail.n102 AVSS 0.43278f
C2476 comparator_slice_1.comparator_body_0.mref_m5_diff_0.tail.n103 AVSS 0.31466f
C2477 comparator_slice_1.comparator_body_0.mref_m5_diff_0.tail.t75 AVSS 0.13064f
C2478 comparator_slice_1.comparator_body_0.mref_m5_diff_0.tail.t66 AVSS 0.13107f
C2479 comparator_slice_1.comparator_body_0.mref_m5_diff_0.tail.n104 AVSS 0.19862f
C2480 comparator_slice_1.comparator_body_0.mref_m5_diff_0.tail.n105 AVSS 0.31101f
C2481 comparator_slice_1.comparator_body_0.mref_m5_diff_0.tail.n106 AVSS 0.68128f
C2482 comparator_slice_1.comparator_body_0.mref_m5_diff_0.tail.n107 AVSS 0.49972f
C2483 comparator_slice_1.comparator_body_0.mref_m5_diff_0.tail.n108 AVSS 0.57763f
C2484 comparator_slice_1.comparator_body_0.mref_m5_diff_0.tail.n109 AVSS 0.84443f
C2485 comparator_slice_1.comparator_body_0.mref_m5_diff_0.tail.n110 AVSS 0.54437f
C2486 comparator_slice_1.comparator_body_0.mref_m5_diff_0.tail.t93 AVSS 0.13107f
C2487 comparator_slice_1.comparator_body_0.mref_m5_diff_0.tail.n111 AVSS 0.1986f
C2488 comparator_slice_1.comparator_body_0.mref_m5_diff_0.tail.n112 AVSS 0.50295f
C2489 comparator_slice_1.comparator_body_0.mref_m5_diff_0.tail.n113 AVSS 0.52029f
C2490 comparator_slice_1.comparator_body_0.mref_m5_diff_0.tail.n114 AVSS 0.40287f
C2491 comparator_slice_1.comparator_body_0.mref_m5_diff_0.tail.t52 AVSS 0.13148f
C2492 comparator_slice_1.comparator_body_0.mref_m5_diff_0.tail.t11 AVSS 0.13148f
C2493 comparator_slice_1.comparator_body_0.mref_m5_diff_0.tail.t45 AVSS 0.13148f
C2494 comparator_slice_1.comparator_body_0.mref_m5_diff_0.tail.t50 AVSS 0.13148f
C2495 comparator_slice_1.comparator_body_0.mref_m5_diff_0.tail.n115 AVSS 0.32829f
C2496 comparator_slice_1.comparator_body_0.mref_m5_diff_0.tail.t21 AVSS 0.13148f
C2497 comparator_slice_1.comparator_body_0.mref_m5_diff_0.tail.t55 AVSS 0.13148f
C2498 comparator_slice_1.comparator_body_0.mref_m5_diff_0.tail.n116 AVSS 0.3232f
C2499 comparator_slice_1.comparator_body_0.mref_m5_diff_0.tail.n117 AVSS 0.35949f
C2500 comparator_slice_0.comparator_body_0.m3_m4_diff_0.m3_m4_array_1/p1_2$1_13.D AVSS 8.22886f
C2501 comparator_slice_0.comparator_body_0.m3_m4_diff_0.n1.n0 AVSS 1.6482f
C2502 comparator_slice_0.comparator_body_0.m3_m4_diff_0.m3_m4_array_3/p1_2$1_7.D AVSS 2.20662f
C2503 comparator_slice_0.comparator_body_0.m3_m4_diff_0.n1.n2 AVSS 0.84748f
C2504 comparator_slice_0.comparator_body_0.m3_m4_diff_0.n1.n3 AVSS 0.84281f
C2505 comparator_slice_0.comparator_body_0.m3_m4_diff_0.m3_m4_array_1/p1_2$1_7.D AVSS 2.20662f
C2506 comparator_slice_0.comparator_body_0.m3_m4_diff_0.n1.n4 AVSS 0.84748f
C2507 comparator_slice_0.comparator_body_0.m3_m4_diff_0.n1.n5 AVSS 0.84281f
C2508 comparator_slice_0.comparator_body_0.m3_m4_diff_0.m3_m4_array_2/p1_2$1_10.D AVSS 1.39561f
C2509 comparator_slice_0.comparator_body_0.m3_m4_diff_0.m3_m4_array_2/p1_2$1_7.D AVSS 2.20662f
C2510 comparator_slice_0.comparator_body_0.m3_m4_diff_0.n1.n6 AVSS 0.84748f
C2511 comparator_slice_0.comparator_body_0.m3_m4_diff_0.m3_m4_array_0/p1_2$1_7.D AVSS 2.20662f
C2512 comparator_slice_0.comparator_body_0.m3_m4_diff_0.m3_m4_array_3/p1_2$1_14.D AVSS 2.29465f
C2513 comparator_slice_0.comparator_body_0.m3_m4_diff_0.m3_m4_array_2/p1_2$1_14.D AVSS 2.22069f
C2514 comparator_slice_0.comparator_body_0.m3_m4_diff_0.m3_m4_array_1/p1_2$1_14.D AVSS 2.22069f
C2515 comparator_slice_0.comparator_body_0.m3_m4_diff_0.m3_m4_array_0/p1_2$1_14.D AVSS 2.22069f
C2516 comparator_slice_0.comparator_body_0.m3_m4_diff_0.m3_m4_array_3/p1_2$1_4.D AVSS 2.22204f
C2517 comparator_slice_0.comparator_body_0.m3_m4_diff_0.m3_m4_array_1/p1_2$1_4.D AVSS 2.22204f
C2518 comparator_slice_0.comparator_body_0.m3_m4_diff_0.m3_m4_array_0/p1_2$1_4.D AVSS 2.22204f
C2519 comparator_slice_0.comparator_body_0.m3_m4_diff_0.m3_m4_array_2/p1_2$1_4.D AVSS 1.44448f
C2520 comparator_slice_0.comparator_body_0.m3_m4_diff_0.m3_m4_array_2/p1_2$1_13.D AVSS 1.8297f
C2521 comparator_slice_0.comparator_body_0.m3_m4_diff_0.m3_m4_array_3/p1_2$1_13.D AVSS 1.33916f
C2522 comparator_slice_0.comparator_body_0.m3_m4_diff_0.n1.n8 AVSS 0.84298f
C2523 comparator_slice_0.comparator_body_0.m3_m4_diff_0.n1.n11 AVSS 0.84298f
C2524 comparator_slice_0.comparator_body_0.m3_m4_diff_0.n1.n16 AVSS 2.25372f
C2525 comparator_slice_0.comparator_body_0.m3_m4_diff_0.n1.n17 AVSS 1.6809f
C2526 comparator_slice_0.comparator_body_0.m3_m4_diff_0.m3_m4_array_1/p1_2$1_9.D AVSS 1.27239f
C2527 comparator_slice_0.comparator_body_0.m3_m4_diff_0.n1.n20 AVSS 2.18596f
C2528 comparator_slice_0.comparator_body_0.m3_m4_diff_0.n1.n21 AVSS 1.14709f
C2529 comparator_slice_0.comparator_body_0.m3_m4_diff_0.n1.n22 AVSS 1.48832f
C2530 comparator_slice_0.comparator_body_0.m3_m4_diff_0.n1.n23 AVSS 2.06982f
C2531 comparator_slice_0.comparator_body_0.m3_m4_diff_0.n1.n24 AVSS 2.69007f
C2532 comparator_slice_0.comparator_body_0.m3_m4_diff_0.n1.n25 AVSS 2.69226f
C2533 comparator_slice_0.comparator_body_0.m3_m4_diff_0.n1.n26 AVSS 2.69226f
C2534 comparator_slice_0.comparator_body_0.m3_m4_diff_0.n1.n27 AVSS 2.69226f
C2535 comparator_slice_0.comparator_body_0.m3_m4_diff_0.n1.n28 AVSS 2.41873f
C2536 comparator_slice_0.comparator_body_0.m3_m4_diff_0.n1.n29 AVSS 1.66803f
C2537 comparator_slice_0.comparator_body_0.m3_m4_diff_0.n1.n32 AVSS 1.97677f
C2538 comparator_slice_0.comparator_body_0.m3_m4_diff_0.n1.n33 AVSS 1.98999f
C2539 comparator_slice_0.comparator_body_0.m3_m4_diff_0.n1.n34 AVSS 1.95695f
C2540 comparator_slice_0.comparator_body_0.m3_m4_diff_0.n1.n36 AVSS 2.56325f
C2541 comparator_slice_0.comparator_body_0.m3_m4_diff_0.n1.n37 AVSS 1.97677f
C2542 comparator_slice_0.comparator_body_0.m3_m4_diff_0.n1.n38 AVSS 1.97677f
C2543 comparator_slice_0.comparator_body_0.m3_m4_diff_0.n1.n39 AVSS 3.32799f
C2544 comparator_slice_0.comparator_body_0.m3_m4_diff_0.m3_m4_array_2/p1_2$1_9.D AVSS 1.79289f
C2545 comparator_slice_0.comparator_body_0.m3_m4_diff_0.m3_m4_array_0/p1_2$1_13.D AVSS 1.72335f
C2546 comparator_slice_0.comparator_body_0.m3_m4_diff_0.n1.n41 AVSS 0.68922f
C2547 comparator_slice_0.comparator_body_0.m3_m4_diff_0.n1.n42 AVSS 6.0915f
C2548 comparator_slice_0.comparator_body_0.m1_m2_diff_0.n1 AVSS 4.90863f
C2549 comparator_slice_0.comparator_body_0.m3_m4_diff_0.n1.n44 AVSS 5.27713f
C2550 comparator_slice_0.comparator_body_0.m3_m4_diff_0.m3_m4_array_2/p1_2$1_1.D AVSS 1.33814f
C2551 comparator_slice_0.comparator_body_0.m3_m4_diff_0.n1.n47 AVSS 0.80073f
C2552 comparator_slice_0.comparator_body_0.m3_m4_diff_0.m3_m4_array_1/p1_2$1_1.D AVSS 1.40042f
C2553 comparator_slice_0.comparator_body_0.m3_m4_diff_0.m3_m4_array_3/p1_2$1_1.D AVSS 1.40042f
C2554 comparator_slice_0.comparator_body_0.m3_m4_diff_0.n1.n48 AVSS 0.80072f
C2555 comparator_slice_0.comparator_body_0.m3_m4_diff_0.m3_m4_array_0/p1_2$1_1.D AVSS 1.40042f
C2556 comparator_slice_0.comparator_body_0.m3_m4_diff_0.m3_m4_array_3/p1_2$1_9.D AVSS 1.36231f
C2557 comparator_slice_0.comparator_body_0.m3_m4_diff_0.m3_m4_array_0/p1_2$1_9.D AVSS 1.28033f
C2558 comparator_slice_0.comparator_body_0.m3_m4_diff_0.m3_m4_array_1/p1_2$1_0.D AVSS 1.35248f
C2559 comparator_slice_0.comparator_body_0.m3_m4_diff_0.m3_m4_array_1/p1_2$1_10.D AVSS 1.39561f
C2560 comparator_slice_0.comparator_body_0.m3_m4_diff_0.m3_m4_array_2/p1_2$1_0.D AVSS 1.35248f
C2561 comparator_slice_0.comparator_body_0.m3_m4_diff_0.m3_m4_array_3/p1_2$1_0.D AVSS 1.35248f
C2562 comparator_slice_0.comparator_body_0.m3_m4_diff_0.m3_m4_array_3/p1_2$1_10.D AVSS 1.39561f
C2563 comparator_slice_0.comparator_body_0.m3_m4_diff_0.m3_m4_array_0/p1_2$1_0.D AVSS 1.35248f
C2564 comparator_slice_0.comparator_body_0.m3_m4_diff_0.m3_m4_array_0/p1_2$1_10.D AVSS 1.39561f
C2565 comparator_slice_0.comparator_body_0.m3_m4_diff_0.n1.t83 AVSS 0.21954f
C2566 comparator_slice_0.comparator_body_0.m3_m4_diff_0.n1.t33 AVSS 1.73201f
C2567 comparator_slice_0.comparator_body_0.m3_m4_diff_0.n1.t63 AVSS 0.21954f
C2568 comparator_slice_0.comparator_body_0.m3_m4_diff_0.n1.t95 AVSS 0.21954f
C2569 comparator_slice_0.comparator_body_0.m3_m4_diff_0.n1.t39 AVSS 0.21954f
C2570 comparator_slice_0.comparator_body_0.m3_m4_diff_0.n1.t75 AVSS 0.21954f
C2571 comparator_slice_0.comparator_body_0.m3_m4_diff_0.n1.t51 AVSS 0.21954f
C2572 comparator_slice_0.comparator_body_0.m3_m4_diff_0.n1.t45 AVSS 0.21954f
C2573 comparator_slice_0.comparator_body_0.m3_m4_diff_0.n1.t73 AVSS 0.21954f
C2574 comparator_slice_0.comparator_body_0.m3_m4_diff_0.n1.t87 AVSS 0.21954f
C2575 comparator_slice_0.comparator_body_0.m3_m4_diff_0.n1.t35 AVSS 1.73201f
C2576 comparator_slice_0.comparator_body_0.m3_m4_diff_0.n1.t93 AVSS 0.21954f
C2577 comparator_slice_0.comparator_body_0.m3_m4_diff_0.n1.n49 AVSS 1.07937f
C2578 comparator_slice_0.comparator_body_0.m3_m4_diff_0.n1.n50 AVSS 2.02296f
C2579 comparator_slice_0.comparator_body_0.m1_m2_diff_0.m1_m2_array_3/n1_2_4.D AVSS 0.36113f
C2580 comparator_slice_0.comparator_body_0.m1_m2_diff_0.m1_m2_array_3/n1_2_10.D AVSS 0.32361f
C2581 comparator_slice_0.comparator_body_0.m1_m2_diff_0.m1_m2_array_3/n1_2_7.D AVSS 0.35894f
C2582 comparator_slice_0.comparator_body_0.m1_m2_diff_0.m1_m2_array_2/n1_2_7.D AVSS 0.35894f
C2583 comparator_slice_0.comparator_body_0.m1_m2_diff_0.m1_m2_array_2/n1_2_4.D AVSS 0.35894f
C2584 comparator_slice_0.comparator_body_0.m1_m2_diff_0.m1_m2_array_2/n1_2_10.D AVSS 0.32357f
C2585 comparator_slice_0.comparator_body_0.m1_m2_diff_0.m1_m2_array_2/n1_2_11.D AVSS 0.33725f
C2586 comparator_slice_0.comparator_body_0.m1_m2_diff_0.m1_m2_array_0/n1_2_11.D AVSS 0.41843f
C2587 comparator_slice_0.comparator_body_0.m1_m2_diff_0.m1_m2_array_0/n1_2_10.D AVSS 0.32357f
C2588 comparator_slice_0.comparator_body_0.m1_m2_diff_0.m1_m2_array_0/n1_2_7.D AVSS 0.35894f
C2589 comparator_slice_0.comparator_body_0.m1_m2_diff_0.m1_m2_array_0/n1_2_4.D AVSS 0.35894f
C2590 comparator_slice_0.comparator_body_0.m1_m2_diff_0.m1_m2_array_1/n1_2_7.D AVSS 0.35894f
C2591 comparator_slice_0.comparator_body_0.m1_m2_diff_0.m1_m2_array_1/n1_2_4.D AVSS 0.35894f
C2592 comparator_slice_0.comparator_body_0.m1_m2_diff_0.m1_m2_array_1/n1_2_10.D AVSS 0.32357f
C2593 comparator_slice_0.comparator_body_0.m1_m2_diff_0.m1_m2_array_1/n1_2_11.D AVSS 0.4081f
C2594 comparator_slice_0.comparator_body_0.m1_m2_diff_0.m1_m2_array_3/n1_2_11.D AVSS 0.87142f
C2595 comparator_slice_0.comparator_body_0.m1_m2_diff_0.m1_m2_array_3/n1_2_1.D AVSS 0.35978f
C2596 comparator_slice_0.comparator_body_0.m1_m2_diff_0.m1_m2_array_3/n1_2_2.D AVSS 0.3243f
C2597 comparator_slice_0.comparator_body_0.m1_m2_diff_0.m1_m2_array_3/n1_2_13.D AVSS 0.3243f
C2598 comparator_slice_0.comparator_body_0.m1_m2_diff_0.m1_m2_array_2/n1_2_1.D AVSS 0.35978f
C2599 comparator_slice_0.comparator_body_0.m1_m2_diff_0.m1_m2_array_2/n1_2_14.D AVSS 0.75964f
C2600 comparator_slice_0.comparator_body_0.m1_m2_diff_0.m1_m2_array_0/n1_2_1.D AVSS 0.35978f
C2601 comparator_slice_0.comparator_body_0.m1_m2_diff_0.m1_m2_array_0/n1_2_14.D AVSS 0.75964f
C2602 comparator_slice_0.comparator_body_0.m1_m2_diff_0.m1_m2_array_2/n1_2_13.D AVSS 0.3243f
C2603 comparator_slice_0.comparator_body_0.m1_m2_diff_0.m1_m2_array_2/n1_2_2.D AVSS 0.3243f
C2604 comparator_slice_0.comparator_body_0.m1_m2_diff_0.m1_m2_array_0/n1_2_2.D AVSS 0.3243f
C2605 comparator_slice_0.comparator_body_0.m1_m2_diff_0.m1_m2_array_0/n1_2_13.D AVSS 0.3243f
C2606 comparator_slice_0.comparator_body_0.m1_m2_diff_0.m1_m2_array_1/n1_2_1.D AVSS 0.35978f
C2607 comparator_slice_0.comparator_body_0.m1_m2_diff_0.m1_m2_array_1/n1_2_14.D AVSS 0.75964f
C2608 comparator_slice_0.comparator_body_0.m1_m2_diff_0.m1_m2_array_1/n1_2_2.D AVSS 0.3243f
C2609 comparator_slice_0.comparator_body_0.m1_m2_diff_0.m1_m2_array_1/n1_2_13.D AVSS 0.31123f
C2610 comparator_slice_0.comparator_body_0.m1_m2_diff_0.m1_m2_array_3/n1_2_14.D AVSS 0.75964f
C2611 comparator_slice_0.comparator_body_0.m3_m4_diff_0.n1.t21 AVSS 0.22135f
C2612 comparator_slice_0.comparator_body_0.m3_m4_diff_0.n1.t8 AVSS 0.45694f
C2613 comparator_slice_0.comparator_body_0.m3_m4_diff_0.n1.t30 AVSS 0.22063f
C2614 comparator_slice_0.comparator_body_0.m3_m4_diff_0.n1.t57 AVSS 1.73108f
C2615 comparator_slice_0.comparator_body_0.m3_m4_diff_0.n1.t4 AVSS 0.45694f
C2616 comparator_slice_0.comparator_body_0.m3_m4_diff_0.n1.t13 AVSS 0.45694f
C2617 comparator_slice_0.comparator_body_0.m3_m4_diff_0.n1.t59 AVSS 1.73108f
C2618 comparator_slice_0.comparator_body_0.m3_m4_diff_0.n1.t79 AVSS 1.73108f
C2619 comparator_slice_0.comparator_body_0.m3_m4_diff_0.n1.t65 AVSS 0.21954f
C2620 comparator_slice_0.comparator_body_0.m3_m4_diff_0.n1.t47 AVSS 0.2186f
C2621 comparator_slice_0.comparator_body_0.m3_m4_diff_0.n1.t53 AVSS 0.2186f
C2622 comparator_slice_0.comparator_body_0.m3_m4_diff_0.n1.t61 AVSS 1.73108f
C2623 comparator_slice_0.comparator_body_0.m3_m4_diff_0.n1.t41 AVSS 0.21954f
C2624 comparator_slice_0.comparator_body_0.m3_m4_diff_0.n1.t85 AVSS 0.2186f
C2625 comparator_slice_0.comparator_body_0.m3_m4_diff_0.n1.t43 AVSS 0.2186f
C2626 comparator_slice_0.comparator_body_0.m3_m4_diff_0.n1.t69 AVSS 0.21954f
C2627 comparator_slice_0.comparator_body_0.m3_m4_diff_0.n1.n51 AVSS 0.79605f
C2628 comparator_slice_0.comparator_body_0.m3_m4_diff_0.n1.n52 AVSS 0.79605f
C2629 comparator_slice_0.comparator_body_0.m3_m4_diff_0.n1.t67 AVSS 0.2186f
C2630 comparator_slice_0.comparator_body_0.m3_m4_diff_0.n1.t91 AVSS 0.2186f
C2631 comparator_slice_0.comparator_body_0.m3_m4_diff_0.n1.t25 AVSS 0.22135f
C2632 comparator_slice_0.comparator_body_0.m3_m4_diff_0.n1.t12 AVSS 0.22135f
C2633 comparator_slice_0.comparator_body_0.m3_m4_diff_0.n1.t19 AVSS 0.45694f
C2634 comparator_slice_0.comparator_body_0.m3_m4_diff_0.n1.t6 AVSS 0.22135f
C2635 comparator_slice_0.comparator_body_0.m3_m4_diff_0.n1.t24 AVSS 0.45694f
C2636 comparator_slice_0.comparator_body_0.m3_m4_diff_0.n1.t23 AVSS 0.22135f
C2637 comparator_slice_0.comparator_body_0.m3_m4_diff_0.n1.t14 AVSS 0.46332f
C2638 comparator_slice_0.comparator_body_0.m3_m4_diff_0.n1.t28 AVSS 0.45767f
C2639 comparator_slice_0.comparator_body_0.m3_m4_diff_0.n1.t11 AVSS 0.45694f
C2640 comparator_slice_0.comparator_body_0.m3_m4_diff_0.n1.t26 AVSS 0.22135f
C2641 comparator_slice_0.comparator_body_0.m3_m4_diff_0.n1.t27 AVSS 0.45694f
C2642 comparator_slice_0.comparator_body_0.m3_m4_diff_0.n1.t1 AVSS 0.22135f
C2643 comparator_slice_0.comparator_body_0.m3_m4_diff_0.n1.t9 AVSS 0.22135f
C2644 comparator_slice_0.comparator_body_0.m3_m4_diff_0.n1.n53 AVSS 1.62309f
C2645 comparator_slice_0.comparator_body_0.m3_m4_diff_0.n1.t18 AVSS 0.46332f
C2646 comparator_slice_0.comparator_body_0.m3_m4_diff_0.n1.t10 AVSS 0.22135f
C2647 comparator_slice_0.comparator_body_0.m3_m4_diff_0.n1.t5 AVSS 0.45694f
C2648 comparator_slice_0.comparator_body_0.m3_m4_diff_0.n1.t2 AVSS 0.45767f
C2649 comparator_slice_0.comparator_body_0.m3_m4_diff_0.n1.t22 AVSS 0.45694f
C2650 comparator_slice_0.comparator_body_0.m3_m4_diff_0.n1.t7 AVSS 0.45694f
C2651 comparator_slice_0.comparator_body_0.m3_m4_diff_0.n1.t31 AVSS 0.45694f
C2652 comparator_slice_0.comparator_body_0.m3_m4_diff_0.n1.t49 AVSS 0.2186f
C2653 comparator_slice_0.comparator_body_0.m3_m4_diff_0.n1.t37 AVSS 0.2186f
C2654 comparator_slice_0.comparator_body_0.m3_m4_diff_0.n1.t89 AVSS 0.2186f
C2655 comparator_slice_0.comparator_body_0.m3_m4_diff_0.n1.t55 AVSS 0.21954f
C2656 comparator_slice_0.comparator_body_0.m3_m4_diff_0.n1.t77 AVSS 1.73108f
C2657 comparator_slice_0.comparator_body_0.m3_m4_diff_0.n1.t71 AVSS 0.2186f
C2658 comparator_slice_0.comparator_body_0.m3_m4_diff_0.n1.t81 AVSS 0.2186f
C2659 comparator_slice_0.comparator_body_0.m3_m4_diff_0.n1.t20 AVSS 0.45694f
C2660 comparator_slice_0.comparator_body_0.m3_m4_diff_0.n1.t3 AVSS 0.45694f
C2661 comparator_slice_0.comparator_body_0.m3_m4_diff_0.n1.n54 AVSS 1.42433f
C2662 comparator_slice_0.comparator_body_0.m3_m4_diff_0.n1.n55 AVSS 0.87958f
C2663 comparator_slice_0.comparator_body_0.m3_m4_diff_0.n1.n56 AVSS 0.80073f
C2664 comparator_slice_0.comparator_body_0.m3_m4_diff_0.n1.n57 AVSS 1.44705f
C2665 comparator_slice_0.comparator_body_0.m3_m4_diff_0.n1.n58 AVSS 1.65773f
C2666 comparator_slice_0.comparator_body_0.m3_m4_diff_0.n1.n59 AVSS 1.70925f
C2667 comparator_slice_0.comparator_body_0.m3_m4_diff_0.n1.t29 AVSS 0.22135f
C2668 comparator_slice_0.comparator_body_0.m3_m4_diff_0.n1.n60 AVSS 3.48613f
C2669 comparator_slice_0.comparator_body_0.m3_m4_diff_0.n1.n61 AVSS 1.23145f
C2670 comparator_slice_0.comparator_body_0.m3_m4_diff_0.n1.t17 AVSS 0.22062f
C2671 comparator_slice_0.comparator_body_0.m3_m4_diff_0.n1.t16 AVSS 0.22135f
C2672 comparator_slice_0.comparator_body_0.m3_m4_diff_0.n1.t15 AVSS 0.22135f
C2673 comparator_slice_0.comparator_body_0.m3_m4_diff_0.n1.t0 AVSS 0.45694f
C2674 comparator_slice_0.comparator_body_0.mref_m5_diff_0.tail.n0 AVSS 22.054f
C2675 comparator_slice_0.comparator_body_0.mref_m5_diff_0.tail.n1 AVSS 0.45661f
C2676 comparator_slice_0.comparator_body_0.mref_m5_diff_0.tail.n2 AVSS 3.58044f
C2677 comparator_slice_0.comparator_body_0.mref_m5_diff_0.tail.n3 AVSS 32.4118f
C2678 comparator_slice_0.comparator_body_0.mref_m5_diff_0.tail.n4 AVSS 0.92557f
C2679 comparator_slice_0.comparator_body_0.mref_m5_diff_0.tail.n6 AVSS 0.63511f
C2680 comparator_slice_0.comparator_body_0.m1_m2_diff_0.m1_m2_array_3/n1_2_0.S AVSS 0.23294f
C2681 comparator_slice_0.comparator_body_0.mref_m5_diff_0.tail.n7 AVSS 0.56988f
C2682 comparator_slice_0.comparator_body_0.mref_m5_diff_0.tail.n8 AVSS 0.59908f
C2683 comparator_slice_0.comparator_body_0.mref_m5_diff_0.tail.n10 AVSS 0.37374f
C2684 comparator_slice_0.comparator_body_0.m1_m2_diff_0.m1_m2_array_3/n1_2_8.S AVSS 0.25082f
C2685 comparator_slice_0.comparator_body_0.mref_m5_diff_0.tail.n11 AVSS 0.65012f
C2686 comparator_slice_0.comparator_body_0.mref_m5_diff_0.tail.n12 AVSS 0.65012f
C2687 comparator_slice_0.comparator_body_0.m1_m2_diff_0.m1_m2_array_3/n1_2_15.S AVSS 0.2967f
C2688 comparator_slice_0.comparator_body_0.m1_m2_diff_0.m1_m2_array_3/n1_2_14.S AVSS 0.23793f
C2689 comparator_slice_0.comparator_body_0.m1_m2_diff_0.m1_m2_array_0/n1_2_7.S AVSS 0.23043f
C2690 comparator_slice_0.comparator_body_0.m1_m2_diff_0.m1_m2_array_2/n1_2_7.S AVSS 0.23365f
C2691 comparator_slice_0.comparator_body_0.mref_m5_diff_0.tail.n13 AVSS 0.59813f
C2692 comparator_slice_0.comparator_body_0.mref_m5_diff_0.tail.n14 AVSS 0.78246f
C2693 comparator_slice_0.comparator_body_0.m1_m2_diff_0.m1_m2_array_2/n1_2_14.S AVSS 0.22847f
C2694 comparator_slice_0.comparator_body_0.mref_m5_diff_0.tail.n15 AVSS 0.22967f
C2695 comparator_slice_0.comparator_body_0.m1_m2_diff_0.m1_m2_array_1/n1_2_7.S AVSS 0.23365f
C2696 comparator_slice_0.comparator_body_0.m1_m2_diff_0.m1_m2_array_2/n1_2_4.S AVSS 0.22917f
C2697 comparator_slice_0.comparator_body_0.m1_m2_diff_0.m1_m2_array_0/n1_2_3.S AVSS 0.23053f
C2698 comparator_slice_0.comparator_body_0.m1_m2_diff_0.m1_m2_array_1/n1_2_3.S AVSS 0.23053f
C2699 comparator_slice_0.comparator_body_0.m1_m2_diff_0.m1_m2_array_2/n1_2_3.S AVSS 0.23053f
C2700 comparator_slice_0.comparator_body_0.mref_m5_diff_0.tail.n16 AVSS 0.36456f
C2701 comparator_slice_0.comparator_body_0.mref_m5_diff_0.tail.n17 AVSS 0.57761f
C2702 comparator_slice_0.comparator_body_0.mref_m5_diff_0.tail.n18 AVSS 1.35465f
C2703 comparator_slice_0.comparator_body_0.mref_m5_diff_0.tail.n19 AVSS 0.35843f
C2704 comparator_slice_0.comparator_body_0.mref_m5_diff_0.tail.n20 AVSS 0.38286f
C2705 comparator_slice_0.comparator_body_0.mref_m5_diff_0.tail.n21 AVSS 0.3156f
C2706 comparator_slice_0.comparator_body_0.mref_m5_diff_0.tail.n22 AVSS 0.54434f
C2707 comparator_slice_0.comparator_body_0.mref_m5_diff_0.tail.n23 AVSS 0.61188f
C2708 comparator_slice_0.comparator_body_0.mref_m5_diff_0.tail.n24 AVSS 0.54437f
C2709 comparator_slice_0.comparator_body_0.mref_m5_diff_0.tail.n25 AVSS 0.54043f
C2710 comparator_slice_0.comparator_body_0.mref_m5_diff_0.tail.n26 AVSS 0.1986f
C2711 comparator_slice_0.comparator_body_0.mref_m5_diff_0.tail.n27 AVSS 0.70431f
C2712 comparator_slice_0.comparator_body_0.mref_m5_diff_0.tail.n28 AVSS 0.54437f
C2713 comparator_slice_0.comparator_body_0.mref_m5_diff_0.tail.n29 AVSS 0.1986f
C2714 comparator_slice_0.comparator_body_0.mref_m5_diff_0.tail.n30 AVSS 0.54043f
C2715 comparator_slice_0.comparator_body_0.mref_m5_diff_0.tail.n31 AVSS 0.70431f
C2716 comparator_slice_0.comparator_body_0.mref_m5_diff_0.tail.n32 AVSS 0.19943f
C2717 comparator_slice_0.comparator_body_0.mref_m5_diff_0.tail.n33 AVSS 0.54437f
C2718 comparator_slice_0.comparator_body_0.mref_m5_diff_0.tail.n34 AVSS 0.1986f
C2719 comparator_slice_0.comparator_body_0.mref_m5_diff_0.tail.n35 AVSS 0.70431f
C2720 comparator_slice_0.comparator_body_0.mref_m5_diff_0.tail.n36 AVSS 0.54437f
C2721 comparator_slice_0.comparator_body_0.mref_m5_diff_0.tail.n37 AVSS 0.54043f
C2722 comparator_slice_0.comparator_body_0.mref_m5_diff_0.tail.n38 AVSS 0.1986f
C2723 comparator_slice_0.comparator_body_0.mref_m5_diff_0.tail.n39 AVSS 0.70431f
C2724 comparator_slice_0.comparator_body_0.mref_m5_diff_0.mref_m5_array_2/n1_2$1_6.D AVSS 0.18393f
C2725 comparator_slice_0.comparator_body_0.mref_m5_diff_0.mref_m5_array_2/n1_2$1_15.D AVSS 0.23835f
C2726 comparator_slice_0.comparator_body_0.mref_m5_diff_0.mref_m5_array_2/n1_2$1_5.D AVSS 0.18392f
C2727 comparator_slice_0.comparator_body_0.mref_m5_diff_0.mref_m5_array_2/n1_2$1_12.D AVSS 0.18392f
C2728 comparator_slice_0.comparator_body_0.mref_m5_diff_0.mref_m5_array_3/n1_2$1_5.D AVSS 0.18392f
C2729 comparator_slice_0.comparator_body_0.mref_m5_diff_0.mref_m5_array_3/n1_2$1_15.D AVSS 0.23835f
C2730 comparator_slice_0.comparator_body_0.mref_m5_diff_0.mref_m5_array_3/n1_2$1_12.D AVSS 0.18392f
C2731 comparator_slice_0.comparator_body_0.mref_m5_diff_0.mref_m5_array_1/n1_2$1_5.D AVSS 0.18392f
C2732 comparator_slice_0.comparator_body_0.mref_m5_diff_0.mref_m5_array_1/n1_2$1_15.D AVSS 0.23835f
C2733 comparator_slice_0.comparator_body_0.mref_m5_diff_0.mref_m5_array_1/n1_2$1_12.D AVSS 0.18392f
C2734 comparator_slice_0.comparator_body_0.mref_m5_diff_0.mref_m5_array_0/n1_2$1_5.D AVSS 0.18392f
C2735 comparator_slice_0.comparator_body_0.mref_m5_diff_0.mref_m5_array_0/n1_2$1_15.D AVSS 0.23835f
C2736 comparator_slice_0.comparator_body_0.mref_m5_diff_0.mref_m5_array_0/n1_2$1_12.D AVSS 0.18392f
C2737 comparator_slice_0.comparator_body_0.mref_m5_diff_0.mref_m5_array_0/n1_2$1_6.D AVSS 0.18393f
C2738 comparator_slice_0.comparator_body_0.mref_m5_diff_0.mref_m5_array_1/n1_2$1_6.D AVSS 0.18393f
C2739 comparator_slice_0.comparator_body_0.mref_m5_diff_0.mref_m5_array_3/n1_2$1_6.D AVSS 0.18393f
C2740 comparator_slice_0.comparator_body_0.m1_m2_diff_0.m1_m2_array_3/n1_2_9.S AVSS 0.24644f
C2741 comparator_slice_0.comparator_body_0.m1_m2_diff_0.m1_m2_array_3/n1_2_1.S AVSS 0.21969f
C2742 comparator_slice_0.comparator_body_0.m1_m2_diff_0.m1_m2_array_3/n1_2_6.S AVSS 0.21969f
C2743 comparator_slice_0.comparator_body_0.m1_m2_diff_0.m1_m2_array_2/n1_2_1.S AVSS 0.21969f
C2744 comparator_slice_0.comparator_body_0.m1_m2_diff_0.m1_m2_array_2/n1_2_6.S AVSS 0.21969f
C2745 comparator_slice_0.comparator_body_0.m1_m2_diff_0.m1_m2_array_2/n1_2_9.S AVSS 0.21969f
C2746 comparator_slice_0.comparator_body_0.m1_m2_diff_0.m1_m2_array_1/n1_2_13.S AVSS 0.21969f
C2747 comparator_slice_0.comparator_body_0.m1_m2_diff_0.m1_m2_array_1/n1_2_5.S AVSS 0.21969f
C2748 comparator_slice_0.comparator_body_0.m1_m2_diff_0.m1_m2_array_1/n1_2_2.S AVSS 0.21969f
C2749 comparator_slice_0.comparator_body_0.m1_m2_diff_0.m1_m2_array_1/n1_2_8.S AVSS 0.21969f
C2750 comparator_slice_0.comparator_body_0.m1_m2_diff_0.m1_m2_array_0/n1_2_13.S AVSS 0.25663f
C2751 comparator_slice_0.comparator_body_0.m1_m2_diff_0.m1_m2_array_0/n1_2_5.S AVSS 0.21969f
C2752 comparator_slice_0.comparator_body_0.m1_m2_diff_0.m1_m2_array_0/n1_2_2.S AVSS 0.21969f
C2753 comparator_slice_0.comparator_body_0.m1_m2_diff_0.m1_m2_array_0/n1_2_8.S AVSS 0.25613f
C2754 comparator_slice_0.comparator_body_0.m1_m2_diff_0.m1_m2_array_2/n1_2_13.S AVSS 0.21969f
C2755 comparator_slice_0.comparator_body_0.m1_m2_diff_0.m1_m2_array_2/n1_2_5.S AVSS 0.21969f
C2756 comparator_slice_0.comparator_body_0.m1_m2_diff_0.m1_m2_array_2/n1_2_2.S AVSS 0.21969f
C2757 comparator_slice_0.comparator_body_0.m1_m2_diff_0.m1_m2_array_2/n1_2_8.S AVSS 0.25319f
C2758 comparator_slice_0.comparator_body_0.m1_m2_diff_0.m1_m2_array_0/n1_2_1.S AVSS 0.21969f
C2759 comparator_slice_0.comparator_body_0.m1_m2_diff_0.m1_m2_array_0/n1_2_6.S AVSS 0.21969f
C2760 comparator_slice_0.comparator_body_0.m1_m2_diff_0.m1_m2_array_0/n1_2_14.S AVSS 0.21969f
C2761 comparator_slice_0.comparator_body_0.m1_m2_diff_0.m1_m2_array_0/n1_2_9.S AVSS 0.21969f
C2762 comparator_slice_0.comparator_body_0.m1_m2_diff_0.m1_m2_array_1/n1_2_1.S AVSS 0.21969f
C2763 comparator_slice_0.comparator_body_0.m1_m2_diff_0.m1_m2_array_1/n1_2_6.S AVSS 0.21969f
C2764 comparator_slice_0.comparator_body_0.m1_m2_diff_0.m1_m2_array_1/n1_2_14.S AVSS 0.2278f
C2765 comparator_slice_0.comparator_body_0.m1_m2_diff_0.m1_m2_array_1/n1_2_9.S AVSS 0.21969f
C2766 comparator_slice_0.comparator_body_0.m1_m2_diff_0.m1_m2_array_3/n1_2_13.S AVSS 0.21969f
C2767 comparator_slice_0.comparator_body_0.m1_m2_diff_0.m1_m2_array_3/n1_2_5.S AVSS 0.21969f
C2768 comparator_slice_0.comparator_body_0.m1_m2_diff_0.m1_m2_array_3/n1_2_2.S AVSS 0.2383f
C2769 comparator_slice_0.comparator_body_0.mref_m5_diff_0.mref_m5_array_2/n1_2$1_11.D AVSS 0.23886f
C2770 comparator_slice_0.comparator_body_0.mref_m5_diff_0.mref_m5_array_2/n1_2$1_3.D AVSS 0.18431f
C2771 comparator_slice_0.comparator_body_0.mref_m5_diff_0.mref_m5_array_2/n1_2$1_8.D AVSS 0.1843f
C2772 comparator_slice_0.comparator_body_0.mref_m5_diff_0.mref_m5_array_2/n1_2$1_2.D AVSS 0.1843f
C2773 comparator_slice_0.comparator_body_0.mref_m5_diff_0.mref_m5_array_3/n1_2$1_3.D AVSS 0.18431f
C2774 comparator_slice_0.comparator_body_0.mref_m5_diff_0.mref_m5_array_3/n1_2$1_11.D AVSS 0.23886f
C2775 comparator_slice_0.comparator_body_0.mref_m5_diff_0.mref_m5_array_1/n1_2$1_11.D AVSS 0.23886f
C2776 comparator_slice_0.comparator_body_0.mref_m5_diff_0.mref_m5_array_0/n1_2$1_11.D AVSS 0.23886f
C2777 comparator_slice_0.comparator_body_0.mref_m5_diff_0.mref_m5_array_0/n1_2$1_2.D AVSS 0.1843f
C2778 comparator_slice_0.comparator_body_0.mref_m5_diff_0.mref_m5_array_0/n1_2$1_8.D AVSS 0.1843f
C2779 comparator_slice_0.comparator_body_0.mref_m5_diff_0.mref_m5_array_0/n1_2$1_3.D AVSS 0.18431f
C2780 comparator_slice_0.comparator_body_0.mref_m5_diff_0.mref_m5_array_1/n1_2$1_2.D AVSS 0.1843f
C2781 comparator_slice_0.comparator_body_0.mref_m5_diff_0.mref_m5_array_1/n1_2$1_8.D AVSS 0.1843f
C2782 comparator_slice_0.comparator_body_0.mref_m5_diff_0.mref_m5_array_1/n1_2$1_3.D AVSS 0.18431f
C2783 comparator_slice_0.comparator_body_0.mref_m5_diff_0.mref_m5_array_3/n1_2$1_2.D AVSS 0.1843f
C2784 comparator_slice_0.comparator_body_0.mref_m5_diff_0.mref_m5_array_3/n1_2$1_8.D AVSS 0.1843f
C2785 comparator_slice_0.comparator_body_0.mref_m5_diff_0.tail.t0 AVSS 0.13146f
C2786 comparator_slice_0.comparator_body_0.m1_m2_diff_0.m1_m2_array_3/n1_2_4.S AVSS 0.22926f
C2787 comparator_slice_0.comparator_body_0.m1_m2_diff_0.m1_m2_array_3/n1_2_11.S AVSS 0.23883f
C2788 comparator_slice_0.comparator_body_0.m1_m2_diff_0.m1_m2_array_3/n1_2_10.S AVSS 0.2715f
C2789 comparator_slice_0.comparator_body_0.m1_m2_diff_0.m1_m2_array_3/n1_2_12.S AVSS 0.21977f
C2790 comparator_slice_0.comparator_body_0.m1_m2_diff_0.m1_m2_array_2/n1_2_15.S AVSS 0.2621f
C2791 comparator_slice_0.comparator_body_0.m1_m2_diff_0.m1_m2_array_2/n1_2_11.S AVSS 0.21977f
C2792 comparator_slice_0.comparator_body_0.m1_m2_diff_0.m1_m2_array_2/n1_2_0.S AVSS 0.21977f
C2793 comparator_slice_0.comparator_body_0.m1_m2_diff_0.m1_m2_array_2/n1_2_10.S AVSS 0.21977f
C2794 comparator_slice_0.comparator_body_0.m1_m2_diff_0.m1_m2_array_0/n1_2_12.S AVSS 0.21977f
C2795 comparator_slice_0.comparator_body_0.m1_m2_diff_0.m1_m2_array_0/n1_2_4.S AVSS 0.22917f
C2796 comparator_slice_0.comparator_body_0.m1_m2_diff_0.m1_m2_array_1/n1_2_12.S AVSS 0.21977f
C2797 comparator_slice_0.comparator_body_0.m1_m2_diff_0.m1_m2_array_1/n1_2_4.S AVSS 0.22992f
C2798 comparator_slice_0.comparator_body_0.m1_m2_diff_0.m1_m2_array_2/n1_2_12.S AVSS 0.21977f
C2799 comparator_slice_0.comparator_body_0.m1_m2_diff_0.m1_m2_array_0/n1_2_15.S AVSS 0.26203f
C2800 comparator_slice_0.comparator_body_0.m1_m2_diff_0.m1_m2_array_0/n1_2_11.S AVSS 0.24467f
C2801 comparator_slice_0.comparator_body_0.m1_m2_diff_0.m1_m2_array_0/n1_2_0.S AVSS 0.21977f
C2802 comparator_slice_0.comparator_body_0.m1_m2_diff_0.m1_m2_array_0/n1_2_10.S AVSS 0.24592f
C2803 comparator_slice_0.comparator_body_0.m1_m2_diff_0.m1_m2_array_1/n1_2_15.S AVSS 0.21977f
C2804 comparator_slice_0.comparator_body_0.m1_m2_diff_0.m1_m2_array_1/n1_2_11.S AVSS 0.21977f
C2805 comparator_slice_0.comparator_body_0.m1_m2_diff_0.m1_m2_array_1/n1_2_0.S AVSS 0.21977f
C2806 comparator_slice_0.comparator_body_0.m1_m2_diff_0.m1_m2_array_1/n1_2_10.S AVSS 0.24592f
C2807 comparator_slice_0.comparator_body_0.m1_m2_diff_0.m1_m2_array_3/n1_2_3.S AVSS 0.23053f
C2808 comparator_slice_0.comparator_body_0.m1_m2_diff_0.m1_m2_array_3/n1_2_7.S AVSS 0.23183f
C2809 comparator_slice_0.comparator_body_0.mref_m5_diff_0.tail.t70 AVSS 0.13148f
C2810 comparator_slice_0.comparator_body_0.mref_m5_diff_0.tail.t15 AVSS 0.36724f
C2811 comparator_slice_0.comparator_body_0.mref_m5_diff_0.tail.t27 AVSS 0.13148f
C2812 comparator_slice_0.comparator_body_0.mref_m5_diff_0.tail.t74 AVSS 0.4995f
C2813 comparator_slice_0.comparator_body_0.mref_m5_diff_0.tail.t72 AVSS 0.13148f
C2814 comparator_slice_0.comparator_body_0.mref_m5_diff_0.tail.t26 AVSS 0.36724f
C2815 comparator_slice_0.comparator_body_0.mref_m5_diff_0.tail.t11 AVSS 0.13148f
C2816 comparator_slice_0.comparator_body_0.mref_m5_diff_0.tail.t76 AVSS 0.47649f
C2817 comparator_slice_0.comparator_body_0.mref_m5_diff_0.tail.t65 AVSS 0.47705f
C2818 comparator_slice_0.comparator_body_0.mref_m5_diff_0.tail.t28 AVSS 0.13092f
C2819 comparator_slice_0.comparator_body_0.mref_m5_diff_0.tail.t4 AVSS 0.13148f
C2820 comparator_slice_0.comparator_body_0.mref_m5_diff_0.tail.n40 AVSS 0.37908f
C2821 comparator_slice_0.comparator_body_0.mref_m5_diff_0.tail.n41 AVSS 0.33593f
C2822 comparator_slice_0.comparator_body_0.mref_m5_diff_0.tail.t92 AVSS 0.13148f
C2823 comparator_slice_0.comparator_body_0.mref_m5_diff_0.tail.n42 AVSS 0.26181f
C2824 comparator_slice_0.comparator_body_0.mref_m5_diff_0.tail.n43 AVSS 0.33593f
C2825 comparator_slice_0.comparator_body_0.mref_m5_diff_0.tail.t13 AVSS 0.13148f
C2826 comparator_slice_0.comparator_body_0.mref_m5_diff_0.tail.n44 AVSS 0.38474f
C2827 comparator_slice_0.comparator_body_0.mref_m5_diff_0.tail.t68 AVSS 0.49958f
C2828 comparator_slice_0.comparator_body_0.mref_m5_diff_0.tail.t67 AVSS 0.4995f
C2829 comparator_slice_0.comparator_body_0.mref_m5_diff_0.tail.t22 AVSS 0.13148f
C2830 comparator_slice_0.comparator_body_0.mref_m5_diff_0.tail.t2 AVSS 0.13092f
C2831 comparator_slice_0.comparator_body_0.mref_m5_diff_0.tail.t80 AVSS 0.47705f
C2832 comparator_slice_0.comparator_body_0.mref_m5_diff_0.tail.t81 AVSS 0.47649f
C2833 comparator_slice_0.comparator_body_0.mref_m5_diff_0.tail.t5 AVSS 0.13148f
C2834 comparator_slice_0.comparator_body_0.mref_m5_diff_0.tail.t10 AVSS 0.36724f
C2835 comparator_slice_0.comparator_body_0.mref_m5_diff_0.tail.t7 AVSS 0.13148f
C2836 comparator_slice_0.comparator_body_0.mref_m5_diff_0.tail.t93 AVSS 0.48528f
C2837 comparator_slice_0.comparator_body_0.mref_m5_diff_0.tail.n45 AVSS 0.42647f
C2838 comparator_slice_0.comparator_body_0.mref_m5_diff_0.tail.t31 AVSS 0.13148f
C2839 comparator_slice_0.comparator_body_0.mref_m5_diff_0.tail.t82 AVSS 0.13148f
C2840 comparator_slice_0.comparator_body_0.mref_m5_diff_0.tail.t78 AVSS 0.13148f
C2841 comparator_slice_0.comparator_body_0.mref_m5_diff_0.tail.t87 AVSS 0.4995f
C2842 comparator_slice_0.comparator_body_0.mref_m5_diff_0.tail.t24 AVSS 0.13148f
C2843 comparator_slice_0.comparator_body_0.mref_m5_diff_0.tail.t6 AVSS 0.36724f
C2844 comparator_slice_0.comparator_body_0.mref_m5_diff_0.tail.t75 AVSS 0.47705f
C2845 comparator_slice_0.comparator_body_0.mref_m5_diff_0.tail.t85 AVSS 0.47649f
C2846 comparator_slice_0.comparator_body_0.mref_m5_diff_0.tail.t19 AVSS 0.13148f
C2847 comparator_slice_0.comparator_body_0.mref_m5_diff_0.tail.t12 AVSS 0.36724f
C2848 comparator_slice_0.comparator_body_0.mref_m5_diff_0.tail.t20 AVSS 0.13148f
C2849 comparator_slice_0.comparator_body_0.mref_m5_diff_0.tail.t90 AVSS 0.13148f
C2850 comparator_slice_0.comparator_body_0.mref_m5_diff_0.tail.n46 AVSS 0.30055f
C2851 comparator_slice_0.comparator_body_0.mref_m5_diff_0.tail.n47 AVSS 0.33593f
C2852 comparator_slice_0.comparator_body_0.mref_m5_diff_0.tail.t3 AVSS 0.13148f
C2853 comparator_slice_0.comparator_body_0.mref_m5_diff_0.tail.n48 AVSS 0.26086f
C2854 comparator_slice_0.comparator_body_0.mref_m5_diff_0.tail.n49 AVSS 0.33593f
C2855 comparator_slice_0.comparator_body_0.mref_m5_diff_0.tail.t86 AVSS 0.13148f
C2856 comparator_slice_0.comparator_body_0.mref_m5_diff_0.tail.t47 AVSS 0.68905f
C2857 comparator_slice_0.comparator_body_0.mref_m5_diff_0.tail.n50 AVSS 0.40495f
C2858 comparator_slice_0.comparator_body_0.mref_m5_diff_0.tail.t91 AVSS 0.13092f
C2859 comparator_slice_0.comparator_body_0.mref_m5_diff_0.tail.n51 AVSS 0.32893f
C2860 comparator_slice_0.comparator_body_0.mref_m5_diff_0.tail.t37 AVSS 0.13107f
C2861 comparator_slice_0.comparator_body_0.mref_m5_diff_0.tail.n52 AVSS 0.31466f
C2862 comparator_slice_0.comparator_body_0.mref_m5_diff_0.tail.n53 AVSS 0.50295f
C2863 comparator_slice_0.comparator_body_0.mref_m5_diff_0.tail.t48 AVSS 0.13064f
C2864 comparator_slice_0.comparator_body_0.mref_m5_diff_0.tail.n54 AVSS 0.19941f
C2865 comparator_slice_0.comparator_body_0.mref_m5_diff_0.tail.t35 AVSS 0.13064f
C2866 comparator_slice_0.comparator_body_0.mref_m5_diff_0.tail.n55 AVSS 0.73585f
C2867 comparator_slice_0.comparator_body_0.mref_m5_diff_0.tail.n56 AVSS 0.76957f
C2868 comparator_slice_0.comparator_body_0.mref_m5_diff_0.tail.n57 AVSS 0.51902f
C2869 comparator_slice_0.comparator_body_0.mref_m5_diff_0.tail.n58 AVSS 0.62185f
C2870 comparator_slice_0.comparator_body_0.mref_m5_diff_0.tail.t55 AVSS 0.13064f
C2871 comparator_slice_0.comparator_body_0.mref_m5_diff_0.tail.n59 AVSS 0.19941f
C2872 comparator_slice_0.comparator_body_0.mref_m5_diff_0.tail.t32 AVSS 0.13107f
C2873 comparator_slice_0.comparator_body_0.mref_m5_diff_0.tail.t59 AVSS 0.68905f
C2874 comparator_slice_0.comparator_body_0.mref_m5_diff_0.tail.n60 AVSS 0.19943f
C2875 comparator_slice_0.comparator_body_0.mref_m5_diff_0.tail.n61 AVSS 0.31101f
C2876 comparator_slice_0.comparator_body_0.mref_m5_diff_0.tail.t38 AVSS 0.13107f
C2877 comparator_slice_0.comparator_body_0.mref_m5_diff_0.tail.n62 AVSS 0.68034f
C2878 comparator_slice_0.comparator_body_0.mref_m5_diff_0.tail.t62 AVSS 0.13107f
C2879 comparator_slice_0.comparator_body_0.mref_m5_diff_0.tail.n63 AVSS 0.19862f
C2880 comparator_slice_0.comparator_body_0.mref_m5_diff_0.tail.n64 AVSS 0.49972f
C2881 comparator_slice_0.comparator_body_0.mref_m5_diff_0.tail.t46 AVSS 0.13064f
C2882 comparator_slice_0.comparator_body_0.mref_m5_diff_0.tail.t39 AVSS 0.13064f
C2883 comparator_slice_0.comparator_body_0.mref_m5_diff_0.tail.t54 AVSS 0.68948f
C2884 comparator_slice_0.comparator_body_0.mref_m5_diff_0.tail.n65 AVSS 0.57763f
C2885 comparator_slice_0.comparator_body_0.mref_m5_diff_0.tail.n66 AVSS 0.84443f
C2886 comparator_slice_0.comparator_body_0.mref_m5_diff_0.tail.t49 AVSS 0.13064f
C2887 comparator_slice_0.comparator_body_0.mref_m5_diff_0.tail.n67 AVSS 0.19941f
C2888 comparator_slice_0.comparator_body_0.mref_m5_diff_0.tail.n68 AVSS 0.31466f
C2889 comparator_slice_0.comparator_body_0.mref_m5_diff_0.tail.t44 AVSS 0.13064f
C2890 comparator_slice_0.comparator_body_0.mref_m5_diff_0.tail.t56 AVSS 0.13107f
C2891 comparator_slice_0.comparator_body_0.mref_m5_diff_0.tail.n69 AVSS 0.50295f
C2892 comparator_slice_0.comparator_body_0.mref_m5_diff_0.tail.t58 AVSS 0.68967f
C2893 comparator_slice_0.comparator_body_0.mref_m5_diff_0.tail.n70 AVSS 0.19941f
C2894 comparator_slice_0.comparator_body_0.mref_m5_diff_0.tail.t52 AVSS 0.68905f
C2895 comparator_slice_0.comparator_body_0.mref_m5_diff_0.tail.t41 AVSS 0.13107f
C2896 comparator_slice_0.comparator_body_0.mref_m5_diff_0.tail.n71 AVSS 0.68034f
C2897 comparator_slice_0.comparator_body_0.mref_m5_diff_0.tail.t63 AVSS 0.13107f
C2898 comparator_slice_0.comparator_body_0.mref_m5_diff_0.tail.n72 AVSS 0.55798f
C2899 comparator_slice_0.comparator_body_0.mref_m5_diff_0.tail.n73 AVSS 0.75574f
C2900 comparator_slice_0.comparator_body_0.mref_m5_diff_0.tail.t40 AVSS 0.13064f
C2901 comparator_slice_0.comparator_body_0.m1_m2_diff_0.tail AVSS 0.54538f
C2902 comparator_slice_0.comparator_body_0.mref_m5_diff_0.tail.t1 AVSS 0.37289f
C2903 comparator_slice_0.comparator_body_0.mref_m5_diff_0.tail.n74 AVSS 0.40368f
C2904 comparator_slice_0.comparator_body_0.mref_m5_diff_0.tail.n75 AVSS 0.52029f
C2905 comparator_slice_0.comparator_body_0.mref_m5_diff_0.tail.n76 AVSS 0.31466f
C2906 comparator_slice_0.comparator_body_0.mref_m5_diff_0.tail.t50 AVSS 0.13107f
C2907 comparator_slice_0.comparator_body_0.mref_m5_diff_0.tail.t84 AVSS 0.13148f
C2908 comparator_slice_0.comparator_body_0.mref_m5_diff_0.tail.t17 AVSS 0.3678f
C2909 comparator_slice_0.comparator_body_0.mref_m5_diff_0.tail.t88 AVSS 0.13092f
C2910 comparator_slice_0.comparator_body_0.mref_m5_diff_0.tail.t30 AVSS 0.3678f
C2911 comparator_slice_0.comparator_body_0.mref_m5_diff_0.tail.t71 AVSS 0.47649f
C2912 comparator_slice_0.comparator_body_0.mref_m5_diff_0.tail.t94 AVSS 0.13148f
C2913 comparator_slice_0.comparator_body_0.mref_m5_diff_0.tail.t79 AVSS 0.13148f
C2914 comparator_slice_0.comparator_body_0.mref_m5_diff_0.tail.t8 AVSS 0.13148f
C2915 comparator_slice_0.comparator_body_0.mref_m5_diff_0.tail.t16 AVSS 0.36724f
C2916 comparator_slice_0.comparator_body_0.mref_m5_diff_0.tail.t95 AVSS 0.13092f
C2917 comparator_slice_0.comparator_body_0.mref_m5_diff_0.tail.t21 AVSS 0.37289f
C2918 comparator_slice_0.comparator_body_0.mref_m5_diff_0.tail.t64 AVSS 0.13092f
C2919 comparator_slice_0.comparator_body_0.mref_m5_diff_0.tail.n77 AVSS 0.41575f
C2920 comparator_slice_0.comparator_body_0.mref_m5_diff_0.tail.n78 AVSS 0.61876f
C2921 comparator_slice_0.comparator_body_0.mref_m5_diff_0.tail.t51 AVSS 0.13107f
C2922 comparator_slice_0.comparator_body_0.mref_m5_diff_0.tail.n79 AVSS 0.19862f
C2923 comparator_slice_0.comparator_body_0.mref_m5_diff_0.tail.t60 AVSS 0.13064f
C2924 comparator_slice_0.comparator_body_0.mref_m5_diff_0.tail.n80 AVSS 0.19943f
C2925 comparator_slice_0.comparator_body_0.mref_m5_diff_0.tail.n81 AVSS 0.31101f
C2926 comparator_slice_0.comparator_body_0.mref_m5_diff_0.tail.n82 AVSS 0.61938f
C2927 comparator_slice_0.comparator_body_0.mref_m5_diff_0.tail.t57 AVSS 0.68905f
C2928 comparator_slice_0.comparator_body_0.mref_m5_diff_0.tail.n83 AVSS 0.61938f
C2929 comparator_slice_0.comparator_body_0.mref_m5_diff_0.tail.t45 AVSS 0.13107f
C2930 comparator_slice_0.comparator_body_0.mref_m5_diff_0.tail.t42 AVSS 0.13064f
C2931 comparator_slice_0.comparator_body_0.mref_m5_diff_0.tail.n84 AVSS 0.19943f
C2932 comparator_slice_0.comparator_body_0.mref_m5_diff_0.tail.n85 AVSS 0.31101f
C2933 comparator_slice_0.comparator_body_0.mref_m5_diff_0.tail.t34 AVSS 0.13107f
C2934 comparator_slice_0.comparator_body_0.mref_m5_diff_0.tail.n86 AVSS 0.68034f
C2935 comparator_slice_0.comparator_body_0.mref_m5_diff_0.tail.t53 AVSS 0.13107f
C2936 comparator_slice_0.comparator_body_0.mref_m5_diff_0.tail.n87 AVSS 0.19862f
C2937 comparator_slice_0.comparator_body_0.mref_m5_diff_0.tail.n88 AVSS 0.49972f
C2938 comparator_slice_0.comparator_body_0.mref_m5_diff_0.tail.n89 AVSS 0.57763f
C2939 comparator_slice_0.comparator_body_0.mref_m5_diff_0.tail.n90 AVSS 0.84443f
C2940 comparator_slice_0.comparator_body_0.mref_m5_diff_0.tail.n91 AVSS 0.57424f
C2941 comparator_slice_0.comparator_body_0.mref_m5_diff_0.tail.n92 AVSS 0.43278f
C2942 comparator_slice_0.comparator_body_0.mref_m5_diff_0.tail.n93 AVSS 0.42434f
C2943 comparator_slice_0.comparator_body_0.mref_m5_diff_0.tail.t73 AVSS 0.47649f
C2944 comparator_slice_0.comparator_body_0.mref_m5_diff_0.tail.t9 AVSS 0.37289f
C2945 comparator_slice_0.comparator_body_0.mref_m5_diff_0.tail.t66 AVSS 0.47649f
C2946 comparator_slice_0.comparator_body_0.mref_m5_diff_0.tail.t18 AVSS 0.13092f
C2947 comparator_slice_0.comparator_body_0.mref_m5_diff_0.tail.n94 AVSS 0.40729f
C2948 comparator_slice_0.comparator_body_0.mref_m5_diff_0.tail.n95 AVSS 0.51667f
C2949 comparator_slice_0.comparator_body_0.mref_m5_diff_0.tail.n96 AVSS 0.50295f
C2950 comparator_slice_0.comparator_body_0.mref_m5_diff_0.tail.n97 AVSS 0.57424f
C2951 comparator_slice_0.comparator_body_0.mref_m5_diff_0.tail.n98 AVSS 0.44049f
C2952 comparator_slice_0.comparator_body_0.mref_m5_diff_0.tail.t33 AVSS 0.13064f
C2953 comparator_slice_0.comparator_body_0.mref_m5_diff_0.tail.t89 AVSS 0.47649f
C2954 comparator_slice_0.comparator_body_0.mref_m5_diff_0.tail.t61 AVSS 0.13107f
C2955 comparator_slice_0.comparator_body_0.mref_m5_diff_0.tail.n99 AVSS 0.41662f
C2956 comparator_slice_0.comparator_body_0.mref_m5_diff_0.tail.t14 AVSS 0.13092f
C2957 comparator_slice_0.comparator_body_0.mref_m5_diff_0.tail.t77 AVSS 0.47649f
C2958 comparator_slice_0.comparator_body_0.mref_m5_diff_0.tail.t23 AVSS 0.37289f
C2959 comparator_slice_0.comparator_body_0.mref_m5_diff_0.tail.n100 AVSS 0.40879f
C2960 comparator_slice_0.comparator_body_0.mref_m5_diff_0.tail.n101 AVSS 0.51518f
C2961 comparator_slice_0.comparator_body_0.mref_m5_diff_0.tail.n102 AVSS 0.31466f
C2962 comparator_slice_0.comparator_body_0.mref_m5_diff_0.tail.t43 AVSS 0.13107f
C2963 comparator_slice_0.comparator_body_0.mref_m5_diff_0.tail.n103 AVSS 0.54043f
C2964 comparator_slice_0.comparator_body_0.mref_m5_diff_0.tail.t36 AVSS 0.6901f
C2965 comparator_slice_0.comparator_body_0.mref_m5_diff_0.tail.n104 AVSS 0.19862f
C2966 comparator_slice_0.comparator_body_0.mref_m5_diff_0.tail.n105 AVSS 0.49972f
C2967 comparator_slice_0.comparator_body_0.mref_m5_diff_0.tail.n106 AVSS 0.68034f
C2968 comparator_slice_0.comparator_body_0.mref_m5_diff_0.tail.n107 AVSS 0.31101f
C2969 comparator_slice_0.comparator_body_0.mref_m5_diff_0.tail.n108 AVSS 0.61938f
C2970 comparator_slice_0.comparator_body_0.mref_m5_diff_0.tail.n109 AVSS 0.57763f
C2971 comparator_slice_0.comparator_body_0.mref_m5_diff_0.tail.n110 AVSS 0.84443f
C2972 comparator_slice_0.comparator_body_0.mref_m5_diff_0.tail.n111 AVSS 0.57424f
C2973 comparator_slice_0.comparator_body_0.mref_m5_diff_0.tail.n112 AVSS 0.43896f
C2974 comparator_slice_0.comparator_body_0.mref_m5_diff_0.tail.n113 AVSS 0.41815f
C2975 comparator_slice_0.comparator_body_0.mref_m5_diff_0.tail.t25 AVSS 0.37289f
C2976 comparator_slice_0.comparator_body_0.mref_m5_diff_0.tail.t69 AVSS 0.47649f
C2977 comparator_slice_0.comparator_body_0.mref_m5_diff_0.tail.n114 AVSS 0.3232f
C2978 comparator_slice_0.comparator_body_0.mref_m5_diff_0.tail.t29 AVSS 0.37289f
C2979 comparator_slice_0.comparator_body_0.mref_m5_diff_0.tail.n115 AVSS 0.3602f
C2980 comparator_slice_0.comparator_body_0.mref_m5_diff_0.tail.t83 AVSS 0.47705f
C2981 comparator_slice_0.comparator_body_0.outx.n0 AVSS 6.44113f
C2982 comparator_slice_0.comparator_body_0.outx.n1 AVSS 0.46042f
C2983 comparator_slice_0.comparator_body_0.outx.n2 AVSS 1.50813f
C2984 comparator_slice_0.comparator_body_0.outx.n3 AVSS 3.30084f
C2985 comparator_slice_0.comparator_body_0.outx.n4 AVSS 11.116f
C2986 comparator_slice_0.comparator_body_0.outx.n5 AVSS 0.47958f
C2987 comparator_slice_0.comparator_body_0.outx.n6 AVSS 7.02767f
C2988 comparator_slice_0.comparator_body_0.outx.n7 AVSS 0.52563f
C2989 comparator_slice_0.comparator_body_0.outx.n8 AVSS 1.19491f
C2990 comparator_slice_0.comparator_body_0.outx.n9 AVSS 3.38297f
C2991 comparator_slice_0.comparator_body_0.outx.n10 AVSS 1.11727f
C2992 comparator_slice_0.comparator_body_0.outx.n11 AVSS 2.42723f
C2993 comparator_slice_0.comparator_body_0.outx.n12 AVSS 6.7498f
C2994 comparator_slice_0.comparator_body_0.outx.n13 AVSS 0.38537f
C2995 comparator_slice_0.comparator_body_0.outx.n15 AVSS 3.36734f
C2996 comparator_slice_0.comparator_body_0.outx.n16 AVSS 1.63629f
C2997 comparator_slice_0.comparator_body_0.outx.n17 AVSS 3.36734f
C2998 comparator_slice_0.comparator_body_0.outx.n19 AVSS 0.98548f
C2999 comparator_slice_0.comparator_body_0.outx.n20 AVSS 2.14436f
C3000 comparator_slice_0.comparator_body_0.outx.n21 AVSS 2.60309f
C3001 comparator_slice_0.comparator_body_0.outx.n23 AVSS 0.9939f
C3002 comparator_slice_0.comparator_body_0.outx.n24 AVSS 2.64869f
C3003 comparator_slice_0.comparator_body_0.outx.n27 AVSS 0.98367f
C3004 comparator_slice_0.comparator_body_0.outx.n28 AVSS 1.85165f
C3005 comparator_slice_0.comparator_body_0.outx.n30 AVSS 1.5589f
C3006 comparator_slice_0.comparator_body_0.outx.n31 AVSS 0.9913f
C3007 comparator_slice_0.comparator_body_0.outx.n32 AVSS 1.23793f
C3008 comparator_slice_0.comparator_body_0.outx.n33 AVSS 1.23793f
C3009 comparator_slice_0.comparator_body_0.outx.n34 AVSS 0.73591f
C3010 comparator_slice_0.comparator_body_0.outx.n35 AVSS 1.9779f
C3011 comparator_slice_0.comparator_body_0.outx.n36 AVSS 1.07836f
C3012 comparator_slice_0.comparator_body_0.outx.n37 AVSS 1.07836f
C3013 comparator_slice_0.comparator_body_0.outx.n38 AVSS 1.77296f
C3014 comparator_slice_0.comparator_body_0.outx.n39 AVSS 1.68207f
C3015 comparator_slice_0.comparator_body_0.outx.n40 AVSS 1.68207f
C3016 comparator_slice_0.comparator_body_0.outx.n41 AVSS 1.78804f
C3017 comparator_slice_0.comparator_body_0.outx.n42 AVSS 0.80456f
C3018 comparator_slice_0.comparator_body_0.outx.n43 AVSS 9.25325f
C3019 comparator_slice_0.comparator_body_0.outx.n44 AVSS 0.73591f
C3020 comparator_slice_0.comparator_body_0.outx.n45 AVSS 1.25465f
C3021 comparator_slice_0.comparator_body_0.outx.n46 AVSS 1.06607f
C3022 comparator_slice_0.comparator_body_0.outx.n47 AVSS 1.15391f
C3023 comparator_slice_0.comparator_body_0.outx.n48 AVSS 1.24678f
C3024 comparator_slice_0.comparator_body_0.outx.n49 AVSS 0.97407f
C3025 comparator_slice_0.comparator_body_0.outx.n50 AVSS 1.9422f
C3026 comparator_slice_0.comparator_body_0.outx.n51 AVSS 4.1618f
C3027 comparator_slice_0.comparator_body_0.outx.t12 AVSS 1.68385f
C3028 comparator_slice_0.comparator_body_0.outx.t7 AVSS 0.1721f
C3029 comparator_slice_0.comparator_body_0.outx.t2 AVSS 1.68385f
C3030 comparator_slice_0.comparator_body_0.outx.t9 AVSS 1.68385f
C3031 comparator_slice_0.comparator_body_0.outx.t54 AVSS 0.1721f
C3032 comparator_slice_0.comparator_body_0.outx.t63 AVSS 0.17138f
C3033 comparator_slice_0.comparator_body_0.outx.t6 AVSS 0.1721f
C3034 comparator_slice_0.comparator_body_0.outx.t31 AVSS 0.1716f
C3035 comparator_slice_0.comparator_body_0.outx.t49 AVSS 0.52484f
C3036 comparator_slice_0.comparator_body_0.outx.n52 AVSS 1.36756f
C3037 comparator_slice_0.comparator_body_0.outx.t33 AVSS 0.1716f
C3038 comparator_slice_0.comparator_body_0.outx.t10 AVSS 1.68458f
C3039 comparator_slice_0.comparator_body_0.outx.t8 AVSS 0.17138f
C3040 comparator_slice_0.comparator_body_0.outx.t58 AVSS 0.17138f
C3041 comparator_slice_0.comparator_body_0.outx.t60 AVSS 0.1721f
C3042 comparator_slice_0.comparator_body_0.outx.t61 AVSS 0.1721f
C3043 comparator_slice_0.comparator_body_0.outx.n53 AVSS 1.67548f
C3044 comparator_slice_0.comparator_body_0.outx.t16 AVSS 0.1721f
C3045 comparator_slice_0.comparator_body_0.outx.t45 AVSS 0.54018f
C3046 comparator_slice_0.comparator_body_0.outx.t51 AVSS 0.52484f
C3047 comparator_slice_0.comparator_body_0.outx.n54 AVSS 1.36762f
C3048 comparator_slice_0.comparator_body_0.outx.t28 AVSS 0.1716f
C3049 comparator_slice_0.comparator_body_0.outx.t52 AVSS 0.51717f
C3050 comparator_slice_0.comparator_body_0.outx.t41 AVSS 0.51661f
C3051 comparator_slice_0.comparator_body_0.outx.n55 AVSS 1.37938f
C3052 comparator_slice_0.comparator_body_0.outx.t21 AVSS 0.51717f
C3053 comparator_slice_0.comparator_body_0.outx.t27 AVSS 0.51661f
C3054 comparator_slice_0.comparator_body_0.outx.t36 AVSS 0.53914f
C3055 comparator_slice_0.comparator_body_0.outx.t13 AVSS 0.1721f
C3056 comparator_slice_0.comparator_body_0.outx.t56 AVSS 0.17138f
C3057 comparator_slice_0.comparator_body_0.outx.t14 AVSS 0.17138f
C3058 comparator_slice_0.comparator_body_0.outx.t5 AVSS 0.1721f
C3059 comparator_slice_0.comparator_body_0.outx.t55 AVSS 0.17138f
C3060 comparator_slice_0.comparator_body_0.outx.t20 AVSS 0.17138f
C3061 comparator_slice_0.comparator_body_0.outx.t1 AVSS 0.1721f
C3062 comparator_slice_0.comparator_body_0.outx.t59 AVSS 0.1721f
C3063 comparator_slice_0.comparator_body_0.outx.t25 AVSS 0.17104f
C3064 comparator_slice_0.comparator_body_0.outx.t30 AVSS 0.1716f
C3065 comparator_slice_0.comparator_body_0.outx.t29 AVSS 0.51661f
C3066 comparator_slice_0.comparator_body_0.outx.n56 AVSS 1.37938f
C3067 comparator_slice_0.comparator_body_0.outx.t23 AVSS 0.1716f
C3068 comparator_slice_0.comparator_body_0.outx.t22 AVSS 0.17104f
C3069 comparator_slice_0.comparator_body_0.outx.t39 AVSS 0.53914f
C3070 comparator_slice_0.comparator_body_0.outx.t24 AVSS 0.1716f
C3071 comparator_slice_0.comparator_body_0.outx.t50 AVSS 0.17104f
C3072 comparator_slice_0.comparator_body_0.outx.n57 AVSS 1.36756f
C3073 comparator_slice_0.comparator_body_0.outx.t38 AVSS 0.1716f
C3074 comparator_slice_0.comparator_body_0.outx.t46 AVSS 0.1716f
C3075 comparator_slice_0.comparator_body_0.outx.t37 AVSS 0.17104f
C3076 comparator_slice_0.comparator_body_0.outx.n58 AVSS 1.37938f
C3077 comparator_slice_0.comparator_body_0.outx.t34 AVSS 0.1716f
C3078 comparator_slice_0.comparator_body_0.outx.t35 AVSS 0.51661f
C3079 comparator_slice_0.comparator_body_0.outx.t3 AVSS 1.68385f
C3080 comparator_slice_0.comparator_body_0.outx.t44 AVSS 0.1716f
C3081 comparator_slice_0.comparator_body_0.outx.t47 AVSS 0.52484f
C3082 comparator_slice_0.comparator_body_0.outx.n59 AVSS 1.36756f
C3083 comparator_slice_0.comparator_body_0.outx.t42 AVSS 0.1716f
C3084 comparator_slice_0.comparator_body_0.outx.t43 AVSS 0.53914f
C3085 comparator_slice_0.comparator_body_0.outx.t48 AVSS 0.51717f
C3086 comparator_slice_0.comparator_body_0.outx.t32 AVSS 0.17104f
C3087 comparator_slice_0.comparator_body_0.outx.n60 AVSS 1.37938f
C3088 comparator_slice_0.comparator_body_0.outx.t26 AVSS 0.1716f
C3089 comparator_slice_0.comparator_body_0.outx.t40 AVSS 0.17104f
C3090 comparator_slice_0.comparator_body_0.outx.t18 AVSS 0.1721f
C3091 comparator_slice_0.comparator_body_0.outx.t62 AVSS 1.68385f
C3092 comparator_slice_0.comparator_body_0.outx.t11 AVSS 0.17138f
C3093 comparator_slice_0.comparator_body_0.outx.t19 AVSS 0.17138f
C3094 comparator_slice_0.comparator_body_0.outx.t15 AVSS 0.1721f
C3095 comparator_slice_0.comparator_body_0.outx.n61 AVSS 1.28108f
C3096 comparator_slice_0.comparator_body_0.outx.t57 AVSS 0.1721f
C3097 comparator_slice_0.comparator_body_0.outx.n62 AVSS 1.21861f
C3098 comparator_slice_0.comparator_body_0.outx.t53 AVSS 0.17138f
C3099 comparator_slice_0.comparator_body_0.outx.t4 AVSS 1.68458f
C3100 comparator_slice_0.comparator_body_0.outx.t17 AVSS 0.1721f
C3101 comparator_slice_0.comparator_body_0.outx.t0 AVSS 0.17137f
C3102 AVSS.t174 AVSS 0.57276f
C3103 AVSS.t172 AVSS 0.57276f
C3104 AVSS.t181 AVSS 0.57276f
C3105 AVSS.t168 AVSS 0.57276f
C3106 AVSS.t185 AVSS 0.57276f
C3107 AVSS.t194 AVSS 0.57341f
C3108 AVSS.t193 AVSS 0.57276f
C3109 AVSS.t200 AVSS 0.57276f
C3110 AVSS.t192 AVSS 0.57276f
C3111 AVSS.t195 AVSS 0.57276f
C3112 AVSS.t183 AVSS 1.14617f
C3113 AVSS.t170 AVSS 0.57276f
C3114 AVSS.t202 AVSS 1.14617f
C3115 AVSS.t208 AVSS 0.57276f
C3116 AVSS.t211 AVSS 0.57276f
C3117 AVSS.t217 AVSS 0.57276f
C3118 AVSS.t204 AVSS 0.57341f
C3119 AVSS.t205 AVSS 0.57276f
C3120 AVSS.t223 AVSS 0.57276f
C3121 AVSS.t221 AVSS 0.57341f
C3122 AVSS.t224 AVSS 0.57276f
C3123 AVSS.t227 AVSS 0.57276f
C3124 AVSS.t92 AVSS 0.55841f
C3125 AVSS.t108 AVSS 0.55841f
C3126 AVSS.t99 AVSS 0.55841f
C3127 AVSS.t94 AVSS 0.55903f
C3128 AVSS.t98 AVSS 0.55841f
C3129 AVSS.t83 AVSS 0.55903f
C3130 AVSS.t88 AVSS 0.55841f
C3131 AVSS.t79 AVSS 0.55841f
C3132 AVSS.t81 AVSS 0.55841f
C3133 AVSS.t71 AVSS 0.55841f
C3134 AVSS.t66 AVSS 0.55903f
C3135 AVSS.t56 AVSS 1.67522f
C3136 AVSS.t63 AVSS 0.55841f
C3137 AVSS.t132 AVSS 0.69083f
C3138 AVSS.t73 AVSS 1.11681f
C3139 AVSS.t116 AVSS 0.55841f
C3140 AVSS.t121 AVSS 0.55841f
C3141 AVSS.t147 AVSS 0.39809f
C3142 AVSS.t15 AVSS 7.63531f
C3143 AVSS.t36 AVSS 0.34652f
C3144 AVSS.t148 AVSS 0.39809f
C3145 AVSS.t161 AVSS 0.39809f
C3146 AVSS.t162 AVSS 0.39809f
C3147 AVSS.t7 AVSS 0.39809f
C3148 AVSS.t8 AVSS 0.39809f
C3149 AVSS.t234 AVSS 0.39809f
C3150 AVSS.t35 AVSS 0.34652f
C3151 AVSS.t50 AVSS 0.34652f
C3152 AVSS.t49 AVSS 0.34652f
C3153 AVSS.t52 AVSS 0.34652f
C3154 AVSS.t51 AVSS 0.34652f
C3155 AVSS.t240 AVSS 0.34652f
C3156 AVSS.t239 AVSS 0.34652f
C3157 AVSS.t14 AVSS 7.23743f
C3158 AVSS.t0 AVSS 7.23871f
C3159 AVSS.t48 AVSS 0.34652f
C3160 AVSS.t141 AVSS 0.34652f
C3161 AVSS.t11 AVSS 7.63395f
C3162 AVSS.t47 AVSS 0.34652f
C3163 AVSS.t2 AVSS 0.34652f
C3164 AVSS.t1 AVSS 0.34652f
C3165 AVSS.t242 AVSS 0.34652f
C3166 AVSS.t241 AVSS 0.34652f
C3167 AVSS.t142 AVSS 0.34652f
C3168 AVSS.t17 AVSS 0.39809f
C3169 AVSS.t38 AVSS 0.39809f
C3170 AVSS.t39 AVSS 0.39809f
C3171 AVSS.t42 AVSS 0.39809f
C3172 AVSS.t43 AVSS 0.39809f
C3173 AVSS.t45 AVSS 0.39809f
C3174 AVSS.t46 AVSS 0.39809f
C3175 AVSS.t235 AVSS 0.34652f
C3176 AVSS.t126 AVSS 0.34652f
C3177 AVSS.t6 AVSS 7.63531f
C3178 AVSS.t236 AVSS 0.34652f
C3179 AVSS.t9 AVSS 0.34652f
C3180 AVSS.t10 AVSS 0.34652f
C3181 AVSS.t232 AVSS 0.34652f
C3182 AVSS.t233 AVSS 0.34652f
C3183 AVSS.t125 AVSS 0.34652f
C3184 AVSS.t44 AVSS 0.39809f
C3185 AVSS.t134 AVSS 0.39809f
C3186 AVSS.t133 AVSS 0.39809f
C3187 AVSS.t34 AVSS 0.39809f
C3188 AVSS.t33 AVSS 0.39809f
C3189 AVSS.t130 AVSS 0.39809f
C3190 AVSS.t129 AVSS 0.39809f
C3191 AVSS.t16 AVSS 7.24013f
C3192 AVSS.t37 AVSS 7.2413f
C3193 AVSS.t144 AVSS 0.39809f
C3194 AVSS.t20 AVSS 7.63395f
C3195 AVSS.t150 AVSS 0.34652f
C3196 AVSS.t143 AVSS 0.39809f
C3197 AVSS.t153 AVSS 0.39809f
C3198 AVSS.t152 AVSS 0.39809f
C3199 AVSS.t19 AVSS 0.39809f
C3200 AVSS.t18 AVSS 0.39809f
C3201 AVSS.t237 AVSS 0.39809f
C3202 AVSS.t151 AVSS 0.34652f
C3203 AVSS.t154 AVSS 0.34652f
C3204 AVSS.t155 AVSS 0.34652f
C3205 AVSS.t127 AVSS 0.34652f
C3206 AVSS.t128 AVSS 0.34652f
C3207 AVSS.t12 AVSS 0.34652f
C3208 AVSS.t13 AVSS 0.34652f
C3209 AVDD.n0 AVSS 3.95707f
C3210 AVDD.n2 AVSS 5.19689f
C3211 AVDD.n3 AVSS 0.11566f
C3212 AVDD.n4 AVSS 0.11144f
C3213 AVDD.n5 AVSS 0.11168f
C3214 AVDD.n6 AVSS 0.11622f
C3215 AVDD.n7 AVSS 0.1115f
C3216 AVDD.n8 AVSS 0.11577f
C3217 AVDD.n9 AVSS 0.11194f
C3218 AVDD.n10 AVSS 0.1117f
C3219 AVDD.n11 AVSS 0.11735f
C3220 AVDD.n12 AVSS 0.11162f
C3221 AVDD.n13 AVSS 0.11137f
C3222 AVDD.n14 AVSS 0.1164f
C3223 AVDD.n15 AVSS 0.11144f
C3224 AVDD.t3 AVSS 0.27161p
C3225 AVDD.n16 AVSS 1.10207f
C3226 AVDD.n17 AVSS 0.15684f
C3227 AVDD.n18 AVSS 3.95895f
C3228 AVDD.n19 AVSS 0.01008f
C3229 AVDD.n20 AVSS 0.01298f
C3230 AVDD.n21 AVSS 2.68719f
C3231 AVDD.n22 AVSS 30.7297f
C3232 AVDD.t76 AVSS 11.31733f
C3233 AVDD.n23 AVSS 47.4324f
C3234 AVDD.n24 AVSS 3.87475f
C3235 AVDD.n25 AVSS 0.01806f
C3236 AVDD.n26 AVSS 0.01301f
C3237 AVDD.n28 AVSS 6.46749f
C3238 AVDD.t25 AVSS 34.6818f
C3239 AVDD.n29 AVSS 63.0438f
C3240 AVDD.n30 AVSS 0.11409f
C3241 AVDD.n31 AVSS 0.36682f
C3242 AVDD.n32 AVSS 0.37649f
C3243 AVDD.n33 AVSS 2.62365f
C3244 AVDD.n34 AVSS 0.53768f
C3245 AVDD.n35 AVSS 0.36735f
C3246 AVDD.n36 AVSS 1.07816f
C3247 AVDD.n37 AVSS 0.41352f
C3248 AVDD.n39 AVSS 3.45105f
C3249 AVDD.n40 AVSS 0.13918f
C3250 AVDD.t0 AVSS 73.5114f
C3251 AVDD.n42 AVSS 0.19186f
C3252 AVDD.n43 AVSS 0.09857f
C3253 AVDD.n44 AVSS 0.08839f
C3254 AVDD.n45 AVSS 0.09935f
C3255 AVDD.n46 AVSS 0.09724f
C3256 AVDD.n47 AVSS 0.07394f
C3257 AVDD.n48 AVSS 2.84144f
C3258 AVDD.n49 AVSS 1.91387f
C3259 AVDD.n50 AVSS 2.83523f
C3260 AVDD.n51 AVSS 2.46061f
C3261 AVDD.n52 AVSS 0.11574f
C3262 AVDD.n53 AVSS 3.82372f
C3263 AVDD.n54 AVSS 0.08305f
C3264 AVDD.n55 AVSS 1.20546f
C3265 AVDD.n56 AVSS 0.08299f
C3266 AVDD.n57 AVSS 0.09521f
C3267 AVDD.n58 AVSS 1.74556f
C3268 AVDD.n59 AVSS 0.09571f
C3269 AVDD.n60 AVSS 1.74528f
C3270 AVDD.n61 AVSS 0.09524f
C3271 AVDD.n62 AVSS 1.72282f
C3272 AVDD.n63 AVSS 0.08869f
C3273 AVDD.n64 AVSS 1.31601f
C3274 AVDD.n65 AVSS 1.21277f
C3275 AVDD.n66 AVSS 0.09521f
C3276 AVDD.n67 AVSS 3.87193f
C3277 AVDD.n68 AVSS 0.0957f
C3278 AVDD.n69 AVSS 3.8732f
C3279 AVDD.n70 AVSS 0.09522f
C3280 AVDD.n71 AVSS 3.82227f
C3281 AVDD.n72 AVSS 0.0887f
C3282 AVDD.n73 AVSS 3.08286f
C3283 AVDD.n74 AVSS 2.70521f
C3284 AVDD.n75 AVSS 1.21184f
C3285 AVDD.n76 AVSS 1.31601f
C3286 AVDD.n77 AVSS 0.09488f
C3287 AVDD.n78 AVSS 1.72282f
C3288 AVDD.n79 AVSS 0.10736f
C3289 AVDD.n80 AVSS 1.74528f
C3290 AVDD.n81 AVSS 1.94683f
C3291 AVDD.n82 AVSS 1.90916f
C3292 AVDD.n83 AVSS 2.70427f
C3293 AVDD.n84 AVSS 3.08283f
C3294 AVDD.n85 AVSS 0.08849f
C3295 AVDD.n86 AVSS 0.11094f
C3296 AVDD.n87 AVSS 0.09567f
C3297 AVDD.n88 AVSS 0.11125f
C3298 AVDD.n89 AVSS 0.09614f
C3299 AVDD.n90 AVSS 3.87032f
C3300 AVDD.n91 AVSS 0.09568f
C3301 AVDD.n92 AVSS 0.11105f
C3302 AVDD.n93 AVSS 0.08383f
C3303 AVDD.t8 AVSS 0.77931f
C3304 AVDD.t37 AVSS 0.77554f
C3305 AVDD.n94 AVSS 0.27806f
C3306 AVDD.t7 AVSS 4.17636f
C3307 AVDD.n95 AVSS 2.62968f
C3308 AVDD.n96 AVSS 0.96091f
C3309 AVDD.n97 AVSS 0.17233f
C3310 AVDD.n98 AVSS 0.12109f
C3311 AVDD.t85 AVSS 0.07708f
C3312 AVDD.n99 AVSS 0.10064f
C3313 AVDD.t86 AVSS 1.58956f
C3314 AVDD.n100 AVSS 0.1038f
C3315 AVDD.t84 AVSS 0.07708f
C3316 AVDD.n101 AVSS 0.1038f
C3317 AVDD.t44 AVSS 0.07708f
C3318 AVDD.n102 AVSS 0.10058f
C3319 AVDD.t11 AVSS 0.07708f
C3320 AVDD.n103 AVSS 0.10409f
C3321 AVDD.n104 AVSS 0.04952f
C3322 AVDD.t16 AVSS 0.07708f
C3323 AVDD.n105 AVSS 0.1038f
C3324 AVDD.t111 AVSS 0.07708f
C3325 AVDD.n106 AVSS 0.1038f
C3326 AVDD.n107 AVSS 0.15587f
C3327 AVDD.n108 AVSS 3.45386f
C3328 AVDD.t32 AVSS 0.07708f
C3329 AVDD.n109 AVSS 0.1038f
C3330 AVDD.n110 AVSS 0.12109f
C3331 AVDD.t110 AVSS 1.58956f
C3332 AVDD.n111 AVSS 0.10064f
C3333 AVDD.t92 AVSS 0.07708f
C3334 AVDD.n112 AVSS 0.10058f
C3335 AVDD.t150 AVSS 0.07708f
C3336 AVDD.n113 AVSS 0.10058f
C3337 AVDD.t31 AVSS 0.07708f
C3338 AVDD.n114 AVSS 0.10064f
C3339 AVDD.t42 AVSS 0.07708f
C3340 AVDD.n115 AVSS 0.10058f
C3341 AVDD.t68 AVSS 0.07708f
C3342 AVDD.n116 AVSS 0.10058f
C3343 AVDD.t34 AVSS 1.58956f
C3344 AVDD.n117 AVSS 0.10064f
C3345 AVDD.t89 AVSS 0.07708f
C3346 AVDD.n118 AVSS 0.10409f
C3347 AVDD.t33 AVSS 0.07708f
C3348 AVDD.n119 AVSS 0.1038f
C3349 AVDD.t13 AVSS 0.07708f
C3350 AVDD.n120 AVSS 0.10409f
C3351 AVDD.t65 AVSS 0.07708f
C3352 AVDD.n121 AVSS 0.10409f
C3353 AVDD.t148 AVSS 0.07708f
C3354 AVDD.n122 AVSS 0.12674f
C3355 AVDD.t66 AVSS 0.07708f
C3356 AVDD.n123 AVSS 0.10058f
C3357 AVDD.t14 AVSS 0.07708f
C3358 AVDD.n124 AVSS 0.10058f
C3359 AVDD.n125 AVSS 0.05116f
C3360 AVDD.n126 AVSS 0.1372f
C3361 AVDD.n127 AVSS 0.04388f
C3362 AVDD.t90 AVSS 1.58956f
C3363 AVDD.n128 AVSS 0.12674f
C3364 AVDD.n129 AVSS 0.10215f
C3365 AVDD.n130 AVSS 0.12104f
C3366 AVDD.n131 AVSS 0.04952f
C3367 AVDD.n132 AVSS 0.12126f
C3368 AVDD.n133 AVSS 0.10215f
C3369 AVDD.t147 AVSS 0.07708f
C3370 AVDD.n134 AVSS 0.10409f
C3371 AVDD.n135 AVSS 0.13693f
C3372 AVDD.n136 AVSS 0.15599f
C3373 AVDD.n137 AVSS 0.04952f
C3374 AVDD.n138 AVSS 0.15587f
C3375 AVDD.n139 AVSS 0.13693f
C3376 AVDD.t80 AVSS 0.07708f
C3377 AVDD.n140 AVSS 0.1038f
C3378 AVDD.n141 AVSS 0.10215f
C3379 AVDD.t79 AVSS 0.07708f
C3380 AVDD.n142 AVSS 0.10064f
C3381 AVDD.n143 AVSS 0.15825f
C3382 AVDD.n144 AVSS 0.22418f
C3383 AVDD.t2 AVSS 1.58956f
C3384 AVDD.n145 AVSS 0.10058f
C3385 AVDD.t1 AVSS 0.07708f
C3386 AVDD.n146 AVSS 0.10409f
C3387 AVDD.n147 AVSS 0.12109f
C3388 AVDD.n148 AVSS 0.10215f
C3389 AVDD.t67 AVSS 0.07708f
C3390 AVDD.n149 AVSS 0.10409f
C3391 AVDD.n150 AVSS 0.13693f
C3392 AVDD.t121 AVSS 0.07708f
C3393 AVDD.n151 AVSS 0.1038f
C3394 AVDD.n152 AVSS 0.10215f
C3395 AVDD.t120 AVSS 1.58956f
C3396 AVDD.n153 AVSS 0.10064f
C3397 AVDD.t108 AVSS 0.07708f
C3398 AVDD.n154 AVSS 0.10409f
C3399 AVDD.t41 AVSS 0.07708f
C3400 AVDD.n155 AVSS 0.10409f
C3401 AVDD.n156 AVSS 0.12121f
C3402 AVDD.n157 AVSS 0.93696f
C3403 AVDD.n158 AVSS 0.15587f
C3404 AVDD.t10 AVSS 1.58956f
C3405 AVDD.n159 AVSS 0.1038f
C3406 AVDD.t131 AVSS 1.58956f
C3407 AVDD.n160 AVSS 0.10064f
C3408 AVDD.t9 AVSS 0.07708f
C3409 AVDD.n161 AVSS 0.10064f
C3410 AVDD.t127 AVSS 0.07708f
C3411 AVDD.n162 AVSS 0.1038f
C3412 AVDD.t126 AVSS 1.58956f
C3413 AVDD.n163 AVSS 0.10064f
C3414 AVDD.n164 AVSS 0.13693f
C3415 AVDD.t63 AVSS 0.07708f
C3416 AVDD.n165 AVSS 0.1038f
C3417 AVDD.t119 AVSS 0.07708f
C3418 AVDD.n166 AVSS 0.10058f
C3419 AVDD.t78 AVSS 0.07708f
C3420 AVDD.n167 AVSS 0.10058f
C3421 AVDD.n168 AVSS 0.22458f
C3422 AVDD.n169 AVSS 1.09588f
C3423 AVDD.n170 AVSS 0.12109f
C3424 AVDD.t122 AVSS 1.58956f
C3425 AVDD.n171 AVSS 0.10409f
C3426 AVDD.t123 AVSS 0.07708f
C3427 AVDD.n172 AVSS 0.10058f
C3428 AVDD.t134 AVSS 0.07708f
C3429 AVDD.n173 AVSS 0.1038f
C3430 AVDD.t28 AVSS 1.58956f
C3431 AVDD.n174 AVSS 0.1038f
C3432 AVDD.t77 AVSS 1.58956f
C3433 AVDD.n175 AVSS 0.10409f
C3434 AVDD.t75 AVSS 0.07708f
C3435 AVDD.n176 AVSS 0.1038f
C3436 AVDD.n177 AVSS 0.10215f
C3437 AVDD.t118 AVSS 0.07708f
C3438 AVDD.n178 AVSS 0.10409f
C3439 AVDD.t81 AVSS 0.07708f
C3440 AVDD.n179 AVSS 0.1268f
C3441 AVDD.t74 AVSS 1.58956f
C3442 AVDD.n180 AVSS 0.10064f
C3443 AVDD.n181 AVSS 0.12121f
C3444 AVDD.n182 AVSS 0.04463f
C3445 AVDD.n183 AVSS 0.10215f
C3446 AVDD.t133 AVSS 1.58956f
C3447 AVDD.n184 AVSS 0.1268f
C3448 AVDD.t27 AVSS 0.07708f
C3449 AVDD.n185 AVSS 0.10064f
C3450 AVDD.n186 AVSS 0.04319f
C3451 AVDD.n187 AVSS 0.14155f
C3452 AVDD.n188 AVSS 0.88175f
C3453 AVDD.n189 AVSS 1.06778f
C3454 AVDD.n190 AVSS 0.04952f
C3455 AVDD.n191 AVSS 0.12109f
C3456 AVDD.n192 AVSS 0.10215f
C3457 AVDD.t82 AVSS 1.58956f
C3458 AVDD.n193 AVSS 0.1038f
C3459 AVDD.n194 AVSS 0.13693f
C3460 AVDD.n195 AVSS 0.15587f
C3461 AVDD.n196 AVSS 0.04952f
C3462 AVDD.n197 AVSS 0.15599f
C3463 AVDD.n198 AVSS 0.13693f
C3464 AVDD.t116 AVSS 1.58956f
C3465 AVDD.n199 AVSS 0.10409f
C3466 AVDD.n200 AVSS 0.15825f
C3467 AVDD.t117 AVSS 0.07708f
C3468 AVDD.n201 AVSS 0.10058f
C3469 AVDD.n202 AVSS 0.10215f
C3470 AVDD.n203 AVSS 0.12121f
C3471 AVDD.n204 AVSS 0.04952f
C3472 AVDD.n205 AVSS 0.94755f
C3473 AVDD.n206 AVSS 3.45308f
C3474 AVDD.n207 AVSS 0.17233f
C3475 AVDD.n208 AVSS 0.22418f
C3476 AVDD.n209 AVSS 0.15825f
C3477 AVDD.t64 AVSS 0.07708f
C3478 AVDD.n210 AVSS 0.10064f
C3479 AVDD.n211 AVSS 0.10215f
C3480 AVDD.n212 AVSS 0.12109f
C3481 AVDD.n213 AVSS 0.04952f
C3482 AVDD.n214 AVSS 0.12121f
C3483 AVDD.n215 AVSS 0.10215f
C3484 AVDD.t132 AVSS 0.07708f
C3485 AVDD.n216 AVSS 0.1038f
C3486 AVDD.n217 AVSS 0.10215f
C3487 AVDD.t91 AVSS 1.58956f
C3488 AVDD.n218 AVSS 0.10409f
C3489 AVDD.n219 AVSS 0.13693f
C3490 AVDD.t149 AVSS 0.07708f
C3491 AVDD.n220 AVSS 0.10409f
C3492 AVDD.n221 AVSS 0.15599f
C3493 AVDD.n222 AVSS 0.04952f
C3494 AVDD.n223 AVSS 1.09588f
C3495 AVDD.n224 AVSS 0.94294f
C3496 AVDD.n225 AVSS 0.04952f
C3497 AVDD.n226 AVSS 0.12109f
C3498 AVDD.n227 AVSS 0.10215f
C3499 AVDD.t109 AVSS 0.07708f
C3500 AVDD.n228 AVSS 0.10058f
C3501 AVDD.n229 AVSS 0.15825f
C3502 AVDD.n230 AVSS 0.22418f
C3503 AVDD.n231 AVSS 0.17233f
C3504 AVDD.n232 AVSS 0.22458f
C3505 AVDD.n233 AVSS 0.15825f
C3506 AVDD.t15 AVSS 0.07708f
C3507 AVDD.n234 AVSS 0.10064f
C3508 AVDD.n235 AVSS 0.10215f
C3509 AVDD.n236 AVSS 0.12121f
C3510 AVDD.n237 AVSS 0.04952f
C3511 AVDD.n238 AVSS 0.9411f
C3512 AVDD.n239 AVSS 1.09588f
C3513 AVDD.n240 AVSS 0.04952f
C3514 AVDD.n241 AVSS 0.15599f
C3515 AVDD.n242 AVSS 0.13693f
C3516 AVDD.t43 AVSS 0.07708f
C3517 AVDD.n243 AVSS 0.10409f
C3518 AVDD.n244 AVSS 0.10215f
C3519 AVDD.n245 AVSS 0.12121f
C3520 AVDD.t12 AVSS 0.07708f
C3521 AVDD.n246 AVSS 0.10058f
C3522 AVDD.n247 AVSS 0.22458f
C3523 AVDD.n248 AVSS 0.15825f
C3524 AVDD.t83 AVSS 1.58956f
C3525 AVDD.n249 AVSS 0.10064f
C3526 AVDD.n250 AVSS 0.10215f
C3527 AVDD.n251 AVSS 0.12121f
C3528 AVDD.n252 AVSS 0.04952f
C3529 AVDD.n253 AVSS 0.92268f
C3530 AVDD.n254 AVSS 3.454f
C3531 AVDD.n255 AVSS 0.9411f
C3532 AVDD.n256 AVSS 0.94294f
C3533 AVDD.n257 AVSS 0.18528f
C3534 AVDD.t71 AVSS 2.02878f
C3535 AVDD.t21 AVSS 1.80612f
C3536 AVDD.t103 AVSS 0.29377f
C3537 AVDD.t73 AVSS 0.45024f
C3538 AVDD.t22 AVSS 2.02918f
C3539 AVDD.n258 AVSS 0.23657f
C3540 AVDD.t145 AVSS 0.27471f
C3541 AVDD.t101 AVSS 0.29377f
C3542 AVDD.n259 AVSS 0.04952f
C3543 AVDD.n260 AVSS 0.23657f
C3544 AVDD.n261 AVSS 0.04952f
C3545 AVDD.t72 AVSS 0.27445f
C3546 AVDD.n262 AVSS 0.21751f
C3547 AVDD.t6 AVSS 0.45024f
C3548 AVDD.t5 AVSS 1.78733f
C3549 AVDD.n263 AVSS 0.17233f
C3550 AVDD.t95 AVSS 2.02918f
C3551 AVDD.n264 AVSS 0.04952f
C3552 AVDD.n265 AVSS 0.21751f
C3553 AVDD.t59 AVSS 0.27445f
C3554 AVDD.t94 AVSS 1.80612f
C3555 AVDD.t23 AVSS 3.54139f
C3556 AVDD.n266 AVSS 1.09588f
C3557 AVDD.n267 AVSS 0.96091f
C3558 AVDD.n268 AVSS 0.15699f
C3559 AVDD.t39 AVSS 0.29339f
C3560 AVDD.n269 AVSS 0.04952f
C3561 AVDD.n270 AVSS 0.23657f
C3562 AVDD.t54 AVSS 1.71644f
C3563 AVDD.t55 AVSS 0.24301f
C3564 AVDD.t36 AVSS 1.80644f
C3565 AVDD.n271 AVSS 0.21751f
C3566 AVDD.n272 AVSS 0.23646f
C3567 AVDD.n273 AVSS 0.04952f
C3568 AVDD.t50 AVSS 0.2936f
C3569 AVDD.t114 AVSS 0.24301f
C3570 AVDD.t57 AVSS 1.78706f
C3571 AVDD.t58 AVSS 1.96285f
C3572 AVDD.t130 AVSS 0.27471f
C3573 AVDD.n274 AVSS 0.21751f
C3574 AVDD.t24 AVSS 0.29366f
C3575 AVDD.t61 AVSS 1.78706f
C3576 AVDD.n275 AVSS 0.23646f
C3577 AVDD.t70 AVSS 0.29339f
C3578 AVDD.t62 AVSS 1.96285f
C3579 AVDD.t143 AVSS 0.27471f
C3580 AVDD.n276 AVSS 0.21751f
C3581 AVDD.t125 AVSS 0.29366f
C3582 AVDD.n277 AVSS 0.23646f
C3583 AVDD.n278 AVSS 0.04952f
C3584 AVDD.t112 AVSS 1.80612f
C3585 AVDD.n279 AVSS 0.04952f
C3586 AVDD.n280 AVSS 0.21751f
C3587 AVDD.t18 AVSS 0.27445f
C3588 AVDD.t17 AVSS 1.96285f
C3589 AVDD.t113 AVSS 0.51656f
C3590 AVDD.t47 AVSS 0.29339f
C3591 AVDD.t136 AVSS 0.29377f
C3592 AVDD.n281 AVSS 0.17233f
C3593 AVDD.t105 AVSS 0.27471f
C3594 AVDD.t97 AVSS 0.29366f
C3595 AVDD.t52 AVSS 1.96285f
C3596 AVDD.t48 AVSS 0.51616f
C3597 AVDD.n282 AVSS 0.23646f
C3598 AVDD.n283 AVSS 0.04952f
C3599 AVDD.t98 AVSS 0.27445f
C3600 AVDD.t53 AVSS 0.27471f
C3601 AVDD.n284 AVSS 0.21751f
C3602 AVDD.n285 AVSS 1.06778f
C3603 AVDD.t106 AVSS 0.29351f
C3604 AVDD.n286 AVSS 0.21751f
C3605 AVDD.n287 AVSS 0.23657f
C3606 AVDD.t107 AVSS 0.19719f
C3607 AVDD.n288 AVSS 0.04952f
C3608 AVDD.t29 AVSS 1.75538f
C3609 AVDD.t30 AVSS 0.20388f
C3610 AVDD.t20 AVSS 0.18991f
C3611 AVDD.t46 AVSS 0.24276f
C3612 AVDD.t19 AVSS 0.29339f
C3613 AVDD.n289 AVSS 0.1372f
C3614 AVDD.t45 AVSS 0.20388f
C3615 AVDD.n290 AVSS 0.88361f
C3616 AVDD.n291 AVSS 0.04952f
C3617 AVDD.n292 AVSS 1.09588f
C3618 AVDD.n293 AVSS 0.94755f
C3619 AVDD.n294 AVSS 0.04952f
C3620 AVDD.n295 AVSS 0.93696f
C3621 AVDD.n296 AVSS 1.09588f
C3622 AVDD.t115 AVSS 1.71644f
C3623 AVDD.t49 AVSS 1.7032f
C3624 AVDD.n297 AVSS 0.14155f
C3625 AVDD.t35 AVSS 0.18914f
C3626 AVDD.n298 AVSS 0.04952f
C3627 AVDD.n299 AVSS 0.92268f
C3628 AVDD.n300 AVSS 3.41325f
C3629 AVDD.n301 AVSS 0.17233f
C3630 AVDD.n302 AVSS 3.3763f
C3631 AVDD.n303 AVSS 0.05946f
C3632 AVDD.t4 AVSS 67.0658f
C3633 threshold.n0 AVSS 0.30513f
C3634 threshold.n1 AVSS 0.30513f
C3635 threshold.n2 AVSS 0.30513f
C3636 threshold.n3 AVSS 0.30513f
C3637 threshold.n4 AVSS 0.51177f
C3638 threshold.n5 AVSS 0.68099f
C3639 threshold.n6 AVSS 0.51109f
C3640 threshold.n7 AVSS 0.67979f
C3641 threshold.n8 AVSS 0.51016f
C3642 threshold.n9 AVSS 0.67886f
C3643 threshold.n10 AVSS 0.61723f
C3644 threshold.n11 AVSS 0.59167f
C3645 threshold.n12 AVSS 0.59327f
C3646 threshold.n13 AVSS 0.73696f
C3647 threshold.n14 AVSS 1.17294f
C3648 threshold.n15 AVSS 0.45466f
C3649 threshold.n16 AVSS 0.50095f
C3650 threshold.n17 AVSS 1.157f
C3651 threshold.n18 AVSS 1.16999f
C3652 threshold.n19 AVSS 1.15582f
C3653 threshold.n20 AVSS 1.73184f
C3654 threshold.n21 AVSS 20.8655f
C3655 ibias1.n0 AVSS 0.86517f
C3656 ibias1.n3 AVSS 0.86517f
C3657 ibias1.n4 AVSS 0.1137f
C3658 ibias1.n6 AVSS 0.86517f
C3659 ibias1.n7 AVSS 0.1137f
C3660 ibias1.n9 AVSS 0.86517f
C3661 ibias1.n10 AVSS 0.1137f
C3662 ibias1.n12 AVSS 0.65485f
C3663 ibias1.n13 AVSS 0.32385f
C3664 ibias1.n14 AVSS 0.32539f
C3665 ibias1.n16 AVSS 0.54741f
C3666 ibias1.n18 AVSS 0.54741f
C3667 ibias1.n20 AVSS 0.32385f
C3668 ibias1.n21 AVSS 0.3011f
C3669 ibias1.n23 AVSS 0.32539f
C3670 ibias1.n24 AVSS 0.54741f
C3671 ibias1.n25 AVSS 0.32385f
C3672 ibias1.n26 AVSS 2.42172f
C3673 ibias1.n28 AVSS 0.55219f
C3674 ibias1.n29 AVSS 0.32539f
C3675 ibias1.n30 AVSS 0.38096f
C3676 ibias1.n31 AVSS 0.54741f
C3677 ibias1.n32 AVSS 0.32385f
C3678 ibias1.n34 AVSS 0.3011f
C3679 ibias1.n35 AVSS 0.32539f
C3680 ibias1.n37 AVSS 0.7368f
C3681 ibias1.n38 AVSS 0.18182f
C3682 ibias1.n40 AVSS 0.1513f
C3683 ibias1.n41 AVSS 0.73273f
C3684 ibias1.n43 AVSS 0.70582f
C3685 ibias1.n44 AVSS 0.60228f
C3686 ibias1.n50 AVSS 0.43186f
C3687 ibias1.n51 AVSS 0.71202f
C3688 ibias1.n52 AVSS 0.21219f
C3689 ibias1.n53 AVSS 0.42122f
C3690 ibias1.n54 AVSS 0.30095f
C3691 ibias1.n55 AVSS 0.48649f
C3692 ibias1.n56 AVSS 0.88261f
C3693 ibias1.n57 AVSS 1.41421f
C3694 ibias1.n58 AVSS 1.41421f
C3695 ibias1.n59 AVSS 0.55219f
C3696 ibias1.n62 AVSS 0.55219f
C3697 ibias1.n65 AVSS 0.55219f
C3698 ibias1.n68 AVSS 0.91453f
C3699 ibias1.n69 AVSS 0.51939f
C3700 ibias1.n70 AVSS 0.50423f
C3701 ibias1.n71 AVSS 0.44859f
C3702 ibias1.n72 AVSS 0.50685f
C3703 ibias1.n73 AVSS 0.50423f
C3704 ibias1.n74 AVSS 0.34135f
C3705 ibias1.n75 AVSS 0.50685f
C3706 ibias1.n76 AVSS 0.50423f
C3707 ibias1.n77 AVSS 0.51676f
C3708 ibias1.n78 AVSS 0.50423f
C3709 ibias1.n79 AVSS 0.51676f
C3710 ibias1.n80 AVSS 0.30903f
C3711 ibias1.n81 AVSS 0.51676f
C3712 ibias1.n82 AVSS 0.51939f
C3713 ibias1.n83 AVSS 0.30903f
C3714 ibias1.n84 AVSS 0.51676f
C3715 ibias1.n85 AVSS 0.51939f
C3716 ibias1.n86 AVSS 0.30903f
C3717 ibias1.n87 AVSS 0.51939f
C3718 ibias1.n88 AVSS 0.5286f
C3719 ibias1.n89 AVSS 0.35546f
C3720 ibias1.n90 AVSS 0.2994f
C3721 ibias1.n91 AVSS 0.58303f
C3722 ibias1.n92 AVSS 0.34704f
C3723 ibias1.t47 AVSS 0.6611f
C3724 ibias1.t11 AVSS 0.6611f
C3725 ibias1.t37 AVSS 0.08761f
C3726 ibias1.t35 AVSS 0.09059f
C3727 ibias1.t59 AVSS 0.08833f
C3728 ibias1.t15 AVSS 0.08833f
C3729 ibias1.t31 AVSS 0.08761f
C3730 ibias1.t39 AVSS 0.08833f
C3731 ibias1.t45 AVSS 0.09059f
C3732 ibias1.t9 AVSS 0.08833f
C3733 ibias1.t51 AVSS 0.08833f
C3734 ibias1.t7 AVSS 0.08833f
C3735 ibias1.t27 AVSS 0.08761f
C3736 ibias1.t53 AVSS 0.08833f
C3737 ibias1.t29 AVSS 0.09059f
C3738 ibias1.t19 AVSS 0.08761f
C3739 ibias1.t57 AVSS 0.08833f
C3740 ibias1.t43 AVSS 0.08746f
C3741 ibias1.n93 AVSS 0.62849f
C3742 ibias1.t33 AVSS 0.08833f
C3743 ibias1.t3 AVSS 0.08833f
C3744 ibias1.n94 AVSS 0.1513f
C3745 ibias1.n95 AVSS 0.49636f
C3746 ibias1.n96 AVSS 0.30903f
C3747 ibias1.n97 AVSS 0.3011f
C3748 ibias1.t63 AVSS 0.09059f
C3749 ibias1.t5 AVSS 0.08761f
C3750 ibias1.t1 AVSS 0.08833f
C3751 ibias1.t61 AVSS 0.08761f
C3752 ibias1.t41 AVSS 0.08746f
C3753 ibias1.n98 AVSS 0.3011f
C3754 ibias1.t17 AVSS 0.08761f
C3755 ibias1.t13 AVSS 0.08833f
C3756 ibias1.t49 AVSS 0.08746f
C3757 ibias1.n99 AVSS 0.61168f
C3758 ibias1.n100 AVSS 0.31794f
C3759 ibias1.t21 AVSS 0.08833f
C3760 ibias1.t55 AVSS 0.08833f
C3761 ibias1.t25 AVSS 0.08761f
C3762 ibias1.t23 AVSS 0.08746f
C3763 ibias1.n101 AVSS 0.38995f
C3764 ibias1.n102 AVSS 0.53661f
C3765 ibias1.n103 AVSS 10.5641f
C3766 vctrl.n0 AVSS 0.35761f
C3767 vctrl.n1 AVSS 0.33267f
C3768 vctrl.n2 AVSS 0.9265f
C3769 vctrl.n3 AVSS 2.35486f
C3770 vctrl.n4 AVSS 1.20299f
C3771 vctrl.n5 AVSS 1.20299f
C3772 vctrl.n6 AVSS 0.46908f
C3773 vctrl.n7 AVSS 0.5325f
C3774 vctrl.n8 AVSS 0.46908f
C3775 vctrl.n9 AVSS 0.5325f
C3776 vctrl.n10 AVSS 0.36099f
C3777 vctrl.n11 AVSS 0.56335f
C3778 vctrl.n12 AVSS 1.59491f
C3779 vctrl.n13 AVSS 0.36283f
C3780 vctrl.n14 AVSS 0.3632f
C3781 vctrl.n15 AVSS 0.56314f
C3782 vctrl.n16 AVSS 0.65433f
C3783 vctrl.n17 AVSS 0.61858f
C3784 vctrl.n18 AVSS 0.61847f
C3785 vctrl.n19 AVSS 0.72277f
C3786 vctrl.n20 AVSS 0.41004f
C3787 vctrl.n21 AVSS 1.33591f
C3788 vctrl.n22 AVSS 1.28269f
C3789 vctrl.n23 AVSS 0.41004f
C3790 vctrl.n24 AVSS 1.33591f
C3791 vctrl.n25 AVSS 1.28269f
C3792 vctrl.n26 AVSS 0.31089f
C3793 vctrl.n27 AVSS 0.31089f
C3794 vctrl.n28 AVSS 8.33082f
C3795 vctrl.n29 AVSS 0.15412f
C3796 vctrl.n30 AVSS 0.18823f
C3797 vctrl.n31 AVSS 0.15412f
C3798 vctrl.n32 AVSS 0.27931f
C3799 vctrl.n33 AVSS 0.15412f
C3800 vctrl.n34 AVSS 0.18594f
C3801 vctrl.n35 AVSS 0.15412f
C3802 vctrl.n36 AVSS 0.18495f
C3803 vctrl.n37 AVSS 0.61823f
C3804 vctrl.n38 AVSS 0.68116f
C3805 vctrl.n39 AVSS 0.26078f
C3806 vctrl.n40 AVSS 0.33267f
C3807 vctrl.n41 AVSS 0.36228f
C3808 vctrl.n42 AVSS 0.26078f
C3809 vctrl.n43 AVSS 1.57163f
C3810 vctrl.n44 AVSS 1.59089f
C3811 vctrl.n45 AVSS 1.57323f
C3812 vctrl.n46 AVSS 0.26078f
C3813 vctrl.n47 AVSS 0.33267f
C3814 vctrl.n48 AVSS 0.26078f
C3815 vctrl.n49 AVSS 3.15382f
C3816 vctrl.t22 AVSS 0.12326f
C3817 vctrl.t28 AVSS 0.04965f
C3818 vctrl.t23 AVSS 0.05258f
C3819 vctrl.t9 AVSS 0.05283f
C3820 vctrl.n50 AVSS 0.68512f
C3821 vctrl.n51 AVSS 1.08429f
C3822 vctrl.t21 AVSS 0.02931f
C3823 vctrl.n52 AVSS 0.40157f
C3824 vctrl.t4 AVSS 0.04085f
C3825 vctrl.t7 AVSS 0.1624f
C3826 vctrl.n53 AVSS 0.48706f
C3827 vctrl.t13 AVSS 0.04542f
C3828 vctrl.t31 AVSS 0.03642f
C3829 vctrl.t11 AVSS 0.02702f
C3830 vctrl.n54 AVSS 0.37191f
C3831 vctrl.n55 AVSS 0.58815f
C3832 vctrl.t5 AVSS 0.02926f
C3833 vctrl.n56 AVSS 0.30309f
C3834 vctrl.t17 AVSS 0.03305f
C3835 vctrl.t19 AVSS 0.19117f
C3836 vctrl.t14 AVSS 0.18402f
C3837 vctrl.t10 AVSS 0.03373f
C3838 vctrl.n57 AVSS 0.38676f
C3839 vctrl.n58 AVSS 0.32871f
C3840 vctrl.n59 AVSS 0.69513f
C3841 vctrl.t16 AVSS 0.07812f
C3842 vctrl.t25 AVSS 0.04965f
C3843 vctrl.t8 AVSS 0.12326f
C3844 vctrl.t24 AVSS 0.05258f
C3845 vctrl.t18 AVSS 0.05283f
C3846 vctrl.n60 AVSS 0.68512f
C3847 vctrl.n61 AVSS 1.08429f
C3848 vctrl.t0 AVSS 0.04085f
C3849 vctrl.t6 AVSS 0.1624f
C3850 vctrl.n62 AVSS 0.48706f
C3851 vctrl.n63 AVSS 0.32871f
C3852 vctrl.t1 AVSS 0.02931f
C3853 vctrl.t30 AVSS 0.02702f
C3854 vctrl.n64 AVSS 0.37191f
C3855 vctrl.t12 AVSS 0.04542f
C3856 vctrl.t15 AVSS 0.03642f
C3857 vctrl.n65 AVSS 0.58815f
C3858 vctrl.t2 AVSS 0.02926f
C3859 vctrl.n66 AVSS 0.30309f
C3860 vctrl.t26 AVSS 0.03305f
C3861 vctrl.t27 AVSS 0.19117f
C3862 vctrl.t20 AVSS 0.18402f
C3863 vctrl.t3 AVSS 0.03373f
C3864 vctrl.n67 AVSS 0.38676f
C3865 vctrl.n68 AVSS 0.40157f
C3866 vctrl.n69 AVSS 0.69513f
C3867 vctrl.t29 AVSS 0.07812f
C3868 vctrl.n70 AVSS 31.8454f
C3869 trigger.n0 AVSS 0.49783f
C3870 trigger.n1 AVSS 0.28751f
C3871 trigger.n2 AVSS 0.55508f
C3872 trigger.n3 AVSS 0.28751f
C3873 trigger.n4 AVSS 0.28751f
C3874 trigger.n5 AVSS 0.28751f
C3875 trigger.n6 AVSS 0.28751f
C3876 trigger.n7 AVSS 0.28751f
C3877 trigger.n8 AVSS 0.28751f
C3878 trigger.n9 AVSS 0.28751f
C3879 trigger.n10 AVSS 0.52884f
C3880 trigger.n11 AVSS 2.13233f
C3881 trigger.n12 AVSS 0.54564f
C3882 trigger.n13 AVSS 0.52821f
C3883 trigger.n14 AVSS 0.54478f
C3884 trigger.n15 AVSS 0.57158f
C3885 trigger.n16 AVSS 0.28135f
C3886 trigger.n17 AVSS 2.87765f
C3887 trigger.n18 AVSS 18.7741f
C3888 ibias0.n0 AVSS 0.84346f
C3889 ibias0.n1 AVSS 0.11085f
C3890 ibias0.n3 AVSS 0.84346f
C3891 ibias0.n6 AVSS 0.84346f
C3892 ibias0.n7 AVSS 0.11085f
C3893 ibias0.n9 AVSS 0.84346f
C3894 ibias0.n12 AVSS 0.5337f
C3895 ibias0.n13 AVSS 0.53836f
C3896 ibias0.n14 AVSS 0.31724f
C3897 ibias0.n15 AVSS 0.71434f
C3898 ibias0.n16 AVSS 0.31573f
C3899 ibias0.n19 AVSS 0.5337f
C3900 ibias0.n20 AVSS 0.31724f
C3901 ibias0.n22 AVSS 0.30128f
C3902 ibias0.n23 AVSS 0.31573f
C3903 ibias0.n26 AVSS 0.5337f
C3904 ibias0.n27 AVSS 0.53836f
C3905 ibias0.n28 AVSS 0.31724f
C3906 ibias0.n30 AVSS 0.31573f
C3907 ibias0.n33 AVSS 0.5337f
C3908 ibias0.n34 AVSS 0.31724f
C3909 ibias0.n36 AVSS 0.30128f
C3910 ibias0.n37 AVSS 0.31573f
C3911 ibias0.n38 AVSS 0.7183f
C3912 ibias0.n40 AVSS 0.17669f
C3913 ibias0.n41 AVSS 0.63842f
C3914 ibias0.n44 AVSS 0.68745f
C3915 ibias0.n45 AVSS 0.47431f
C3916 ibias0.n46 AVSS 0.37208f
C3917 ibias0.n47 AVSS 0.58666f
C3918 ibias0.n49 AVSS 2.27046f
C3919 ibias0.n50 AVSS 2.36061f
C3920 ibias0.n54 AVSS 0.69417f
C3921 ibias0.n55 AVSS 0.20618f
C3922 ibias0.n56 AVSS 0.41135f
C3923 ibias0.n57 AVSS 0.29341f
C3924 ibias0.n58 AVSS 0.14751f
C3925 ibias0.n59 AVSS 1.37863f
C3926 ibias0.n61 AVSS 0.53836f
C3927 ibias0.n62 AVSS 0.11098f
C3928 ibias0.n64 AVSS 0.53836f
C3929 ibias0.n66 AVSS 0.29355f
C3930 ibias0.n67 AVSS 0.29355f
C3931 ibias0.n69 AVSS 0.61273f
C3932 ibias0.n70 AVSS 0.49416f
C3933 ibias0.n71 AVSS 0.86068f
C3934 ibias0.n72 AVSS 0.42103f
C3935 ibias0.n73 AVSS 0.49156f
C3936 ibias0.n74 AVSS 0.49416f
C3937 ibias0.n75 AVSS 0.49156f
C3938 ibias0.n76 AVSS 0.49156f
C3939 ibias0.n77 AVSS 0.43736f
C3940 ibias0.n78 AVSS 0.50638f
C3941 ibias0.n79 AVSS 0.49156f
C3942 ibias0.n80 AVSS 0.30128f
C3943 ibias0.n81 AVSS 0.50379f
C3944 ibias0.n82 AVSS 0.50638f
C3945 ibias0.n83 AVSS 0.50379f
C3946 ibias0.n84 AVSS 0.50638f
C3947 ibias0.n85 AVSS 0.50379f
C3948 ibias0.n86 AVSS 0.50638f
C3949 ibias0.n87 AVSS 0.50379f
C3950 ibias0.n88 AVSS 0.51535f
C3951 ibias0.n89 AVSS 0.34694f
C3952 ibias0.n90 AVSS 0.33875f
C3953 ibias0.n91 AVSS 0.52316f
C3954 ibias0.n92 AVSS 0.33319f
C3955 ibias0.t35 AVSS 0.0861f
C3956 ibias0.t27 AVSS 0.08528f
C3957 ibias0.t31 AVSS 0.08543f
C3958 ibias0.t41 AVSS 0.0861f
C3959 ibias0.t47 AVSS 0.08528f
C3960 ibias0.t57 AVSS 0.0861f
C3961 ibias0.t7 AVSS 0.08543f
C3962 ibias0.t45 AVSS 0.0861f
C3963 ibias0.t59 AVSS 0.08543f
C3964 ibias0.t25 AVSS 0.0861f
C3965 ibias0.t21 AVSS 0.08834f
C3966 ibias0.t9 AVSS 0.64383f
C3967 ibias0.t49 AVSS 0.6445f
C3968 ibias0.t61 AVSS 0.0861f
C3969 ibias0.t39 AVSS 0.08528f
C3970 ibias0.n93 AVSS 0.14751f
C3971 ibias0.n94 AVSS 0.48392f
C3972 ibias0.t1 AVSS 0.6445f
C3973 ibias0.n95 AVSS 0.29355f
C3974 ibias0.t29 AVSS 0.64737f
C3975 ibias0.t63 AVSS 0.08543f
C3976 ibias0.t17 AVSS 0.0861f
C3977 ibias0.t13 AVSS 0.08543f
C3978 ibias0.t53 AVSS 0.0861f
C3979 ibias0.t5 AVSS 0.0861f
C3980 ibias0.t11 AVSS 0.08834f
C3981 ibias0.t33 AVSS 0.0861f
C3982 ibias0.n96 AVSS 0.30128f
C3983 ibias0.t37 AVSS 0.08528f
C3984 ibias0.n97 AVSS 0.29189f
C3985 ibias0.n98 AVSS 0.56841f
C3986 ibias0.n99 AVSS 0.59631f
C3987 ibias0.t23 AVSS 0.6445f
C3988 ibias0.n100 AVSS 0.29355f
C3989 ibias0.t3 AVSS 0.08834f
C3990 ibias0.t15 AVSS 0.08543f
C3991 ibias0.t43 AVSS 0.0861f
C3992 ibias0.t51 AVSS 0.6445f
C3993 ibias0.t55 AVSS 0.08543f
C3994 ibias0.t19 AVSS 0.0861f
C3995 ibias0.n101 AVSS 0.38018f
C3996 ibias0.n102 AVSS 0.30997f
C3997 ibias0.n103 AVSS 10.3741f
.ends
