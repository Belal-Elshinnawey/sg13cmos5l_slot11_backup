** sch_path: /foss/designs/sg13cmos5l_slot3_backup/macros/timer_555_body/schematic/xschem/timer_555_body.sch
.subckt timer_555_body set_b reset_b vctrl threshold ibias0 trigger AVDD AVDD1V2 AVSS ibias1
*.PININFO ibias1:B ibias0:B vctrl:B AVDD:B AVDD1V2:B AVSS:B threshold:B trigger:B set_b:B reset_b:B
x1 p1_net threshold ibias1 set_b AVDD AVSS AVDD1V2 comparator_slice
x2 trigger vctrl ibias0 reset_b AVDD AVSS AVDD1V2 comparator_slice
x4 AVDD AVSS AVDD p1_net vctrl AVSS resistor_network
.ends

* expanding   symbol:  comparator_slice.sym # of pins=7
** sym_path: /foss/designs/sg13cmos5l_slot3_backup/macros/comparator/schematic/xschem/comparator_slice.sym
** sch_path: /foss/designs/sg13cmos5l_slot3_backup/macros/comparator/schematic/xschem/comparator_slice.sch
.subckt comparator_slice inp inn ibias out AVDD AVSS AVDD1V2
*.PININFO inp:B inn:B ibias:B AVDD:B AVSS:B out:B AVDD1V2:B
xM3[15] n1 n1 AVDD AVDD p1_4
xM3[14] n1 n1 AVDD AVDD p1_4
xM3[13] n1 n1 AVDD AVDD p1_4
xM3[12] n1 n1 AVDD AVDD p1_4
xM3[11] n1 n1 AVDD AVDD p1_4
xM3[10] n1 n1 AVDD AVDD p1_4
xM3[9] n1 n1 AVDD AVDD p1_4
xM3[8] n1 n1 AVDD AVDD p1_4
xM3[7] n1 n1 AVDD AVDD p1_4
xM3[6] n1 n1 AVDD AVDD p1_4
xM3[5] n1 n1 AVDD AVDD p1_4
xM3[4] n1 n1 AVDD AVDD p1_4
xM3[3] n1 n1 AVDD AVDD p1_4
xM3[2] n1 n1 AVDD AVDD p1_4
xM3[1] n1 n1 AVDD AVDD p1_4
xM3[0] n1 n1 AVDD AVDD p1_4
xM4[15] outx n1 AVDD AVDD p1_4
xM4[14] outx n1 AVDD AVDD p1_4
xM4[13] outx n1 AVDD AVDD p1_4
xM4[12] outx n1 AVDD AVDD p1_4
xM4[11] outx n1 AVDD AVDD p1_4
xM4[10] outx n1 AVDD AVDD p1_4
xM4[9] outx n1 AVDD AVDD p1_4
xM4[8] outx n1 AVDD AVDD p1_4
xM4[7] outx n1 AVDD AVDD p1_4
xM4[6] outx n1 AVDD AVDD p1_4
xM4[5] outx n1 AVDD AVDD p1_4
xM4[4] outx n1 AVDD AVDD p1_4
xM4[3] outx n1 AVDD AVDD p1_4
xM4[2] outx n1 AVDD AVDD p1_4
xM4[1] outx n1 AVDD AVDD p1_4
xM4[0] outx n1 AVDD AVDD p1_4
xM1[15] n1 inp tail AVSS n1_4
xM1[14] n1 inp tail AVSS n1_4
xM1[13] n1 inp tail AVSS n1_4
xM1[12] n1 inp tail AVSS n1_4
xM1[11] n1 inp tail AVSS n1_4
xM1[10] n1 inp tail AVSS n1_4
xM1[9] n1 inp tail AVSS n1_4
xM1[8] n1 inp tail AVSS n1_4
xM1[7] n1 inp tail AVSS n1_4
xM1[6] n1 inp tail AVSS n1_4
xM1[5] n1 inp tail AVSS n1_4
xM1[4] n1 inp tail AVSS n1_4
xM1[3] n1 inp tail AVSS n1_4
xM1[2] n1 inp tail AVSS n1_4
xM1[1] n1 inp tail AVSS n1_4
xM1[0] n1 inp tail AVSS n1_4
xM2[15] outx inn tail AVSS n1_4
xM2[14] outx inn tail AVSS n1_4
xM2[13] outx inn tail AVSS n1_4
xM2[12] outx inn tail AVSS n1_4
xM2[11] outx inn tail AVSS n1_4
xM2[10] outx inn tail AVSS n1_4
xM2[9] outx inn tail AVSS n1_4
xM2[8] outx inn tail AVSS n1_4
xM2[7] outx inn tail AVSS n1_4
xM2[6] outx inn tail AVSS n1_4
xM2[5] outx inn tail AVSS n1_4
xM2[4] outx inn tail AVSS n1_4
xM2[3] outx inn tail AVSS n1_4
xM2[2] outx inn tail AVSS n1_4
xM2[1] outx inn tail AVSS n1_4
xM2[0] outx inn tail AVSS n1_4
xM5[15] tail ibias AVSS AVSS n1_4
xM5[14] tail ibias AVSS AVSS n1_4
xM5[13] tail ibias AVSS AVSS n1_4
xM5[12] tail ibias AVSS AVSS n1_4
xM5[11] tail ibias AVSS AVSS n1_4
xM5[10] tail ibias AVSS AVSS n1_4
xM5[9] tail ibias AVSS AVSS n1_4
xM5[8] tail ibias AVSS AVSS n1_4
xM5[7] tail ibias AVSS AVSS n1_4
xM5[6] tail ibias AVSS AVSS n1_4
xM5[5] tail ibias AVSS AVSS n1_4
xM5[4] tail ibias AVSS AVSS n1_4
xM5[3] tail ibias AVSS AVSS n1_4
xM5[2] tail ibias AVSS AVSS n1_4
xM5[1] tail ibias AVSS AVSS n1_4
xM5[0] tail ibias AVSS AVSS n1_4
xMref[15] ibias ibias AVSS AVSS n1_4
xMref[14] ibias ibias AVSS AVSS n1_4
xMref[13] ibias ibias AVSS AVSS n1_4
xMref[12] ibias ibias AVSS AVSS n1_4
xMref[11] ibias ibias AVSS AVSS n1_4
xMref[10] ibias ibias AVSS AVSS n1_4
xMref[9] ibias ibias AVSS AVSS n1_4
xMref[8] ibias ibias AVSS AVSS n1_4
xMref[7] ibias ibias AVSS AVSS n1_4
xMref[6] ibias ibias AVSS AVSS n1_4
xMref[5] ibias ibias AVSS AVSS n1_4
xMref[4] ibias ibias AVSS AVSS n1_4
xMref[3] ibias ibias AVSS AVSS n1_4
xMref[2] ibias ibias AVSS AVSS n1_4
xMref[1] ibias ibias AVSS AVSS n1_4
xMref[0] ibias ibias AVSS AVSS n1_4
xMinvp outhv outx AVDD AVDD p1_4
xMinvn outhv outx AVSS AVSS n1_4
xMinvp2 out outhv AVDD1V2 AVDD1V2 p1_4
xMinvn2 out outhv AVSS AVSS n1_4
.ends

* expanding   symbol:  resistor_network.sym # of pins=6
** sym_path: /foss/designs/sg13cmos5l_slot3_backup/macros/resistor_network/schematic/xschem/resistor_network.sym
** sch_path: /foss/designs/sg13cmos5l_slot3_backup/macros/resistor_network/schematic/xschem/resistor_network.sch
.subckt resistor_network pt VSS VDD p1 p2 pb
*.PININFO pt:B VDD:B VSS:B p1:B p2:B pb:B
xA pt VSS VDD a_p1 p1 n_ab resistor_leg
xB n_ab VSS VDD p2 b_p2 pb resistor_leg
xC pt VSS VDD c_p1 p1 n_cd resistor_leg
xD n_cd VSS VDD p2 d_p2 pb resistor_leg
.ends

* expanding   symbol:  p1_4.sym # of pins=4
** sym_path: /foss/designs/sg13cmos5l_slot3_backup/macros/comparator/schematic/xschem/p1_4.sym
** sch_path: /foss/designs/sg13cmos5l_slot3_backup/macros/comparator/schematic/xschem/p1_4.sch
.subckt p1_4 D G S B
*.PININFO D:B G:B S:B B:B
xp1 D G S B p1_2
xp2 D G S B p1_2
.ends

* expanding   symbol:  n1_4.sym # of pins=4
** sym_path: /foss/designs/sg13cmos5l_slot3_backup/macros/comparator/schematic/xschem/n1_4.sym
** sch_path: /foss/designs/sg13cmos5l_slot3_backup/macros/comparator/schematic/xschem/n1_4.sch
.subckt n1_4 D G S B
*.PININFO D:B G:B S:B B:B
xp1 D G S B n1_2
xp2 D G S B n1_2
.ends

* expanding   symbol:  resistor_leg.sym # of pins=6
** sym_path: /foss/designs/sg13cmos5l_slot3_backup/macros/resistor_network/schematic/xschem/resistor_leg.sym
** sch_path: /foss/designs/sg13cmos5l_slot3_backup/macros/resistor_network/schematic/xschem/resistor_leg.sch
.subckt resistor_leg pt VSS VDD p1 p2 pb
*.PININFO pt:B pb:B p2:B p1:B VDD:B VSS:B
XR1 pt p1 VDD rhigh w=0.5e-6 l=13.42e-6 m=8 b=0 mm_ok=1
XR2 p1 p2 VDD rhigh w=0.5e-6 l=13.42e-6 m=8 b=0 mm_ok=1
XR3 p2 pb VDD rhigh w=0.5e-6 l=13.42e-6 m=8 b=0 mm_ok=1
XRdummy VSS VSS VDD rhigh w=0.5e-6 l=13.42e-6 m=24 b=0 mm_ok=1
.ends

* expanding   symbol:  p1_2.sym # of pins=4
** sym_path: /foss/designs/sg13cmos5l_slot3_backup/macros/comparator/schematic/xschem/p1_2.sym
** sch_path: /foss/designs/sg13cmos5l_slot3_backup/macros/comparator/schematic/xschem/p1_2.sch
.subckt p1_2 D G S B
*.PININFO G:B D:B S:B B:B
XMbot D G X B sg13_hv_pmos w=2.5e-6 l=1e-6 ng=1 m=1 mm_ok=1
XMtop X G S B sg13_hv_pmos w=2.5e-6 l=1e-6 ng=1 m=1 mm_ok=1
.ends

* expanding   symbol:  n1_2.sym # of pins=4
** sym_path: /foss/designs/sg13cmos5l_slot3_backup/macros/comparator/schematic/xschem/n1_2.sym
** sch_path: /foss/designs/sg13cmos5l_slot3_backup/macros/comparator/schematic/xschem/n1_2.sch
.subckt n1_2 D G S B
*.PININFO G:B D:B S:B B:B
XMbot D G X B sg13_hv_nmos w=2.5e-6 l=1e-6 ng=1 m=1 mm_ok=1
XMtop X G S B sg13_hv_nmos w=2.5e-6 l=1e-6 ng=1 m=1 mm_ok=1
.ends
